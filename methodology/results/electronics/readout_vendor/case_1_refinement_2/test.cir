AD8410A isolated macromodel check; not a complete coil channel
.include ad8410a.cir
Vs supply 0 5
Vref reference 0 2.5
Vcommon common 0 PULSE(0 25.200000000000003 1.5625000000000001e-06 9.9999999999999995e-08 9.9999999999999995e-08 3.0250000000000003e-06 6.2500000000000003e-06)
Vdiff differential 0 0
Eplus plus common differential 0 0.5
Eminus minus common differential 0 -0.5
Xamp minus 0 reference output supply reference plus AD8410A
.options reltol=1e-08 abstol=1e-10
.control
set wr_singlescale
set wr_vecnames
set numdgt=17
dc Vdiff -0.065000000000000002 0.065000000000000002 0.0012999999999999999
wrdata dc.dat v(output)
tran 6.1035156250000003e-09 5.0000000000000002e-05 0 6.1035156250000003e-09
let reported_current = (v(output)-2.5)/0.20000000000000001
wrdata transient.dat v(common) reported_current
quit
.endc
.end
