Independent periodic RL reference; ideal differential drive, not a transistor model
Vdrive drive 0 PULSE(0 25.200000000000003 0 3.1250000000000001e-10 3.1250000000000001e-10 1.5621874999999998e-06 3.1250000000000001e-06)
Rcoil drive winding 0.47570299886022366
Lcoil winding 0 2.578766605211726e-05 IC=26.105418163927872
.options reltol=1e-08 abstol=1e-10
.control
set wr_singlescale
set wr_vecnames
set numdgt=17
tran 6.1035156250000003e-09 2.5000000000000001e-05 0 6.1035156250000003e-09 uic
wrdata unipolar_full_bridge_24V_1.dat i(Lcoil)
quit
.endc
.end
