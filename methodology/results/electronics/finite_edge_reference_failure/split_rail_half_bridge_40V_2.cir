Independent periodic RL reference; ideal differential drive, not a transistor model
Vdrive drive 0 PULSE(-21 21 0 6.2500000000000001e-10 6.2500000000000001e-10 3.151160714285714e-06 6.2500000000000003e-06)
Rcoil drive winding 0.47570299886022366
Lcoil winding 0 2.578766605211726e-05 IC=-0.89378705322482266
.options reltol=1e-08 abstol=1e-10
.control
set wr_singlescale
set wr_vecnames
set numdgt=17
tran 6.1035156250000003e-09 5.0000000000000002e-05 0 6.1035156250000003e-09 uic
wrdata split_rail_half_bridge_40V_2.dat i(Lcoil)
quit
.endc
.end
