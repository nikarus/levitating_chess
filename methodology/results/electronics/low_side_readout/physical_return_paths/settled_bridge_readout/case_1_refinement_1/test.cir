Physical shunt waveform replay into unchanged TI INA181; input loading reported separately
.include ina181a1.lib
Vs supply 0 PWL(0 0 9.9999999999999995e-07 5)
Eref reference 0 supply 0 0.5
VpgndA pgndA 0 PWL(
+ 0 4.5624752229059989e-11
+ 1.2207031250000001e-08 4.5669966819297461e-11
+ 2.4414062500000001e-08 4.5718898557805248e-11
+ 3.6621093750000003e-08 4.5770037749483043e-11
+ 4.8828125000000002e-08 4.5822485350610839e-11
+ 6.1035156250000001e-08 4.5875705969269391e-11
+ 7.3242187500000007e-08 4.5929380773488921e-11
+ 8.5449218750000012e-08 4.5983319895906806e-11
+ 9.7656250000000018e-08 4.6037410269464089e-11
+ 1.0986328125000002e-07 4.6091584562801975e-11
+ 1.2207031250000003e-07 4.6145802680837535e-11
+ 1.3427734375000003e-07 4.6200040748086769e-11
+ 1.4648437500000004e-07 4.6254284548072891e-11
+ 1.5869140625000005e-07 4.6308525616398256e-11
+ 1.7089843750000005e-07 4.6362758914111761e-11
+ 1.8310546875000006e-07 4.641698144216514e-11
+ 1.9531250000000006e-07 4.6471191416301583e-11
+ 2.0751953125000007e-07 4.6525387775689795e-11
+ 2.1972656250000007e-07 4.6579569890308451e-11
+ 2.3193359375000008e-07 4.663373738668933e-11
+ 2.4414062500000006e-07 4.6687890044144897e-11
+ 2.5634765625000004e-07 4.6742027732970226e-11
+ 2.6855468750000002e-07 4.6796150377641402e-11
+ 2.8076171875e-07 4.6850257934899579e-11
+ 2.9296874999999997e-07 4.690435038069982e-11
+ 3.0517578124999995e-07 4.695842770243876e-11
+ 3.1738281249999993e-07 4.7012489894326265e-11
+ 3.2958984374999991e-07 4.7066536954629075e-11
+ 3.4179687499999989e-07 4.7120568884029375e-11
+ 3.5400390624999987e-07 4.7174585684647293e-11
+ 3.6621093749999985e-07 4.7228587359458799e-11
+ 3.7841796874999983e-07 4.728257391194907e-11
+ 3.9062499999999981e-07 4.7336545345906017e-11
+ 4.0283203124999979e-07 4.7390501665297362e-11
+ 4.1503906249999977e-07 4.7444442874197415e-11
+ 4.2724609374999974e-07 4.7498368976743532e-11
+ 4.3945312499999972e-07 4.7552279977110043e-11
+ 4.516601562499997e-07 4.7606175879492929e-11
+ 4.6386718749999968e-07 4.76600566881005e-11
+ 4.7607421874999966e-07 4.771392240714795e-11
+ 4.8828124999999969e-07 4.7767773040854128e-11
+ 5.0048828124999972e-07 4.7821608593439534e-11
+ 5.1269531249999976e-07 4.7875429069125182e-11
+ 5.2490234374999979e-07 4.7929234472131972e-11
+ 5.3710937499999982e-07 4.7983024806680162e-11
+ 5.4931640624999985e-07 4.8036800076989225e-11
+ 5.6152343749999988e-07 4.8090560287277661e-11
+ 5.7373046874999992e-07 4.81443054417629e-11
+ 5.8593749999999995e-07 4.8198035544661283e-11
+ 5.9814453124999998e-07 4.8251750600188019e-11
+ 6.1035156250000001e-07 4.8305450612557161e-11
+ 6.2255859375000004e-07 4.835913558598157e-11
+ 6.3476562500000008e-07 4.8412805524672993e-11
+ 6.4697265625000011e-07 4.846646043284194e-11
+ 6.5917968750000014e-07 4.8520100314697792e-11
+ 6.7138671875000017e-07 4.8573725174448732e-11
+ 6.835937500000002e-07 4.8627335016301782e-11
+ 6.9580078125000024e-07 4.8680929844462761e-11
+ 7.0800781250000027e-07 4.8734509663136332e-11
+ 7.202148437500003e-07 4.8788074476525962e-11
+ 7.3242187500000033e-07 4.8841624288833967e-11
+ 7.4462890625000036e-07 4.8895159104261467e-11
+ 7.568359375000004e-07 4.894867892700839e-11
+ 7.6904296875000043e-07 4.9002183761273549e-11
+ 7.8125000000000046e-07 4.905567361125451e-11
+ 7.9345703125000049e-07 4.9109148481147716e-11
+ 8.0566406250000052e-07 4.9162608375148381e-11
+ 8.1787109375000056e-07 4.9216053297450589e-11
+ 8.3007812500000059e-07 4.9269483252247235e-11
+ 8.4228515625000062e-07 4.932289824373005e-11
+ 8.5449218750000065e-07 4.9376298276089576e-11
+ 8.6669921875000069e-07 4.9429683353515166e-11
+ 8.7890625000000072e-07 4.9483053480195042e-11
+ 8.9111328125000075e-07 4.9536408660316226e-11
+ 9.0332031250000078e-07 4.9589748898064572e-11
+ 9.1552734375000081e-07 4.9643074197624777e-11
+ 9.2773437500000085e-07 4.9696384563180337e-11
+ 9.3994140625000088e-07 4.9749679998913594e-11
+ 9.5214843750000091e-07 4.980296050900572e-11
+ 9.6435546875000094e-07 4.9856226097636712e-11
+ 9.7656250000000087e-07 4.99094767689854e-11
+ 9.8876953125000079e-07 4.9962712527229435e-11
+ 1.0009765625000007e-06 5.0015933376545304e-11
+ 1.0131835937500006e-06 5.0069139321108297e-11
+ 1.0253906250000006e-06 5.0122330365092602e-11
+ 1.0375976562500005e-06 5.0175506512671175e-11
+ 1.0498046875000004e-06 5.0228667768015851e-11
+ 1.0620117187500004e-06 5.0281814135297241e-11
+ 1.0742187500000003e-06 5.0334945618684835e-11
+ 1.0864257812500002e-06 5.0388062222346936e-11
+ 1.0986328125000001e-06 5.0441163950450669e-11
+ 1.1108398437500001e-06 5.0494250807162017e-11
+ 1.123046875e-06 5.0547322796645784e-11
+ 1.1352539062499999e-06 5.060037992306559e-11
+ 1.1474609374999998e-06 5.0653422190583924e-11
+ 1.1596679687499998e-06 5.0706449603362099e-11
+ 1.1718749999999997e-06 5.0759462165560252e-11
+ 1.1840820312499996e-06 5.0812459881337356e-11
+ 1.1962890624999995e-06 5.086544275485121e-11
+ 1.2084960937499995e-06 5.0918410790258479e-11
+ 1.2207031249999994e-06 5.0971363991714641e-11
+ 1.2329101562499993e-06 5.1024302363374004e-11
+ 1.2451171874999992e-06 5.1077225909389738e-11
+ 1.2573242187499992e-06 5.1130134633913832e-11
+ 1.2695312499999991e-06 5.1183028541097097e-11
+ 1.281738281249999e-06 5.123590763508922e-11
+ 1.2939453124999989e-06 5.1288771920038706e-11
+ 1.3061523437499989e-06 5.1341621400092889e-11
+ 1.3183593749999988e-06 5.1394456079397949e-11
+ 1.3305664062499987e-06 5.1447275962098919e-11
+ 1.3427734374999987e-06 5.1500081052339658e-11
+ 1.3549804687499986e-06 5.1552871354262853e-11
+ 1.3671874999999985e-06 5.1605646872010057e-11
+ 1.3793945312499984e-06 5.1658407609721638e-11
+ 1.3916015624999984e-06 5.171115357153682e-11
+ 1.4038085937499983e-06 5.1763884761593666e-11
+ 1.4160156249999982e-06 5.1816601184029079e-11
+ 1.4282226562499981e-06 5.1869302842978788e-11
+ 1.4404296874999981e-06 5.1921989742577379e-11
+ 1.452636718749998e-06 5.1974661886958285e-11
+ 1.4648437499999979e-06 5.2027319280253771e-11
+ 1.4770507812499978e-06 5.2079961926594946e-11
+ 1.4892578124999978e-06 5.2132589830111786e-11
+ 1.5014648437499977e-06 5.2185202994933079e-11
+ 1.5136718749999976e-06 5.2237801425186463e-11
+ 1.5258789062499975e-06 5.2290385124998426e-11
+ 1.5380859374999975e-06 5.2342954098494298e-11
+ 1.5502929687499974e-06 5.2395508349798247e-11
+ 1.5624999999999973e-06 5.2448047883033309e-11
+ 1.5747070312499972e-06 5.2500572702321331e-11
+ 1.5869140624999972e-06 5.2553082811783024e-11
+ 1.5991210937499971e-06 5.260557821553798e-11
+ 1.611328124999997e-06 5.265805891770455e-11
+ 1.623535156249997e-06 5.2710524922400013e-11
+ 1.6357421874999969e-06 5.2762976233740464e-11
+ 1.6479492187499968e-06 5.281541285584085e-11
+ 1.6601562499999967e-06 5.2867834792814952e-11
+ 1.6723632812499967e-06 5.2920242048775429e-11
+ 1.6845703124999966e-06 5.297263462783375e-11
+ 1.6967773437499965e-06 5.3025012534100265e-11
+ 1.7089843749999964e-06 5.3077375771684144e-11
+ 1.7211914062499964e-06 5.3129724344693429e-11
+ 1.7333984374999963e-06 5.3182058257235008e-11
+ 1.7456054687499962e-06 5.3234377513414598e-11
+ 1.7578124999999961e-06 5.3286682117336819e-11
+ 1.7700195312499961e-06 5.3338972073105086e-11
+ 1.782226562499996e-06 5.339124738482168e-11
+ 1.7944335937499959e-06 5.3443508056587737e-11
+ 1.8066406249999958e-06 5.349575409250326e-11
+ 1.8188476562499958e-06 5.3547985496667078e-11
+ 1.8310546874999957e-06 5.3600202273176877e-11
+ 1.8432617187499956e-06 5.3652404426129203e-11
+ 1.8554687499999955e-06 5.3704591959619454e-11
+ 1.8676757812499955e-06 5.3756764877741888e-11
+ 1.8798828124999954e-06 5.3808923184589598e-11
+ 1.8920898437499953e-06 5.3861066884254534e-11
+ 1.9042968749999953e-06 5.3913195980827531e-11
+ 1.9165039062499952e-06 5.3965310478398236e-11
+ 1.9287109374999951e-06 5.4017410381055188e-11
+ 1.940917968749995e-06 5.4069495692885746e-11
+ 1.953124999999995e-06 5.4121566417976143e-11
+ 1.9653320312499949e-06 5.4173622560411455e-11
+ 1.9775390624999948e-06 5.4225664124275648e-11
+ 1.9897460937499947e-06 5.4277691113651499e-11
+ 2.0019531249999947e-06 5.4329703532620677e-11
+ 2.0141601562499946e-06 5.4381701385263697e-11
+ 2.0263671874999945e-06 5.4433684675659917e-11
+ 2.0385742187499944e-06 5.4485653407887576e-11
+ 2.0507812499999944e-06 5.4537607586023745e-11
+ 2.0629882812499943e-06 5.4589547214144361e-11
+ 2.0751953124999942e-06 5.4641472296324253e-11
+ 2.0874023437499941e-06 5.4693382836637059e-11
+ 2.0996093749999941e-06 5.4745278839155299e-11
+ 2.111816406249994e-06 5.4797160307950356e-11
+ 2.1240234374999939e-06 5.4849027247092475e-11
+ 2.1362304687499939e-06 5.4900879660650734e-11
+ 2.1484374999999938e-06 5.4952717552693121e-11
+ 2.1606445312499937e-06 5.5004540927286431e-11
+ 2.1728515624999936e-06 5.5055228596414379e-11
+ 2.1850585937499936e-06 5.510627065877697e-11
+ 2.1972656249999935e-06 5.5158092921228189e-11
+ 2.2094726562499934e-06 5.5210849104087091e-11
+ 2.2216796874999933e-06 5.5264521350196526e-11
+ 2.2338867187499933e-06 5.5318219478297029e-11
+ 2.239990234374993e-06 5.5343709041866146e-11
+ 2.2460937499999932e-06 5.5365175813779936e-11
+ 2.2491455078124933e-06 5.537183500008943e-11
+ 2.2521972656249934e-06 5.5371668509114686e-11
+ 2.2552490234374934e-06 5.5354771851498252e-11
+ 2.2566067907740856e-06 5.5334751403020664e-11
+ 2.2569982166608607e-06 5.5326313558461538e-11
+ 2.2573896425476357e-06 5.5316205768572161e-11
+ 2.2583682072645731e-06 5.5280832763072969e-11
+ 2.2594095029081848e-06 5.5216998316807767e-11
+ 2.2599705987353218e-06 5.5162661637241072e-11
+ 2.2603396292983672e-06 5.5114439869388932e-11
+ 2.2611103238158415e-06 5.4960015216721681e-11
+ 2.2617414812338479e-06 5.4732817211499076e-11
+ 2.2621130840090086e-06 5.4516300482441227e-11
+ 2.2624341937957887e-06 5.42419953316085e-11
+ 2.26264709792541e-06 5.400886072195258e-11
+ 2.2628600020550312e-06 5.3774257755821461e-11
+ 2.2649890433512439e-06 5.1549852354822979e-11
+ 2.2771960746012438e-06 4.2855387214314058e-11
+ 2.2894031058512437e-06 4.053247294954365e-11
+ 2.3016101371012437e-06 4.3931039996784842e-11
+ 2.3138171683512436e-06 5.2388572167819672e-11
+ 2.3260241996012435e-06 6.5140225940715896e-11
+ 2.3382312308512435e-06 8.1286621114128428e-11
+ 2.3504382621012434e-06 9.9800201152591339e-11
+ 2.3626452933512433e-06 1.1955731974057662e-10
+ 2.3748523246012432e-06 1.3938677731239894e-10
+ 2.3870593558512432e-06 1.581275910662053e-10
+ 2.3992663871012431e-06 1.7469004130247602e-10
+ 2.411473418351243e-06 1.881149150311095e-10
+ 2.4236804496012429e-06 1.9762660690176225e-10
+ 2.4358874808512429e-06 2.026764694324815e-10
+ 2.4480945121012428e-06 2.0297359093770258e-10
+ 2.4603015433512427e-06 1.9850103705845601e-10
+ 2.4725085746012426e-06 1.8951650785639057e-10
+ 2.4847156058512426e-06 1.7653730627935789e-10
+ 2.4969226371012425e-06 1.6031044421422816e-10
+ 2.5091296683512424e-06 1.4176958358946107e-10
+ 2.5213366996012423e-06 1.2198127662112241e-10
+ 2.5335437308512423e-06 1.0208359001036545e-10
+ 2.5457507621012422e-06 8.3220638681385549e-11
+ 2.5579577933512421e-06 6.6476791169901555e-11
+ 2.5610095511637422e-06 6.2738216402259133e-11
+ 2.5613147269449921e-06 6.2375524734021021e-11
+ 2.562077666398117e-06 6.1477937832984702e-11
+ 2.5624591361246795e-06 6.1034090082773124e-11
+ 2.5624829779825896e-06 6.1006459924724939e-11
+ 2.5624877463541714e-06 6.1000935454857881e-11
+ 2.5624972830973351e-06 6.0989888077255491e-11
+ 2.5624980460367883e-06 6.0989004377034889e-11
+ 2.5624995719156946e-06 6.0987237016591268e-11
+ 2.562499693986007e-06 6.0987095630059761e-11
+ 2.5624999381266319e-06 6.0986812858020706e-11
+ 2.5624999576578818e-06 6.0986790236316644e-11
+ 2.5624999967203816e-06 6.098674499293473e-11
+ 2.5625000748453813e-06 6.2330481534674083e-11
+ 2.562500152970381e-06 6.6608198187672893e-11
+ 2.5625009342203779e-06 2.7075208822833839e-10
+ 2.5625080518459743e-06 1.5641542586395462e-08
+ 2.5625151694715707e-06 5.5354276368357439e-08
+ 2.5625222870971671e-06 1.1939590331347595e-07
+ 2.5625294047227634e-06 2.0774988808958391e-07
+ 2.5625365223483598e-06 3.2039621340029153e-07
+ 2.5625436399739562e-06 4.5731138406416947e-07
+ 2.5625507575995526e-06 6.1846843192454422e-07
+ 2.562557875225149e-06 8.0383692158836119e-07
+ 2.5625649928507454e-06 1.0133829569922963e-06
+ 2.5625721104763418e-06 1.2470691887940203e-06
+ 2.5625792281019382e-06 1.5048548225862434e-06
+ 2.5625878075685702e-06 1.8475543476526228e-06
+ 2.5625963870352022e-06 2.2251205386231599e-06
+ 2.5626049665018343e-06 2.637462112110794e-06
+ 2.5626135459684663e-06 3.0844806091734263e-06
+ 2.5626221254350983e-06 3.5660704276185103e-06
+ 2.5626307049017303e-06 4.0821188567621002e-06
+ 2.5626392843683624e-06 4.6325061146258863e-06
+ 2.5626478638349944e-06 5.2171053875545835e-06
+ 2.5626581807702498e-06 5.965211217502911e-06
+ 2.5626684977055052e-06 6.7623492313414161e-06
+ 2.5626788146407606e-06 7.6082590651614992e-06
+ 2.562689131576016e-06 8.5026660760363497e-06
+ 2.5626994485112714e-06 9.4452814742207388e-06
+ 2.5627097654465268e-06 1.0435802462230257e-05
+ 2.5627200823817821e-06 1.147391238070454e-05
+ 2.5627303993170375e-06 1.25592808609545e-05
+ 2.562742902012257e-06 1.393744004677843e-05
+ 2.5627554047074765e-06 1.538385928477854e-05
+ 2.562767907402696e-06 1.6897871760843825e-05
+ 2.5627804100979155e-06 1.8478782715895571e-05
+ 2.5627929127931349e-06 2.0125869935940648e-05
+ 2.5628054154883544e-06 2.1838384260846487e-05
+ 2.5628179181835739e-06 2.3615550111329756e-05
+ 2.5628304208787934e-06 2.5456566033633845e-05
+ 2.5628455922538732e-06 2.7775100207116592e-05
+ 2.562860763628953e-06 3.0184906039223483e-05
+ 2.5628759350040328e-06 3.2684405463249104e-05
+ 2.5628911063791127e-06 3.5271969973378807e-05
+ 2.5629062777541925e-06 3.7945922288216153e-05
+ 2.5629214491292723e-06 4.0704538058428326e-05
+ 2.5629366205043521e-06 4.3546047616054653e-05
+ 2.5629548605195594e-06 4.7069469432613542e-05
+ 2.5629731005347667e-06 5.0706855826657106e-05
+ 2.562991340549974e-06 5.4454893918205257e-05
+ 2.5630095805651813e-06 5.8310193146384224e-05
+ 2.5630278205803886e-06 6.2269290123695639e-05
+ 2.5630460605955959e-06 6.6328653564053143e-05
+ 2.5630681998658447e-06 7.1385338233594827e-05
+ 2.5630903391360935e-06 7.6577901326810804e-05
+ 2.5631124784063423e-06 8.189969012601315e-05
+ 2.563134617676591e-06 8.7343953274172687e-05
+ 2.5631612930113167e-06 9.4056657818521804e-05
+ 2.5631878730958064e-06 0.00010090035482762358
+ 2.5632144531802961e-06 0.00010788664307091889
+ 2.5632486884843397e-06 0.00011707548567577072
+ 2.5632829237883832e-06 0.00012645461865043843
+ 2.5633153561270468e-06 0.00013549167951766453
+ 2.5633477884657104e-06 0.00014465398332574899
+ 2.563380220804374e-06 0.00015391958689944246
+ 2.5634126531430375e-06 0.00016326679416820027
+ 2.5634450854817011e-06 0.00017267423453976973
+ 2.5634775178203647e-06 0.00018212093762926101
+ 2.5635099501590283e-06 0.00019158640400330904
+ 2.5635423824976919e-06 0.00020105067163597072
+ 2.5635695849981454e-06 0.00020897371829601134
+ 2.563596787498599e-06 0.00021687121736840308
+ 2.5636239899990525e-06 0.0002247324443841368
+ 2.563651192499506e-06 0.00023254704172942061
+ 2.5636783949999595e-06 0.00024030503688061725
+ 2.5637055975004131e-06 0.00024799685880477063
+ 2.5637328000008666e-06 0.00025561335251051022
+ 2.5637600025013201e-06 0.00026314579174345146
+ 2.5637872050017737e-06 0.00027058588982929906
+ 2.5638144075022272e-06 0.00027792580867665878
+ 2.5638416100026807e-06 0.0002851581659600263
+ 2.5638688125031343e-06 0.00029227604051150784
+ 2.5638960150035878e-06 0.00029927297595749906
+ 2.5639232175040413e-06 0.00030614298264376868
+ 2.5639504200044949e-06 0.00031288053789913813
+ 2.5639776225049484e-06 0.00031948058469418605
+ 2.5640048250054019e-06 0.00032593852875712024
+ 2.5640320275058554e-06 0.00033225023421413059
+ 2.564059230006309e-06 0.00033841201782615327
+ 2.5640864325067625e-06 0.0003444206418985982
+ 2.5641153008834975e-06 0.00035062659892727544
+ 2.5641441692602324e-06 0.0003566540934654631
+ 2.5641730376369674e-06 0.00036250083298786399
+ 2.5642019060137023e-06 0.00036816503744223664
+ 2.5642307743904373e-06 0.00037364542226806104
+ 2.5642596427671722e-06 0.00037894118026981165
+ 2.5642885111439072e-06 0.00038405196247931109
+ 2.5643173795206421e-06 0.000388977858140999
+ 2.5643462478973771e-06 0.00039371937395252178
+ 2.5643811351666819e-06 0.0003992047348763101
+ 2.5644160224359868e-06 0.00040442447430172904
+ 2.5644499855060496e-06 0.00040925368585940502
+ 2.5644839485761124e-06 0.00041383750344981278
+ 2.5645179116461752e-06 0.00041817993390062743
+ 2.564551874716238e-06 0.00042228549548244641
+ 2.5645858377863008e-06 0.00042615916749456922
+ 2.5646273810828166e-06 0.0004305900119691504
+ 2.5646689243793324e-06 0.00043469258490726371
+ 2.5647104676758482e-06 0.0004384781612780042
+ 2.5647520109723639e-06 0.00044195857402361564
+ 2.5648023225230976e-06 0.00044578261210212054
+ 2.564853125173634e-06 0.00044923093231022854
+ 2.5649039278241704e-06 0.00045228765276156626
+ 2.5649716072662458e-06 0.00045579239535176001
+ 2.5650392867083211e-06 0.00045870005395461338
+ 2.5650919193965658e-06 0.00046058369469111949
+ 2.5651445520848105e-06 0.00046216451732223918
+ 2.5651971847730552e-06 0.00046346681282214352
+ 2.5652498174612999e-06 0.00046451393123718372
+ 2.5652978099291026e-06 0.00046526519657479943
+ 2.5653458023969054e-06 0.00046583893527304737
+ 2.5653937948647082e-06 0.00046625041073407677
+ 2.5654417873325109e-06 0.00046651403875466578
+ 2.5654897798003137e-06 0.0004666433740508164
+ 2.5655372615548627e-06 0.00046665162291553914
+ 2.5655847433094117e-06 0.000466552308242554
+ 2.5656322250639607e-06 0.00046635608374731292
+ 2.5656797068185097e-06 0.00046607281339991539
+ 2.5657271885730587e-06 0.00046571159614456351
+ 2.5657746703276077e-06 0.00046528079492301239
+ 2.5658243585833644e-06 0.00046476378468933915
+ 2.5658740468391212e-06 0.00046418694952370777
+ 2.5659237350948779e-06 0.00046355752837163748
+ 2.5659734233506347e-06 0.00046288205221083837
+ 2.5660231116063915e-06 0.00046216639229460844
+ 2.5660727998621482e-06 0.00046141580830294233
+ 2.5661279513860744e-06 0.00046054748419045071
+ 2.5661831029100005e-06 0.00045964758393211987
+ 2.5662382544339267e-06 0.00045872107390199996
+ 2.5662934059578528e-06 0.00045777228079549998
+ 2.566348557481779e-06 0.00045680495887963081
+ 2.5664116405205382e-06 0.000455679953428722
+ 2.5664747235592973e-06 0.00045453907391423655
+ 2.5665378065980565e-06 0.0004533857886546739
+ 2.5666008896368157e-06 0.00045222299034028662
+ 2.566674140146425e-06 0.00045086399130210022
+ 2.5667473906560343e-06 0.00044949844535668453
+ 2.5668206411656436e-06 0.00044812878579885432
+ 2.5669056194215832e-06 0.00044653719761490697
+ 2.5669905976775228e-06 0.0004449449586312652
+ 2.5670938368447841e-06 0.00044301214871122791
+ 2.567198171769413e-06 0.00044106269601017851
+ 2.5673025066940418e-06 0.00043911870626636078
+ 2.5674266644691634e-06 0.00043681393387383496
+ 2.567550822244285e-06 0.00043451951813961668
+ 2.5677058008065315e-06 0.00043167106196547318
+ 2.5678849371317864e-06 0.00042840086834201771
+ 2.5680985566023881e-06 0.00042453293757745131
+ 2.568364485722952e-06 0.00041976628303681877
+ 2.5687179827122034e-06 0.00041351261779238365
+ 2.5692420975641447e-06 0.00040441158298440465
+ 2.5701363401204738e-06 0.00038934346113524376
+ 2.5721328071850344e-06 0.00035769765454050228
+ 2.5739888168580155e-06 0.00033058981538904275
+ 2.576421668443079e-06 0.00029814348467284587
+ 2.5788545200281424e-06 0.00026888165874455468
+ 2.5812873716132059e-06 0.00024249178888257299
+ 2.5837202231982694e-06 0.00021869200206866874
+ 2.5861530747833328e-06 0.00019722808975099272
+ 2.5885859263683963e-06 0.00017787079297825666
+ 2.5910187779534598e-06 0.00016041335425741158
+ 2.5934516295385232e-06 0.0001446693086575522
+ 2.5957677052397796e-06 0.00013111903917235234
+ 2.5988194404067183e-06 0.00011518312547724692
+ 2.6018711755736571e-06 0.00010118403045864018
+ 2.6049229107405958e-06 8.8886357108097517e-05
+ 2.6079746459075345e-06 7.8083318131395906e-05
+ 2.6110263810744732e-06 6.8593258842393536e-05
+ 2.6140781162414119e-06 6.025660181923537e-05
+ 2.6177736187735985e-06 5.1505809187250614e-05
+ 2.6211342886109086e-06 4.4656271026532631e-05
+ 2.6244949584482187e-06 3.8717628008379948e-05
+ 2.6286207316902777e-06 3.2495702272495222e-05
+ 2.6327465049323367e-06 2.7273646663031209e-05
+ 2.6368722781743958e-06 2.2890780980831938e-05
+ 2.6409980514164548e-06 1.9212246512347876e-05
+ 2.6451238246585138e-06 1.6124856494297113e-05
+ 2.650251138437096e-06 1.2970141364146993e-05
+ 2.6553784522156781e-06 1.0432633172092827e-05
+ 2.6605057659942602e-06 8.3915781182774641e-06
+ 2.6656330797728424e-06 6.7498471833962207e-06
+ 2.671995979825151e-06 5.1518189724579756e-06
+ 2.6783588798774597e-06 3.9321378049054371e-06
+ 2.6847217799297684e-06 3.0012267671564931e-06
+ 2.6924972562545095e-06 2.15737185496337e-06
+ 2.7002727325792507e-06 1.5508026051292012e-06
+ 2.7080482089039918e-06 1.1147960586695601e-06
+ 2.7179834419360667e-06 7.3118840550782522e-07
+ 2.7279186749681417e-06 4.7961075194826108e-07
+ 2.7401257062181416e-06 2.8571159964289929e-07
+ 2.7523327374681415e-06 1.7024209705967684e-07
+ 2.7645397687181414e-06 1.0147848625806179e-07
+ 2.7767467999681414e-06 6.0528851952355526e-08
+ 2.7889538312181413e-06 3.6142806128821739e-08
+ 2.8011608624681412e-06 2.1620593980565466e-08
+ 2.8133678937181411e-06 1.2972424953734794e-08
+ 2.8255749249681411e-06 7.8223266739669589e-09
+ 2.837781956218141e-06 4.7553755500354248e-09
+ 2.8499889874681409e-06 2.9289656540459339e-09
+ 2.8621960187181408e-06 1.8413143839828223e-09
+ 2.8744030499681408e-06 1.1936037658401295e-09
+ 2.8866100812181407e-06 8.078836241498485e-10
+ 2.8988171124681406e-06 5.7818218790680653e-10
+ 2.9110241437181405e-06 4.4139192644487092e-10
+ 2.9232311749681405e-06 3.5993152647751398e-10
+ 2.9354382062181404e-06 3.1142080027758294e-10
+ 2.9476452374681403e-06 2.8253202431124535e-10
+ 2.9598522687181403e-06 2.653283707170538e-10
+ 2.9720592999681402e-06 2.5508336753526945e-10
+ 2.9842663312181401e-06 2.4898233649178344e-10
+ 2.99647336246814e-06 2.4534909287155193e-10
+ 3.00868039371814e-06 2.4318544696123555e-10
+ 3.0208874249681399e-06 2.4189696683490067e-10
+ 3.0330944562181398e-06 2.411296605642883e-10
+ 3.0453014874681397e-06 2.406727199550333e-10
+ 3.0575085187181397e-06 2.4040060549918595e-10
+ 3.0697155499681396e-06 2.4023855751768804e-10
+ 3.0819225812181395e-06 2.4014205601586099e-10
+ 3.0941296124681394e-06 2.4008458822552009e-10
+ 3.1063366437181394e-06 2.4005036536744095e-10
+ 3.1185436749681393e-06 2.4002998505548136e-10
+ 3.1307507062181392e-06 2.4001784836154639e-10
+ 3.1429577374681391e-06 2.4001062082534474e-10
+ 3.1551647687181391e-06 2.4000631674323626e-10
+ 3.167371799968139e-06 2.4000375361391963e-10
+ 3.1795788312181389e-06 2.4000222718017004e-10
+ 3.1917858624681389e-06 2.4000131819356677e-10
+ 3.2039928937181388e-06 2.4000077702242996e-10
+ 3.2161999249681387e-06 2.4000045459933931e-10
+ 3.2284069562181386e-06 2.4000026257884156e-10
+ 3.2406139874681386e-06 2.4000014832025053e-10
+ 3.2528210187181385e-06 2.4000008023582484e-10
+ 3.2650280499681384e-06 2.4000003966625581e-10
+ 3.2772350812181383e-06 2.400000155533385e-10
+ 3.2894421124681383e-06 2.4000000121814107e-10
+ 3.3016491437181382e-06 2.3999999261673205e-10
+ 3.3138561749681381e-06 2.3999998758456908e-10
+ 3.326063206218138e-06 2.3999998453222656e-10
+ 3.338270237468138e-06 2.3999998265390494e-10
+ 3.3504772687181379e-06 2.3999998161732485e-10
+ 3.3626842999681378e-06 2.3999998104358188e-10
+ 3.3748913312181377e-06 2.3999998057389865e-10
+ 3.3870983624681377e-06 2.3999998026292464e-10
+ 3.3993053937181376e-06 2.3999998019001177e-10
+ 3.4115124249681375e-06 2.3999998019899801e-10
+ 3.4237194562181374e-06 2.3999998020597388e-10
+ 3.4359264874681374e-06 2.3999998012855701e-10
+ 3.4481335187181373e-06 2.3999998005534517e-10
+ 3.4603405499681372e-06 2.3999998008389102e-10
+ 3.4725475812181372e-06 2.3999998009224399e-10
+ 3.4847546124681371e-06 2.3999998012219294e-10
+ 3.496961643718137e-06 2.3999998013282356e-10
+ 3.5091686749681369e-06 2.3999998009115475e-10
+ 3.5213757062181369e-06 2.3999998009706464e-10
+ 3.5335827374681368e-06 2.3999998010363494e-10
+ 3.5457897687181367e-06 2.3999998011314167e-10
+ 3.5579967999681366e-06 2.3999998013616955e-10
+ 3.5702038312181366e-06 2.3999998011363462e-10
+ 3.5824108624681365e-06 2.3999998009274014e-10
+ 3.5946178937181364e-06 2.399999801011231e-10
+ 3.6068249249681363e-06 2.399999800977465e-10
+ 3.6190319562181363e-06 2.3999998010717031e-10
+ 3.6312389874681362e-06 2.3999998026497155e-10
+ 3.6434460187181361e-06 2.3999998018940695e-10
+ 3.655653049968136e-06 2.399999801489314e-10
+ 3.667860081218136e-06 2.3999998016252337e-10
+ 3.6800671124681359e-06 2.3999998017736873e-10
+ 3.6922741437181358e-06 2.3999998008841631e-10
+ 3.7044811749681357e-06 2.399999801406156e-10
+ 3.7166882062181357e-06 2.3999998027111368e-10
+ 3.7288952374681356e-06 2.399999803096209e-10
+ 3.7411022687181355e-06 2.399999801745041e-10
+ 3.7533092999681355e-06 2.3999998014351678e-10
+ 3.7655163312181354e-06 2.399999802735929e-10
+ 3.7777233624681353e-06 2.3999998026179471e-10
+ 3.7899303937181352e-06 2.3999998016976751e-10
+ 3.8021374249681352e-06 2.3999998022820648e-10
+ 3.8143444562181351e-06 2.3999998018386391e-10
+ 3.8265514874681354e-06 2.3999998024457121e-10
+ 3.8387585187181358e-06 2.399999802712344e-10
+ 3.8509655499681361e-06 2.3999998016906244e-10
+ 3.8631725812181365e-06 2.399999802251944e-10
+ 3.8753796124681368e-06 2.3999998029674961e-10
+ 3.8875866437181372e-06 2.3999998024490881e-10
+ 3.8997936749681375e-06 2.3999998022841694e-10
+ 3.9120007062181379e-06 2.3999998027402318e-10
+ 3.9242077374681382e-06 2.3999998031284179e-10
+ 3.9364147687181386e-06 2.3999998024592236e-10
+ 3.9486217999681389e-06 2.3999998028900653e-10
+ 3.9608288312181393e-06 2.3999998029018118e-10
+ 3.9730358624681396e-06 2.3999998020407995e-10
+ 3.98524289371814e-06 2.3999998030027903e-10
+ 3.9974499249681403e-06 2.3999998034659856e-10
+ 4.0096569562181407e-06 2.3999998035710371e-10
+ 4.021863987468141e-06 2.3999998035781327e-10
+ 4.0340710187181414e-06 2.3999998028429372e-10
+ 4.0462780499681417e-06 2.3999998026462584e-10
+ 4.0584850812181421e-06 2.3999998034401652e-10
+ 4.0706921124681424e-06 2.3999998040748526e-10
+ 4.0828991437181428e-06 2.399999802904164e-10
+ 4.0951061749681431e-06 2.3999998026488739e-10
+ 4.1073132062181435e-06 2.399999803948264e-10
+ 4.1195202374681438e-06 2.399999803901337e-10
+ 4.1317272687181442e-06 2.3999998030809217e-10
+ 4.1439342999681445e-06 2.3999998036169063e-10
+ 4.1561413312181449e-06 2.3999998033495331e-10
+ 4.1683483624681452e-06 2.3999998039429674e-10
+ 4.1805553937181456e-06 2.3999998043834603e-10
+ 4.1927624249681459e-06 2.3999998042747548e-10
+ 4.2049694562181463e-06 2.3999998033813589e-10
+ 4.2171764874681466e-06 2.3999998042749197e-10
+ 4.229383518718147e-06 2.3999998045576412e-10
+ 4.2415905499681473e-06 2.3999998040668088e-10
+ 4.2537975812181477e-06 2.3999998041015307e-10
+ 4.266004612468148e-06 2.3999998038280188e-10
+ 4.2782116437181484e-06 2.399999804963409e-10
+ 4.2904186749681487e-06 2.3999998050724164e-10
+ 4.3026257062181491e-06 2.3999998043757132e-10
+ 4.3148327374681494e-06 2.3999998042873677e-10
+ 4.3270397687181498e-06 2.3999998048062938e-10
+ 4.3392467999681501e-06 2.3999998046244087e-10
+ 4.3514538312181505e-06 2.3999998047367506e-10
+ 4.3636608624681508e-06 2.3999998045481209e-10
+ 4.3758678937181512e-06 2.3999998043752122e-10
+ 4.3880749249681515e-06 2.3999998042446345e-10
+ 4.4002819562181519e-06 2.3999998041722252e-10
+ 4.4124889874681522e-06 2.3999998041674074e-10
+ 4.4246960187181526e-06 2.3999998042357827e-10
+ 4.4369030499681529e-06 2.3999998043806778e-10
+ 4.4491100812181533e-06 2.3999998047660411e-10
+ 4.4613171124681536e-06 2.3999998051655456e-10
+ 4.473524143718154e-06 2.3999998052591767e-10
+ 4.4857311749681543e-06 2.3999998048427911e-10
+ 4.4979382062181547e-06 2.3999998054712477e-10
+ 4.510145237468155e-06 2.3999998057013456e-10
+ 4.5223522687181554e-06 2.3999998051176627e-10
+ 4.5345592999681557e-06 2.3999998057450993e-10
+ 4.5467663312181561e-06 2.3999998053652084e-10
+ 4.5589733624681564e-06 2.3999998056705243e-10
+ 4.5711803937181568e-06 2.399999805326457e-10
+ 4.5833874249681571e-06 2.399999805718764e-10
+ 4.5955944562181575e-06 2.3999998054921403e-10
+ 4.6078014874681578e-06 2.3999998061819825e-10
+ 4.6200085187181582e-06 2.399999805688973e-10
+ 4.6322155499681585e-06 2.3999998054792621e-10
+ 4.6444225812181589e-06 2.39999980627754e-10
+ 4.6566296124681592e-06 2.3999998059474422e-10
+ 4.6688366437181596e-06 2.399999805933057e-10
+ 4.6810436749681599e-06 2.3999998057922352e-10
+ 4.6932507062181603e-06 2.3999998056088616e-10
+ 4.7054577374681606e-06 2.3999998058786213e-10
+ 4.717664768718161e-06 2.399999806005213e-10
+ 4.7298717999681613e-06 2.3999998060792622e-10
+ 4.7420788312181617e-06 2.3999998061547279e-10
+ 4.754285862468162e-06 2.3999998062637359e-10
+ 4.7664928937181624e-06 2.3999998064254068e-10
+ 4.7786999249681627e-06 2.399999806651119e-10
+ 4.7909069562181631e-06 2.3999998065019003e-10
+ 4.8031139874681634e-06 2.3999998066078063e-10
+ 4.8153210187181638e-06 2.399999807158811e-10
+ 4.8275280499681641e-06 2.3999998065933043e-10
+ 4.8397350812181645e-06 2.3999998069949765e-10
+ 4.8519421124681648e-06 2.3999998071137632e-10
+ 4.8641491437181652e-06 2.3999998066492584e-10
+ 4.8763561749681655e-06 2.3999998067631891e-10
+ 4.8885632062181659e-06 2.3999998068067386e-10
+ 4.9007702374681662e-06 2.3999998072884115e-10
+ 4.9129772687181666e-06 2.3999998071703879e-10
+ 4.9251842999681669e-06 2.399999807620995e-10
+ 4.9373913312181673e-06 2.3999998071038665e-10
+ 4.9495983624681676e-06 2.3999998068359319e-10
+ 4.961805393718168e-06 2.3999998073934671e-10
+ 4.9740124249681683e-06 2.3999998074833904e-10
+ 4.9862194562181687e-06 2.3999998072288318e-10
+ 4.998426487468169e-06 2.3999998078919143e-10
+ 5.0106335187181694e-06 2.3999998076965073e-10
+ 5.0228405499681697e-06 2.399999807468099e-10
+ 5.03504758121817e-06 2.3999998076982682e-10
+ 5.0472546124681704e-06 2.3999998077882701e-10
+ 5.0594616437181707e-06 2.3999998078272732e-10
+ 5.0716686749681711e-06 2.3999998077698307e-10
+ 5.0838757062181714e-06 2.3999998078844893e-10
+ 5.0960827374681718e-06 2.3999998080355428e-10
+ 5.1082897687181721e-06 2.3999998082407074e-10
+ 5.1204967999681725e-06 2.3999998085105249e-10
+ 5.1327038312181728e-06 2.3999998076975625e-10
+ 5.1449108624681732e-06 2.399999808033618e-10
+ 5.1571178937181735e-06 2.3999998080328762e-10
+ 5.1693249249681739e-06 2.3999998084082399e-10
+ 5.1815319562181742e-06 2.3999998077877215e-10
+ 5.1937389874681746e-06 2.3999998083679345e-10
+ 5.2059460187181749e-06 2.3999998087406507e-10
+ 5.2181530499681753e-06 2.3999998083776306e-10
+ 5.2303600812181756e-06 2.3999998086990843e-10
+ 5.242567112468176e-06 2.3999998083702247e-10
+ 5.2547741437181763e-06 2.399999808776692e-10
+ 5.2669811749681767e-06 2.3999998085631119e-10
+ 5.279188206218177e-06 2.3999998083949021e-10
+ 5.2913952374681774e-06 2.3999929577393646e-10
+ 5.3036022687181777e-06 2.3999721430085655e-10
+ 5.3158092999681781e-06 2.3999541801853927e-10
+ 5.3280163312181784e-06 2.3999352441667849e-10
+ 5.3402233624681788e-06 2.3998998231508299e-10
+ 5.3524303937181791e-06 2.3998269751518182e-10
+ 5.3646374249681795e-06 2.3996731785187146e-10
+ 5.3707409405931797e-06 2.3994983464395233e-10
+ 5.3768444562181798e-06 2.3990674100743305e-10
+ 5.3798962140306804e-06 2.3985615585153402e-10
+ 5.38294797184318e-06 2.3973456609508262e-10
+ 5.3844738507494298e-06 2.3959023649420816e-10
+ 5.3859997296556797e-06 2.3924487360909957e-10
+ 5.3869911068891847e-06 2.3866252493064795e-10
+ 5.3872697338962416e-06 2.3836567845599657e-10
+ 5.3875483609032986e-06 2.3795958755937176e-10
+ 5.3880988356279693e-06 2.3707317678626589e-10
+ 5.3908752739124348e-06 2.3289947932096134e-10
+ 5.4030823051624352e-06 2.1857108082062022e-10
+ 5.4152893364124355e-06 2.0744394567167327e-10
+ 5.4274963676624359e-06 1.9657101424192844e-10
+ 5.4397033989124362e-06 1.8444183633608339e-10
+ 5.4519104301624366e-06 1.7048236032410772e-10
+ 5.4641174614124369e-06 1.5473832156939622e-10
+ 5.4763244926624373e-06 1.376643966131987e-10
+ 5.4885315239124376e-06 1.1997405552563603e-10
+ 5.500738555162438e-06 1.0252468847149855e-10
+ 5.5129455864124383e-06 8.622433036431135e-11
+ 5.5251526176624386e-06 7.1953269034585456e-11
+ 5.537359648912439e-06 6.0497851486217764e-11
+ 5.5495666801624393e-06 5.2496010132610782e-11
+ 5.5617737114124397e-06 4.8395088933560857e-11
+ 5.57398074266244e-06 4.8422873289603413e-11
+ 5.5861877739124404e-06 5.2572582289997926e-11
+ 5.5983948051624407e-06 6.0602144636946106e-11
+ 5.6106018364124411e-06 7.2047475992215135e-11
+ 5.6228088676624414e-06 8.6248800170538565e-11
+ 5.6350158989124418e-06 1.0238838404643464e-10
+ 5.6472229301624421e-06 1.19537446121802e-10
+ 5.6594299614124425e-06 1.367094991032434e-10
+ 5.6716369926624428e-06 1.5291703382970249e-10
+ 5.6838440239124432e-06 1.6722827017382802e-10
+ 5.6868957817249429e-06 1.7041028620342427e-10
+ 5.687048369615568e-06 1.7056469761267313e-10
+ 5.6874298393421305e-06 1.7094872387604414e-10
+ 5.687467986314787e-06 1.7098696858623529e-10
+ 5.6874756157093184e-06 1.7099461407315297e-10
+ 5.6874908744983814e-06 1.7100990159048815e-10
+ 5.6874969780140066e-06 1.7101601530675094e-10
+ 5.687499419420257e-06 1.7101846058671687e-10
+ 5.6874996044557842e-06 1.7101864591102341e-10
+ 5.6874999745268387e-06 1.710190165576025e-10
+ 5.6875007146689477e-06 2.9362295535076986e-10
+ 5.6875014548110567e-06 6.7955376462053112e-10
+ 5.6875088562321464e-06 1.9019685483973129e-08
+ 5.6875162576532362e-06 6.3680162617685321e-08
+ 5.687523659074326e-06 1.3464578979540883e-07
+ 5.6875310604954158e-06 2.3189729697639808e-07
+ 5.6875384619165056e-06 3.5541134357275011e-07
+ 5.6875475123556867e-06 5.4209487018455778e-07
+ 5.6875565627948677e-06 7.6794744751962639e-07
+ 5.6875656132340488e-06 1.032901665904789e-06
+ 5.6875746636732299e-06 1.3368810846168448e-06
+ 5.687583714112411e-06 1.6798002590529673e-06
+ 5.6875950445335094e-06 2.1638522289015684e-06
+ 5.6876063749546078e-06 2.7085809274094572e-06
+ 5.6876177053757063e-06 3.3137595140903088e-06
+ 5.6876290357968047e-06 3.9791394372703589e-06
+ 5.6876432146533604e-06 4.8961848891924115e-06
+ 5.6876573935099161e-06 5.9065041934527361e-06
+ 5.6876715723664718e-06 7.0094688242501652e-06
+ 5.6876890323969347e-06 8.4939484121898285e-06
+ 5.6877064924273976e-06 1.011650368403691e-05
+ 5.6877239524578605e-06 1.187564441966631e-05
+ 5.6877462684778302e-06 1.4320324258348367e-05
+ 5.6877685844977999e-06 1.6981891243476683e-05
+ 5.6877909005177697e-06 1.9856448881756975e-05
+ 5.6878190902172398e-06 2.3785542948120637e-05
+ 5.68784727991671e-06 2.8038794641957824e-05
+ 5.6878754696161801e-06 3.2606525910010655e-05
+ 5.6879036593156503e-06 3.7478440563006991e-05
+ 5.6879318490151204e-06 4.2643660624918842e-05
+ 5.6879600387145905e-06 4.809076449946518e-05
+ 5.6879882284140607e-06 5.3807826764352856e-05
+ 5.688019414106472e-06 6.0432058501488789e-05
+ 5.6880505997988832e-06 6.7354141141263776e-05
+ 5.6880817854912945e-06 7.4556149339010216e-05
+ 5.6881129711837057e-06 8.2019674226669682e-05
+ 5.6881504184143359e-06 9.1300740447793598e-05
+ 5.688187865644966e-06 0.00010089852928503813
+ 5.6882253128755961e-06 0.00011077933330704341
+ 5.6882708441958085e-06 0.00012312530862772575
+ 5.688316375516021e-06 0.00013577798574481139
+ 5.6883619068362334e-06 0.00014867616552750304
+ 5.6884074381564458e-06 0.00016175929991125412
+ 5.6884410840281113e-06 0.00017151113091571656
+ 5.6884747298997768e-06 0.00018130797963939794
+ 5.6885083757714423e-06 0.00019112690048319055
+ 5.6885420216431078e-06 0.000200945563836072
+ 5.6885756675147732e-06 0.0002107423308290232
+ 5.6886093133864387e-06 0.00022049632214156449
+ 5.6886429592581042e-06 0.00023018748061678874
+ 5.6886766051297697e-06 0.00023979662749408118
+ 5.6887102510014352e-06 0.0002493055121224335
+ 5.6887368706681459e-06 0.00025674620625396695
+ 5.6887634903348567e-06 0.00026410519322842072
+ 5.6887901100015674e-06 0.00027137476557784006
+ 5.6888167296682782e-06 0.00027854762813939171
+ 5.6888433493349889e-06 0.00028561690431054267
+ 5.6888699690016997e-06 0.0002925761407342706
+ 5.6888965886684104e-06 0.0002994193104460534
+ 5.6889232083351212e-06 0.00030614081452042582
+ 5.6889498280018319e-06 0.00031273548226053464
+ 5.6889764476685427e-06 0.00031919856997935221
+ 5.6890030673352534e-06 0.00032552575842600295
+ 5.6890296870019641e-06 0.00033171314891500655
+ 5.6890563066686749e-06 0.00033775725822013397
+ 5.6890829263353856e-06 0.00034365501229800138
+ 5.6891095460020964e-06 0.00034940373890948994
+ 5.6891361656688071e-06 0.00035500115920957621
+ 5.6891627853355179e-06 0.00036044537837818884
+ 5.6891894050022286e-06 0.00036573487536628151
+ 5.6892160246689394e-06 0.00037086849183281574
+ 5.6892394049352276e-06 0.00037524816041470616
+ 5.6892627852015158e-06 0.00037950661982143294
+ 5.689286165467804e-06 0.00038364373347733212
+ 5.6893095457340922e-06 0.00038765955240256639
+ 5.6893329260003804e-06 0.00039155430797307712
+ 5.6893563062666686e-06 0.00039532840450424615
+ 5.6893796865329568e-06 0.00039898241168751826
+ 5.6894030667992451e-06 0.00040251705690861332
+ 5.6894264470655333e-06 0.00040593321747524688
+ 5.6894498273318215e-06 0.0004092319127814815
+ 5.6894732075981097e-06 0.00041241429643495774
+ 5.6894965878643979e-06 0.00041548164837231091
+ 5.6895199681306861e-06 0.00041843536698707185
+ 5.6895433483969743e-06 0.00042127696129328835
+ 5.6895667286632625e-06 0.00042400804314699181
+ 5.6895901089295507e-06 0.00042663031954648096
+ 5.6896134891958389e-06 0.00042914558503120656
+ 5.6896368694621271e-06 0.00043155571419782471
+ 5.6896602497284153e-06 0.00043386265435075173
+ 5.6896836299947035e-06 0.0004360684183033
+ 5.6897070102609918e-06 0.00043817507734421687
+ 5.6897355912375156e-06 0.00044061881915944171
+ 5.6897641722140395e-06 0.00044292160557832261
+ 5.6897927531905634e-06 0.00044508748731897325
+ 5.6898213341670872e-06 0.0004471205811035718
+ 5.6898499151436111e-06 0.00044902505354874717
+ 5.689886199806211e-06 0.00045126415767136695
+ 5.68992545337338e-06 0.00045347065125915753
+ 5.6899469772152624e-06 0.00045458914938144757
+ 5.6899736967146985e-06 0.00045589098737442259
+ 5.6900004162141346e-06 0.00045710004038524538
+ 5.6900271357135706e-06 0.00045821970861944291
+ 5.6900538552130067e-06 0.00045925335947318648
+ 5.6900805747124428e-06 0.00046020432082601948
+ 5.6901072942118789e-06 0.00046107587487371744
+ 5.690134013711315e-06 0.00046187125249194449
+ 5.690160733210751e-06 0.00046259362811953432
+ 5.6901874527101871e-06 0.00046324611514856153
+ 5.6902141722096232e-06 0.00046383176180687778
+ 5.6902408917090593e-06 0.00046435354751746608
+ 5.690262548859611e-06 0.00046473161709406521
+ 5.6902842060101628e-06 0.00046507115570231151
+ 5.6903058631607145e-06 0.00046537364255429416
+ 5.6903275203112662e-06 0.00046564052306956875
+ 5.690349177461818e-06 0.00046587320827894959
+ 5.6903708346123697e-06 0.00046607307433484731
+ 5.6903924917629215e-06 0.00046624146212347479
+ 5.6904141489134732e-06 0.00046637967697419719
+ 5.6904358060640249e-06 0.00046648898846127722
+ 5.6904574632145767e-06 0.00046657063029325929
+ 5.6904791203651284e-06 0.0004666258002852115
+ 5.6904967653996022e-06 0.00046665198683365781
+ 5.690514410434076e-06 0.00046666198405394353
+ 5.6905320554685497e-06 0.00046665638716889121
+ 5.6905497005030235e-06 0.00046663577581361698
+ 5.6905673455374973e-06 0.00046660071413966874
+ 5.690584990571971e-06 0.00046655175093608377
+ 5.6906026356064448e-06 0.00046648941976632619
+ 5.6906202806409186e-06 0.00046641423912008399
+ 5.6906379256753923e-06 0.00046632671257892689
+ 5.6906555707098661e-06 0.00046622732899484812
+ 5.6906732157443399e-06 0.00046611656268073646
+ 5.6906908607788136e-06 0.00046599487361184948
+ 5.6907085058132874e-06 0.00046586270763738396
+ 5.6907261508477612e-06 0.00046572049670126538
+ 5.6907437958822349e-06 0.00046556865907130521
+ 5.6907614409167087e-06 0.00046540759957590188
+ 5.6907790859511825e-06 0.00046523770984748908
+ 5.6907967309856562e-06 0.00046505936857196291
+ 5.69081437602013e-06 0.00046487294174334804
+ 5.6908320210546038e-06 0.00046467878292299136
+ 5.6908496660890775e-06 0.00046447723350260048
+ 5.6908673111235513e-06 0.00046426862297047311
+ 5.6908849561580251e-06 0.00046405326918029163
+ 5.6909026011924988e-06 0.00046383147862188659
+ 5.6909202462269726e-06 0.0004636035466933999
+ 5.6909378912614464e-06 0.00046336975797430831
+ 5.6909555362959202e-06 0.00046313038649879376
+ 5.6909731813303939e-06 0.00046288569602897633
+ 5.6909908263648677e-06 0.00046263594032755121
+ 5.6910084713993415e-06 0.00046238136342939871
+ 5.6910261164338152e-06 0.00046212219991176166
+ 5.691043761468289e-06 0.00046185867516261082
+ 5.6910614065027628e-06 0.00046159100564684353
+ 5.6910790515372365e-06 0.00046131939916998468
+ 5.6910966965717103e-06 0.00046104405513908457
+ 5.6911143416061841e-06 0.00046076516482052872
+ 5.6911319866406578e-06 0.00046048291159450004
+ 5.6911496316751316e-06 0.00046019747120585279
+ 5.6911672767096054e-06 0.00045990901201118061
+ 5.6911849217440791e-06 0.00045961769522188066
+ 5.6912025667785529e-06 0.00045932367514303494
+ 5.6912202118130267e-06 0.00045902709940794936
+ 5.6912378568475004e-06 0.00045872810920820898
+ 5.6912555018819742e-06 0.00045842683951912496
+ 5.691273146916448e-06 0.00045812341932046545
+ 5.6912907919509217e-06 0.00045781797181237863
+ 5.6913084369853955e-06 0.00045751061462643097
+ 5.6913260820198693e-06 0.00045720146003169808
+ 5.691343727054343e-06 0.00045689061513585962
+ 5.6913613720888168e-06 0.00045657818208126165
+ 5.6913790171232906e-06 0.00045626425823592343
+ 5.6913966621577643e-06 0.0004559489363794755
+ 5.6914143071922381e-06 0.0004556323048840281
+ 5.6914319522267119e-06 0.00045531444788997848
+ 5.6914495972611856e-06 0.00045499544547677518
+ 5.6914672422956594e-06 0.00045467537382866608
+ 5.6914848873301332e-06 0.00045435430539546583
+ 5.691502532364607e-06 0.00045403230904838535
+ 5.6915201773990807e-06 0.00045370945023097327
+ 5.6915378224335545e-06 0.00045338579110522598
+ 5.6915554674680283e-06 0.00045306139069292836
+ 5.691573112502502e-06 0.00045273630501229328
+ 5.6915907575369758e-06 0.00045241058720997258
+ 5.6916084025714496e-06 0.00045208428768851668
+ 5.6916260476059233e-06 0.00045175745422936376
+ 5.6916436926403971e-06 0.00045143013211144381
+ 5.6916613376748709e-06 0.00045110236422548483
+ 5.691682620107575e-06 0.00045070649383213837
+ 5.6917027452816776e-06 0.00045033166770387813
+ 5.6917228704557802e-06 0.00044995642757493547
+ 5.6917429956298828e-06 0.00044958082330929242
+ 5.6917631208039854e-06 0.00044920490166811688
+ 5.691783245978088e-06 0.00044882870648050557
+ 5.6918033711521906e-06 0.00044845227880637947
+ 5.6918234963262932e-06 0.00044807565709178331
+ 5.6918436215003957e-06 0.00044769887731683952
+ 5.6918637466744983e-06 0.00044732197313660687
+ 5.6918881107461259e-06 0.00044686556133260454
+ 5.6919124748177534e-06 0.00044640906499999366
+ 5.6919368388893809e-06 0.00044595253182312878
+ 5.6919612029610084e-06 0.00044549600565976083
+ 5.6919855670326359e-06 0.00044503952681690417
+ 5.6920099311042634e-06 0.00044458313230938829
+ 5.6920342951758909e-06 0.00044412685610195336
+ 5.6920586592475184e-06 0.00044367072933572632
+ 5.692083023319146e-06 0.00044321478053989036
+ 5.6921073873907735e-06 0.00044275903582933563
+ 5.6921367196835683e-06 0.00044221066197735565
+ 5.6921660519763631e-06 0.00044166265618977781
+ 5.6921953842691579e-06 0.00044111505229614979
+ 5.6922247165619528e-06 0.000440567880571222
+ 5.6922540488547476e-06 0.0004400211680723513
+ 5.6922833811475424e-06 0.0004394749389480193
+ 5.6923127134403372e-06 0.0004389292147195882
+ 5.6923420457331321e-06 0.00043838401453830063
+ 5.6923778480291947e-06 0.00043771929099924211
+ 5.6924123354546283e-06 0.00043707976746529866
+ 5.6924468228800619e-06 0.00043644103787377733
+ 5.6924813103054954e-06 0.00043580312030283216
+ 5.692515797730929e-06 0.00043516603032572377
+ 5.6925578283212079e-06 0.00043439073279079223
+ 5.6925998589114867e-06 0.00043361670459320404
+ 5.6926418895017655e-06 0.00043284396248195208
+ 5.6926839200920444e-06 0.00043207252012209858
+ 5.6927259506823232e-06 0.00043130238856505936
+ 5.6927775185034229e-06 0.00043035930871672526
+ 5.6928281866664806e-06 0.00042943462880424378
+ 5.6928788548295382e-06 0.00042851188736760037
+ 5.6929295229925959e-06 0.00042759109050169295
+ 5.6929932151434603e-06 0.00042643637215815307
+ 5.6930569072943247e-06 0.0004252847370223043
+ 5.6931205994451891e-06 0.00042413618616643506
+ 5.6931989456107131e-06 0.00042272760989246018
+ 5.6932786576496905e-06 0.00042129925771114857
+ 5.6933583696886679e-06 0.00041987571829712041
+ 5.6934612923707637e-06 0.00041804477075287836
+ 5.6935695089098192e-06 0.00041612824858809757
+ 5.6937019148044358e-06 0.00041379527174881443
+ 5.6938470650301819e-06 0.00041125276249577136
+ 5.6940343152356828e-06 0.00040799587225246868
+ 5.6942558650104237e-06 0.00040417569543334638
+ 5.6945540340925023e-06 0.00039909077578923559
+ 5.694998769870886e-06 0.00039162496079868337
+ 5.6958050039889933e-06 0.00037844492463713218
+ 5.6967117643683144e-06 0.00036415075183872955
+ 5.6977374756864399e-06 0.00034863113834200367
+ 5.6988011434023415e-06 0.00033323544260725887
+ 5.6999447649495455e-06 0.00031744009309453978
+ 5.7022316462789094e-06 0.00028806442739914481
+ 5.704182681216658e-06 0.00026516169925578173
+ 5.706291228517249e-06 0.00024245284579639417
+ 5.7085814674361589e-06 0.00021998507757767748
+ 5.7109266668500228e-06 0.00019913410083615226
+ 5.7132718662638866e-06 0.00018025945489984468
+ 5.7155905371796301e-06 0.00016335772611693962
+ 5.7184745694842792e-06 0.00014452917890563918
+ 5.7213586017889282e-06 0.00012787080313841811
+ 5.7242426340935773e-06 0.00011313246567173927
+ 5.7271266663982263e-06 0.00010009286360866482
+ 5.7300106987028754e-06 8.8556201336288662e-05
+ 5.7328947310075244e-06 7.8349250567829904e-05
+ 5.7357787633121735e-06 6.9318749243295542e-05
+ 5.7393427976635931e-06 5.9583601550415324e-05
+ 5.7429068320150127e-06 5.12156620124964e-05
+ 5.7464708663664323e-06 4.4022919356413453e-05
+ 5.7500349007178519e-06 3.7840328450154061e-05
+ 5.7535989350692715e-06 3.2526023165760874e-05
+ 5.7578999611273604e-06 2.7096692323683933e-05
+ 5.7622009871854493e-06 2.2573641128908005e-05
+ 5.7665020132435382e-06 1.8805590756409222e-05
+ 5.7708030393016272e-06 1.5666514280396347e-05
+ 5.7751040653597161e-06 1.3051421554109079e-05
+ 5.7805025059869823e-06 1.0377818664489998e-05
+ 5.7859009466142486e-06 8.251909089995107e-06
+ 5.7912993872415149e-06 6.5614966739560858e-06
+ 5.7966978278687811e-06 5.2173688876777125e-06
+ 5.8034682476574688e-06 3.9138135354349389e-06
+ 5.8102386674461564e-06 2.9359531577328348e-06
+ 5.8170090872348441e-06 2.2024124497970242e-06
+ 5.8253853043439566e-06 1.5432541258101081e-06
+ 5.833761521453069e-06 1.081378721967762e-06
+ 5.8421377385621815e-06 7.5774041132707628e-07
+ 5.8530433854886557e-06 4.7689837631713853e-07
+ 5.8639490324151299e-06 3.0015113649486665e-07
+ 5.8761560636651302e-06 1.7876217937191045e-07
+ 5.8883630949151306e-06 1.0647330757921957e-07
+ 5.9005701261651309e-06 6.3424252544034479e-08
+ 5.9127771574151313e-06 3.7787934734000867e-08
+ 5.9249841886651316e-06 2.2521155841269887e-08
+ 5.937191219915132e-06 1.3429588576020001e-08
+ 5.9493982511651323e-06 8.015449872567151e-09
+ 5.9616052824151327e-06 4.7912734917149069e-09
+ 5.973812313665133e-06 2.871251600636248e-09
+ 5.9860193449151334e-06 1.7278727196949598e-09
+ 5.9982263761651337e-06 1.0469960699243559e-09
+ 6.0104334074151341e-06 6.4154623608527275e-10
+ 6.0226404386651344e-06 4.0011708092908531e-10
+ 6.0348474699151348e-06 2.563646256420896e-10
+ 6.0470545011651351e-06 1.7078006330613652e-10
+ 6.0592615324151355e-06 1.1983532309874618e-10
+ 6.0714685636651358e-06 8.9519095817165878e-11
+ 6.0836755949151362e-06 7.14874426319846e-11
+ 6.0958826261651365e-06 6.0771426293748156e-11
+ 6.1080896574151369e-06 5.4411972164600532e-11
+ 6.1202966886651372e-06 5.0646908151112081e-11
+ 6.1325037199151376e-06 4.8426835103990855e-11
+ 6.1447107511651379e-06 4.7126820532761082e-11
+ 6.1569177824151383e-06 4.6374708016315066e-11
+ 6.1691248136651386e-06 4.594887297816922e-11
+ 6.181331844915139e-06 4.5717334758833713e-11
+ 6.1935388761651393e-06 4.5601496954841019e-11
+ 6.2057459074151397e-06 4.5554554261028926e-11
+ 6.21795293866514e-06 4.5548633436145208e-11
+ 6.2301599699151404e-06 4.5567135561437956e-11
+ 6.2423670011651407e-06 4.5600175741221697e-11
+ 6.2500000000000003e-06 4.5624752229059989e-11
+ 6.2622070312500006e-06 4.5669966819297461e-11
+ 6.2744140625000002e-06 4.5718898557805248e-11
+ 6.2866210937500005e-06 4.5770037749483043e-11
+ 6.298828125e-06 4.5822485350610839e-11
+ 6.3110351562500004e-06 4.5875705969269391e-11
+ 6.3232421875000007e-06 4.5929380773488921e-11
+ 6.3354492187500002e-06 4.5983319895906806e-11
+ 6.3476562500000006e-06 4.6037410269464089e-11
+ 6.3598632812500001e-06 4.6091584562801975e-11
+ 6.3720703125000004e-06 4.6145802680837535e-11
+ 6.3842773437499999e-06 4.6200040748086769e-11
+ 6.3964843750000003e-06 4.6254284548072891e-11
+ 6.4086914062500006e-06 4.6308525616398256e-11
+ 6.4208984375000001e-06 4.6362758914111761e-11
+ 6.4331054687500005e-06 4.641698144216514e-11
+ 6.4453125e-06 4.6471191416301583e-11
+ 6.4575195312500003e-06 4.6525387775689795e-11
+ 6.4697265625000007e-06 4.6579569890308451e-11
+ 6.4819335937500002e-06 4.663373738668933e-11
+ 6.4941406250000005e-06 4.6687890044144897e-11
+ 6.50634765625e-06 4.6742027732970226e-11
+ 6.5185546875000004e-06 4.6796150377641402e-11
+ 6.5307617187500007e-06 4.6850257934899579e-11
+ 6.5429687500000002e-06 4.690435038069982e-11
+ 6.5551757812500006e-06 4.695842770243876e-11
+ 6.5673828125000001e-06 4.7012489894326265e-11
+ 6.5795898437500004e-06 4.7066536954629075e-11
+ 6.5917968749999999e-06 4.7120568884029375e-11
+ 6.6040039062500003e-06 4.7174585684647293e-11
+ 6.6162109374999998e-06 4.7228587359458799e-11
+ 6.6284179687500001e-06 4.728257391194907e-11
+ 6.6406250000000005e-06 4.7336545345906017e-11
+ 6.65283203125e-06 4.7390501665297362e-11
+ 6.6650390625000003e-06 4.7444442874197415e-11
+ 6.6772460937499998e-06 4.7498368976743532e-11
+ 6.6894531250000002e-06 4.7552279977110043e-11
+ 6.7016601562499997e-06 4.7606175879492929e-11
+ 6.7138671875e-06 4.76600566881005e-11
+ 6.7260742187499995e-06 4.771392240714795e-11
+ 6.7382812499999999e-06 4.7767773040854128e-11
+ 6.7504882812500002e-06 4.7821608593439534e-11
+ 6.7626953124999997e-06 4.7875429069125182e-11
+ 6.7749023437500001e-06 4.7929234472131972e-11
+ 6.7871093750000004e-06 4.7983024806680162e-11
+ 6.7993164062499999e-06 4.8036800076989225e-11
+ 6.8115234375000003e-06 4.8090560287277661e-11
+ 6.8237304687500006e-06 4.81443054417629e-11
+ 6.8359375000000001e-06 4.8198035544661283e-11
+ 6.8481445312500005e-06 4.8251750600188019e-11
+ 6.8603515625e-06 4.8305450612557161e-11
+ 6.8725585937500003e-06 4.835913558598157e-11
+ 6.8847656250000007e-06 4.8412805524672993e-11
+ 6.8969726562500002e-06 4.846646043284194e-11
+ 6.9091796875000005e-06 4.8520100314697792e-11
+ 6.92138671875e-06 4.8573725174448732e-11
+ 6.9335937500000004e-06 4.8627335016301782e-11
+ 6.9458007812500007e-06 4.8680929844462761e-11
+ 6.9580078125000003e-06 4.8734509663136332e-11
+ 6.9702148437500006e-06 4.8788074476525962e-11
+ 6.982421875000001e-06 4.8841624288833967e-11
+ 6.9946289062500005e-06 4.8895159104261467e-11
+ 7.0068359375000008e-06 4.894867892700839e-11
+ 7.0190429687500012e-06 4.9002183761273549e-11
+ 7.0312500000000007e-06 4.905567361125451e-11
+ 7.043457031250001e-06 4.9109148481147716e-11
+ 7.0556640625000005e-06 4.9162608375148381e-11
+ 7.0678710937500009e-06 4.9216053297450589e-11
+ 7.0800781250000012e-06 4.9269483252247235e-11
+ 7.0922851562500007e-06 4.932289824373005e-11
+ 7.1044921875000011e-06 4.9376298276089576e-11
+ 7.1166992187500006e-06 4.9429683353515166e-11
+ 7.1289062500000009e-06 4.9483053480195042e-11
+ 7.1411132812500013e-06 4.9536408660316226e-11
+ 7.1533203125000008e-06 4.9589748898064572e-11
+ 7.1655273437500011e-06 4.9643074197624777e-11
+ 7.1777343750000015e-06 4.9696384563180337e-11
+ 7.189941406250001e-06 4.9749679998913594e-11
+ 7.2021484375000013e-06 4.980296050900572e-11
+ 7.2143554687500017e-06 4.9856226097636712e-11
+ 7.2265625000000012e-06 4.99094767689854e-11
+ 7.2387695312500007e-06 4.9962712527229435e-11
+ 7.250976562500001e-06 5.0015933376545304e-11
+ 7.2631835937500014e-06 5.0069139321108297e-11
+ 7.2753906250000009e-06 5.0122330365092602e-11
+ 7.2875976562500004e-06 5.0175506512671175e-11
+ 7.2998046875000007e-06 5.0228667768015851e-11
+ 7.3120117187500011e-06 5.0281814135297241e-11
+ 7.3242187500000006e-06 5.0334945618684835e-11
+ 7.3364257812500001e-06 5.0388062222346936e-11
+ 7.3486328125000004e-06 5.0441163950450669e-11
+ 7.3608398437500008e-06 5.0494250807162017e-11
+ 7.3730468750000003e-06 5.0547322796645784e-11
+ 7.3852539062499998e-06 5.060037992306559e-11
+ 7.3974609375000001e-06 5.0653422190583924e-11
+ 7.4096679687500005e-06 5.0706449603362099e-11
+ 7.421875e-06 5.0759462165560252e-11
+ 7.4340820312499995e-06 5.0812459881337356e-11
+ 7.4462890624999998e-06 5.086544275485121e-11
+ 7.4584960937500002e-06 5.0918410790258479e-11
+ 7.4707031249999997e-06 5.0971363991714641e-11
+ 7.4829101562499992e-06 5.1024302363374004e-11
+ 7.4951171874999995e-06 5.1077225909389738e-11
+ 7.5073242187499999e-06 5.1130134633913832e-11
+ 7.5195312499999994e-06 5.1183028541097097e-11
+ 7.5317382812499989e-06 5.123590763508922e-11
+ 7.5439453124999992e-06 5.1288771920038706e-11
+ 7.5561523437499996e-06 5.1341621400092889e-11
+ 7.5683593749999991e-06 5.1394456079397949e-11
+ 7.5805664062499986e-06 5.1447275962098919e-11
+ 7.592773437499999e-06 5.1500081052339658e-11
+ 7.6049804687499993e-06 5.1552871354262853e-11
+ 7.6171874999999988e-06 5.1605646872010057e-11
+ 7.6293945312499983e-06 5.1658407609721638e-11
+ 7.6416015624999987e-06 5.171115357153682e-11
+ 7.653808593749999e-06 5.1763884761593666e-11
+ 7.6660156249999994e-06 5.1816601184029079e-11
+ 7.678222656249998e-06 5.1869302842978788e-11
+ 7.6904296874999984e-06 5.1921989742577379e-11
+ 7.7026367187499987e-06 5.1974661886958285e-11
+ 7.7148437499999974e-06 5.2027319280253771e-11
+ 7.7270507812499977e-06 5.2079961926594946e-11
+ 7.7392578124999981e-06 5.2132589830111786e-11
+ 7.7514648437499984e-06 5.2185202994933079e-11
+ 7.7636718749999988e-06 5.2237801425186463e-11
+ 7.7758789062499974e-06 5.2290385124998426e-11
+ 7.7880859374999978e-06 5.2342954098494298e-11
+ 7.8002929687499981e-06 5.2395508349798247e-11
+ 7.8124999999999968e-06 5.2448047883033309e-11
+ 7.8247070312499971e-06 5.2500572702321331e-11
+ 7.8369140624999975e-06 5.2553082811783024e-11
+ 7.8491210937499978e-06 5.260557821553798e-11
+ 7.8613281249999982e-06 5.265805891770455e-11
+ 7.8735351562499968e-06 5.2710524922400013e-11
+ 7.8857421874999972e-06 5.2762976233740464e-11
+ 7.8979492187499975e-06 5.281541285584085e-11
+ 7.9101562499999962e-06 5.2867834792814952e-11
+ 7.9223632812499965e-06 5.2920242048775429e-11
+ 7.9345703124999969e-06 5.297263462783375e-11
+ 7.9467773437499972e-06 5.3025012534100265e-11
+ 7.9589843749999976e-06 5.3077375771684144e-11
+ 7.9711914062499962e-06 5.3129724344693429e-11
+ 7.9833984374999966e-06 5.3182058257235008e-11
+ 7.9956054687499969e-06 5.3234377513414598e-11
+ 8.0078124999999956e-06 5.3286682117336819e-11
+ 8.0200195312499959e-06 5.3338972073105086e-11
+ 8.0322265624999963e-06 5.339124738482168e-11
+ 8.0444335937499966e-06 5.3443508056587737e-11
+ 8.056640624999997e-06 5.349575409250326e-11
+ 8.0688476562499956e-06 5.3547985496667078e-11
+ 8.081054687499996e-06 5.3600202273176877e-11
+ 8.0932617187499963e-06 5.3652404426129203e-11
+ 8.105468749999995e-06 5.3704591959619454e-11
+ 8.1176757812499954e-06 5.3756764877741888e-11
+ 8.1298828124999957e-06 5.3808923184589598e-11
+ 8.1420898437499961e-06 5.3861066884254534e-11
+ 8.1542968749999964e-06 5.3913195980827531e-11
+ 8.1665039062499951e-06 5.3965310478398236e-11
+ 8.1787109374999954e-06 5.4017410381055188e-11
+ 8.1909179687499958e-06 5.4069495692885746e-11
+ 8.2031249999999944e-06 5.4121566417976143e-11
+ 8.2153320312499948e-06 5.4173622560411455e-11
+ 8.2275390624999951e-06 5.4225664124275648e-11
+ 8.2397460937499955e-06 5.4277691113651499e-11
+ 8.2519531249999958e-06 5.4329703532620677e-11
+ 8.2641601562499945e-06 5.4381701385263697e-11
+ 8.2763671874999948e-06 5.4433684675659917e-11
+ 8.2885742187499952e-06 5.4485653407887576e-11
+ 8.3007812499999938e-06 5.4537607586023745e-11
+ 8.3129882812499942e-06 5.4589547214144361e-11
+ 8.3251953124999945e-06 5.4641472296324253e-11
+ 8.3374023437499949e-06 5.4693382836637059e-11
+ 8.3496093749999952e-06 5.4745278839155299e-11
+ 8.3618164062499939e-06 5.4797160307950356e-11
+ 8.3740234374999942e-06 5.4849027247092475e-11
+ 8.3862304687499946e-06 5.4900879660650734e-11
+ 8.3984374999999932e-06 5.4952717552693121e-11
+ 8.4106445312499936e-06 5.5004540927286431e-11
+ 8.4228515624999939e-06 5.5055228596414379e-11
+ 8.4350585937499943e-06 5.510627065877697e-11
+ 8.4472656249999946e-06 5.5158092921228189e-11
+ 8.4594726562499933e-06 5.5210849104087091e-11
+ 8.4716796874999936e-06 5.5264521350196526e-11
+ 8.483886718749994e-06 5.5318219478297029e-11
+ 8.4899902343749933e-06 5.5343709041866146e-11
+ 8.4960937499999926e-06 5.5365175813779936e-11
+ 8.499145507812494e-06 5.537183500008943e-11
+ 8.5021972656249937e-06 5.5371668509114686e-11
+ 8.5052490234374933e-06 5.5354771851498252e-11
+ 8.5066067907740868e-06 5.5334751403020664e-11
+ 8.5069982166608614e-06 5.5326313558461538e-11
+ 8.507389642547636e-06 5.5316205768572161e-11
+ 8.5083682072645734e-06 5.5280832763072969e-11
+ 8.5094095029081855e-06 5.5216998316807767e-11
+ 8.5099705987353213e-06 5.5162661637241072e-11
+ 8.5103396292983667e-06 5.5114439869388932e-11
+ 8.5111103238158418e-06 5.4960015216721681e-11
+ 8.5117414812338482e-06 5.4732817211499076e-11
+ 8.5121130840090089e-06 5.4516300482441227e-11
+ 8.5124341937957882e-06 5.42419953316085e-11
+ 8.5126470979254103e-06 5.400886072195258e-11
+ 8.5128600020550324e-06 5.3774257755821461e-11
+ 8.5149890433512433e-06 5.1549852354822979e-11
+ 8.5271960746012437e-06 4.2855387214314058e-11
+ 8.539403105851244e-06 4.053247294954365e-11
+ 8.5516101371012444e-06 4.3931039996784842e-11
+ 8.5638171683512447e-06 5.2388572167819672e-11
+ 8.5760241996012434e-06 6.5140225940715896e-11
+ 8.5882312308512438e-06 8.1286621114128428e-11
+ 8.6004382621012441e-06 9.9800201152591339e-11
+ 8.6126452933512428e-06 1.1955731974057662e-10
+ 8.6248523246012431e-06 1.3938677731239894e-10
+ 8.6370593558512435e-06 1.581275910662053e-10
+ 8.6492663871012438e-06 1.7469004130247602e-10
+ 8.6614734183512442e-06 1.881149150311095e-10
+ 8.6736804496012428e-06 1.9762660690176225e-10
+ 8.6858874808512432e-06 2.026764694324815e-10
+ 8.6980945121012435e-06 2.0297359093770258e-10
+ 8.7103015433512422e-06 1.9850103705845601e-10
+ 8.7225085746012425e-06 1.8951650785639057e-10
+ 8.7347156058512429e-06 1.7653730627935789e-10
+ 8.7469226371012432e-06 1.6031044421422816e-10
+ 8.7591296683512436e-06 1.4176958358946107e-10
+ 8.7713366996012422e-06 1.2198127662112241e-10
+ 8.7835437308512426e-06 1.0208359001036545e-10
+ 8.7957507621012429e-06 8.3220638681385549e-11
+ 8.8079577933512416e-06 6.6476791169901555e-11
+ 8.8110095511637429e-06 6.2738216402259133e-11
+ 8.8113147269449932e-06 6.2375524734021021e-11
+ 8.8120776663981165e-06 6.1477937832984702e-11
+ 8.8124591361246798e-06 6.1034090082773124e-11
+ 8.812482977982589e-06 6.1006459924724939e-11
+ 8.8124877463541726e-06 6.1000935454857881e-11
+ 8.8124972830973363e-06 6.0989888077255491e-11
+ 8.8124980460367881e-06 6.0989004377034889e-11
+ 8.8124995719156953e-06 6.0987237016591268e-11
+ 8.8124996939860077e-06 6.0987095630059761e-11
+ 8.8124999381266326e-06 6.0986812858020706e-11
+ 8.8124999576578825e-06 6.0986790236316644e-11
+ 8.8124999967203824e-06 6.098674499293473e-11
+ 8.812500074845382e-06 6.2330481534674083e-11
+ 8.8125001529703817e-06 6.6608198187672893e-11
+ 8.8125009342203786e-06 2.7075208822833839e-10
+ 8.8125080518459746e-06 1.5641542586395462e-08
+ 8.8125151694715705e-06 5.5354276368357439e-08
+ 8.8125222870971665e-06 1.1939590331347595e-07
+ 8.8125294047227642e-06 2.0774988808958391e-07
+ 8.8125365223483601e-06 3.2039621340029153e-07
+ 8.8125436399739561e-06 4.5731138406416947e-07
+ 8.8125507575995538e-06 6.1846843192454422e-07
+ 8.8125578752251497e-06 8.0383692158836119e-07
+ 8.8125649928507457e-06 1.0133829569922963e-06
+ 8.8125721104763416e-06 1.2470691887940203e-06
+ 8.8125792281019376e-06 1.5048548225862434e-06
+ 8.8125878075685696e-06 1.8475543476526228e-06
+ 8.8125963870352017e-06 2.2251205386231599e-06
+ 8.8126049665018337e-06 2.637462112110794e-06
+ 8.8126135459684657e-06 3.0844806091734263e-06
+ 8.8126221254350978e-06 3.5660704276185103e-06
+ 8.8126307049017298e-06 4.0821188567621002e-06
+ 8.8126392843683618e-06 4.6325061146258863e-06
+ 8.8126478638349939e-06 5.2171053875545835e-06
+ 8.8126581807702509e-06 5.965211217502911e-06
+ 8.8126684977055046e-06 6.7623492313414161e-06
+ 8.8126788146407617e-06 7.6082590651614992e-06
+ 8.8126891315760154e-06 8.5026660760363497e-06
+ 8.8126994485112725e-06 9.4452814742207388e-06
+ 8.8127097654465262e-06 1.0435802462230257e-05
+ 8.8127200823817833e-06 1.147391238070454e-05
+ 8.812730399317037e-06 1.25592808609545e-05
+ 8.8127429020122577e-06 1.393744004677843e-05
+ 8.8127554047074768e-06 1.538385928477854e-05
+ 8.8127679074026959e-06 1.6897871760843825e-05
+ 8.8127804100979166e-06 1.8478782715895571e-05
+ 8.8127929127931357e-06 2.0125869935940648e-05
+ 8.8128054154883547e-06 2.1838384260846487e-05
+ 8.8128179181835738e-06 2.3615550111329756e-05
+ 8.8128304208787928e-06 2.5456566033633845e-05
+ 8.8128455922538743e-06 2.7775100207116592e-05
+ 8.8128607636289525e-06 3.0184906039223483e-05
+ 8.812875935004034e-06 3.2684405463249104e-05
+ 8.8128911063791121e-06 3.5271969973378807e-05
+ 8.8129062777541936e-06 3.7945922288216153e-05
+ 8.8129214491292718e-06 4.0704538058428326e-05
+ 8.8129366205043533e-06 4.3546047616054653e-05
+ 8.8129548605195593e-06 4.7069469432613542e-05
+ 8.812973100534767e-06 5.0706855826657106e-05
+ 8.8129913405499748e-06 5.4454893918205257e-05
+ 8.8130095805651808e-06 5.8310193146384224e-05
+ 8.8130278205803885e-06 6.2269290123695639e-05
+ 8.8130460605955962e-06 6.6328653564053143e-05
+ 8.8130681998658446e-06 7.1385338233594827e-05
+ 8.8130903391360929e-06 7.6577901326810804e-05
+ 8.813112478406343e-06 8.189969012601315e-05
+ 8.8131346176765913e-06 8.7343953274172687e-05
+ 8.8131612930113179e-06 9.4056657818521804e-05
+ 8.8131878730958072e-06 0.00010090035482762358
+ 8.8132144531802964e-06 0.00010788664307091889
+ 8.8132486884843395e-06 0.00011707548567577072
+ 8.8132829237883827e-06 0.00012645461865043843
+ 8.8133153561270475e-06 0.00013549167951766453
+ 8.8133477884657107e-06 0.00014465398332574899
+ 8.8133802208043738e-06 0.00015391958689944246
+ 8.8134126531430387e-06 0.00016326679416820027
+ 8.8134450854817019e-06 0.00017267423453976973
+ 8.813477517820365e-06 0.00018212093762926101
+ 8.8135099501590282e-06 0.00019158640400330904
+ 8.8135423824976913e-06 0.00020105067163597072
+ 8.8135695849981466e-06 0.00020897371829601134
+ 8.8135967874985984e-06 0.00021687121736840308
+ 8.8136239899990536e-06 0.0002247324443841368
+ 8.8136511924995055e-06 0.00023254704172942061
+ 8.8136783949999607e-06 0.00024030503688061725
+ 8.8137055975004125e-06 0.00024799685880477063
+ 8.8137328000008678e-06 0.00025561335251051022
+ 8.8137600025013196e-06 0.00026314579174345146
+ 8.8137872050017748e-06 0.00027058588982929906
+ 8.8138144075022267e-06 0.00027792580867665878
+ 8.8138416100026819e-06 0.0002851581659600263
+ 8.8138688125031337e-06 0.00029227604051150784
+ 8.8138960150035889e-06 0.00029927297595749906
+ 8.8139232175040408e-06 0.00030614298264376868
+ 8.813950420004496e-06 0.00031288053789913813
+ 8.8139776225049478e-06 0.00031948058469418605
+ 8.8140048250054031e-06 0.00032593852875712024
+ 8.8140320275058549e-06 0.00033225023421413059
+ 8.8140592300063101e-06 0.00033841201782615327
+ 8.814086432506762e-06 0.0003444206418985982
+ 8.8141153008834978e-06 0.00035062659892727544
+ 8.8141441692602336e-06 0.0003566540934654631
+ 8.8141730376369677e-06 0.00036250083298786399
+ 8.8142019060137018e-06 0.00036816503744223664
+ 8.8142307743904376e-06 0.00037364542226806104
+ 8.8142596427671734e-06 0.00037894118026981165
+ 8.8142885111439075e-06 0.00038405196247931109
+ 8.8143173795206416e-06 0.000388977858140999
+ 8.8143462478973774e-06 0.00039371937395252178
+ 8.8143811351666814e-06 0.0003992047348763101
+ 8.8144160224359871e-06 0.00040442447430172904
+ 8.8144499855060499e-06 0.00040925368585940502
+ 8.8144839485761127e-06 0.00041383750344981278
+ 8.8145179116461755e-06 0.00041817993390062743
+ 8.8145518747162383e-06 0.00042228549548244641
+ 8.8145858377863011e-06 0.00042615916749456922
+ 8.8146273810828173e-06 0.0004305900119691504
+ 8.8146689243793318e-06 0.00043469258490726371
+ 8.814710467675848e-06 0.0004384781612780042
+ 8.8147520109723642e-06 0.00044195857402361564
+ 8.8148023225230984e-06 0.00044578261210212054
+ 8.8148531251736352e-06 0.00044923093231022854
+ 8.8149039278241703e-06 0.00045228765276156626
+ 8.8149716072662465e-06 0.00045579239535176001
+ 8.815039286708321e-06 0.00045870005395461338
+ 8.8150919193965661e-06 0.00046058369469111949
+ 8.8151445520848112e-06 0.00046216451732223918
+ 8.8151971847730563e-06 0.00046346681282214352
+ 8.8152498174612997e-06 0.00046451393123718372
+ 8.8152978099291029e-06 0.00046526519657479943
+ 8.8153458023969061e-06 0.00046583893527304737
+ 8.8153937948647076e-06 0.00046625041073407677
+ 8.8154417873325108e-06 0.00046651403875466578
+ 8.815489779800314e-06 0.0004666433740508164
+ 8.8155372615548634e-06 0.00046665162291553914
+ 8.8155847433094128e-06 0.000466552308242554
+ 8.8156322250639606e-06 0.00046635608374731292
+ 8.81567970681851e-06 0.00046607281339991539
+ 8.8157271885730594e-06 0.00046571159614456351
+ 8.8157746703276071e-06 0.00046528079492301239
+ 8.8158243585833651e-06 0.00046476378468933915
+ 8.8158740468391215e-06 0.00046418694952370777
+ 8.8159237350948778e-06 0.00046355752837163748
+ 8.8159734233506359e-06 0.00046288205221083837
+ 8.8160231116063922e-06 0.00046216639229460844
+ 8.8160727998621485e-06 0.00046141580830294233
+ 8.8161279513860738e-06 0.00046054748419045071
+ 8.8161831029100008e-06 0.00045964758393211987
+ 8.8162382544339278e-06 0.00045872107390199996
+ 8.8162934059578531e-06 0.00045777228079549998
+ 8.8163485574817784e-06 0.00045680495887963081
+ 8.8164116405205389e-06 0.000455679953428722
+ 8.8164747235592976e-06 0.00045453907391423655
+ 8.8165378065980564e-06 0.0004533857886546739
+ 8.8166008896368169e-06 0.00045222299034028662
+ 8.8166741401464245e-06 0.00045086399130210022
+ 8.8167473906560355e-06 0.00044949844535668453
+ 8.816820641165643e-06 0.00044812878579885432
+ 8.8169056194215831e-06 0.00044653719761490697
+ 8.8169905976775231e-06 0.0004449449586312652
+ 8.817093836844784e-06 0.00044301214871122791
+ 8.8171981717694137e-06 0.00044106269601017851
+ 8.8173025066940417e-06 0.00043911870626636078
+ 8.8174266644691637e-06 0.00043681393387383496
+ 8.8175508222442858e-06 0.00043451951813961668
+ 8.8177058008065314e-06 0.00043167106196547318
+ 8.8178849371317862e-06 0.00042840086834201771
+ 8.8180985566023893e-06 0.00042453293757745131
+ 8.8183644857229527e-06 0.00041976628303681877
+ 8.8187179827122033e-06 0.00041351261779238365
+ 8.819242097564145e-06 0.00040441158298440465
+ 8.8201363401204749e-06 0.00038934346113524376
+ 8.8221328071850351e-06 0.00035769765454050228
+ 8.8239888168580162e-06 0.00033058981538904275
+ 8.8264216684430788e-06 0.00029814348467284587
+ 8.8288545200281432e-06 0.00026888165874455468
+ 8.8312873716132058e-06 0.00024249178888257299
+ 8.8337202231982701e-06 0.00021869200206866874
+ 8.8361530747833327e-06 0.00019722808975099272
+ 8.838585926368397e-06 0.00017787079297825666
+ 8.8410187779534596e-06 0.00016041335425741158
+ 8.8434516295385239e-06 0.0001446693086575522
+ 8.8457677052397799e-06 0.00013111903917235234
+ 8.8488194404067182e-06 0.00011518312547724692
+ 8.8518711755736565e-06 0.00010118403045864018
+ 8.8549229107405965e-06 8.8886357108097517e-05
+ 8.8579746459075348e-06 7.8083318131395906e-05
+ 8.8610263810744731e-06 6.8593258842393536e-05
+ 8.8640781162414131e-06 6.025660181923537e-05
+ 8.8677736187735984e-06 5.1505809187250614e-05
+ 8.8711342886109085e-06 4.4656271026532631e-05
+ 8.8744949584482185e-06 3.8717628008379948e-05
+ 8.8786207316902784e-06 3.2495702272495222e-05
+ 8.8827465049323366e-06 2.7273646663031209e-05
+ 8.8868722781743965e-06 2.2890780980831938e-05
+ 8.8909980514164547e-06 1.9212246512347876e-05
+ 8.8951238246585145e-06 1.6124856494297113e-05
+ 8.9002511384370958e-06 1.2970141364146993e-05
+ 8.9053784522156788e-06 1.0432633172092827e-05
+ 8.9105057659942601e-06 8.3915781182774641e-06
+ 8.9156330797728431e-06 6.7498471833962207e-06
+ 8.9219959798251518e-06 5.1518189724579756e-06
+ 8.9283588798774604e-06 3.9321378049054371e-06
+ 8.9347217799297691e-06 3.0012267671564931e-06
+ 8.9424972562545102e-06 2.15737185496337e-06
+ 8.9502727325792514e-06 1.5508026051292012e-06
+ 8.9580482089039925e-06 1.1147960586695601e-06
+ 8.967983441936067e-06 7.3118840550782522e-07
+ 8.9779186749681415e-06 4.7961075194826108e-07
+ 8.9901257062181419e-06 2.8571159964289929e-07
+ 9.0023327374681422e-06 1.7024209705967684e-07
+ 9.0145397687181409e-06 1.0147848625806179e-07
+ 9.0267467999681412e-06 6.0528851952355526e-08
+ 9.0389538312181416e-06 3.6142806128821739e-08
+ 9.0511608624681419e-06 2.1620593980565466e-08
+ 9.0633678937181423e-06 1.2972424953734794e-08
+ 9.0755749249681409e-06 7.8223266739669589e-09
+ 9.0877819562181413e-06 4.7553755500354248e-09
+ 9.0999889874681416e-06 2.9289656540459339e-09
+ 9.1121960187181403e-06 1.8413143839828223e-09
+ 9.1244030499681406e-06 1.1936037658401295e-09
+ 9.136610081218141e-06 8.078836241498485e-10
+ 9.1488171124681413e-06 5.7818218790680653e-10
+ 9.1610241437181417e-06 4.4139192644487092e-10
+ 9.1732311749681404e-06 3.5993152647751398e-10
+ 9.1854382062181407e-06 3.1142080027758294e-10
+ 9.1976452374681411e-06 2.8253202431124535e-10
+ 9.2098522687181397e-06 2.653283707170538e-10
+ 9.2220592999681401e-06 2.5508336753526945e-10
+ 9.2342663312181404e-06 2.4898233649178344e-10
+ 9.2464733624681408e-06 2.4534909287155193e-10
+ 9.2586803937181411e-06 2.4318544696123555e-10
+ 9.2708874249681398e-06 2.4189696683490067e-10
+ 9.2830944562181401e-06 2.411296605642883e-10
+ 9.2953014874681405e-06 2.406727199550333e-10
+ 9.3075085187181391e-06 2.4040060549918595e-10
+ 9.3197155499681395e-06 2.4023855751768804e-10
+ 9.3319225812181398e-06 2.4014205601586099e-10
+ 9.3441296124681402e-06 2.4008458822552009e-10
+ 9.3563366437181405e-06 2.4005036536744095e-10
+ 9.3685436749681392e-06 2.4002998505548136e-10
+ 9.3807507062181395e-06 2.4001784836154639e-10
+ 9.3929577374681399e-06 2.4001062082534474e-10
+ 9.4051647687181385e-06 2.4000631674323626e-10
+ 9.4173717999681389e-06 2.4000375361391963e-10
+ 9.4295788312181392e-06 2.4000222718017004e-10
+ 9.4417858624681396e-06 2.4000131819356677e-10
+ 9.4539928937181399e-06 2.4000077702242996e-10
+ 9.4661999249681386e-06 2.4000045459933931e-10
+ 9.4784069562181389e-06 2.4000026257884156e-10
+ 9.4906139874681393e-06 2.4000014832025053e-10
+ 9.5028210187181379e-06 2.4000008023582484e-10
+ 9.5150280499681383e-06 2.4000003966625581e-10
+ 9.5272350812181386e-06 2.400000155533385e-10
+ 9.539442112468139e-06 2.4000000121814107e-10
+ 9.5516491437181393e-06 2.3999999261673205e-10
+ 9.563856174968138e-06 2.3999998758456908e-10
+ 9.5760632062181383e-06 2.3999998453222656e-10
+ 9.5882702374681387e-06 2.3999998265390494e-10
+ 9.6004772687181373e-06 2.3999998161732485e-10
+ 9.6126842999681377e-06 2.3999998104358188e-10
+ 9.624891331218138e-06 2.3999998057389865e-10
+ 9.6370983624681384e-06 2.3999998026292464e-10
+ 9.6493053937181387e-06 2.3999998019001177e-10
+ 9.6615124249681374e-06 2.3999998019899801e-10
+ 9.6737194562181377e-06 2.3999998020597388e-10
+ 9.6859264874681381e-06 2.3999998012855701e-10
+ 9.6981335187181368e-06 2.3999998005534517e-10
+ 9.7103405499681371e-06 2.3999998008389102e-10
+ 9.7225475812181375e-06 2.3999998009224399e-10
+ 9.7347546124681378e-06 2.3999998012219294e-10
+ 9.7469616437181382e-06 2.3999998013282356e-10
+ 9.7591686749681368e-06 2.3999998009115475e-10
+ 9.7713757062181372e-06 2.3999998009706464e-10
+ 9.7835827374681375e-06 2.3999998010363494e-10
+ 9.7957897687181362e-06 2.3999998011314167e-10
+ 9.8079967999681365e-06 2.3999998013616955e-10
+ 9.8202038312181369e-06 2.3999998011363462e-10
+ 9.8324108624681372e-06 2.3999998009274014e-10
+ 9.8446178937181376e-06 2.399999801011231e-10
+ 9.8568249249681362e-06 2.399999800977465e-10
+ 9.8690319562181366e-06 2.3999998010717031e-10
+ 9.8812389874681369e-06 2.3999998026497155e-10
+ 9.8934460187181356e-06 2.3999998018940695e-10
+ 9.9056530499681359e-06 2.399999801489314e-10
+ 9.9178600812181363e-06 2.3999998016252337e-10
+ 9.9300671124681366e-06 2.3999998017736873e-10
+ 9.942274143718137e-06 2.3999998008841631e-10
+ 9.9544811749681356e-06 2.399999801406156e-10
+ 9.966688206218136e-06 2.3999998027111368e-10
+ 9.9788952374681363e-06 2.399999803096209e-10
+ 9.991102268718135e-06 2.399999801745041e-10
+ 1.0003309299968135e-05 2.3999998014351678e-10
+ 1.0015516331218136e-05 2.399999802735929e-10
+ 1.0027723362468136e-05 2.3999998026179471e-10
+ 1.0039930393718136e-05 2.3999998016976751e-10
+ 1.0052137424968135e-05 2.3999998022820648e-10
+ 1.0064344456218135e-05 2.3999998018386391e-10
+ 1.0076551487468136e-05 2.3999998024457121e-10
+ 1.0088758518718136e-05 2.399999802712344e-10
+ 1.0100965549968136e-05 2.3999998016906244e-10
+ 1.0113172581218137e-05 2.399999802251944e-10
+ 1.0125379612468137e-05 2.3999998029674961e-10
+ 1.0137586643718137e-05 2.3999998024490881e-10
+ 1.0149793674968138e-05 2.3999998022841694e-10
+ 1.0162000706218138e-05 2.3999998027402318e-10
+ 1.0174207737468139e-05 2.3999998031284179e-10
+ 1.0186414768718139e-05 2.3999998024592236e-10
+ 1.0198621799968139e-05 2.3999998028900653e-10
+ 1.021082883121814e-05 2.3999998029018118e-10
+ 1.022303586246814e-05 2.3999998020407995e-10
+ 1.023524289371814e-05 2.3999998030027903e-10
+ 1.0247449924968141e-05 2.3999998034659856e-10
+ 1.0259656956218141e-05 2.3999998035710371e-10
+ 1.0271863987468141e-05 2.3999998035781327e-10
+ 1.0284071018718142e-05 2.3999998028429372e-10
+ 1.0296278049968142e-05 2.3999998026462584e-10
+ 1.0308485081218142e-05 2.3999998034401652e-10
+ 1.0320692112468143e-05 2.3999998040748526e-10
+ 1.0332899143718143e-05 2.399999802904164e-10
+ 1.0345106174968143e-05 2.3999998026488739e-10
+ 1.0357313206218144e-05 2.399999803948264e-10
+ 1.0369520237468144e-05 2.399999803901337e-10
+ 1.0381727268718144e-05 2.3999998030809217e-10
+ 1.0393934299968145e-05 2.3999998036169063e-10
+ 1.0406141331218145e-05 2.3999998033495331e-10
+ 1.0418348362468146e-05 2.3999998039429674e-10
+ 1.0430555393718146e-05 2.3999998043834603e-10
+ 1.0442762424968146e-05 2.3999998042747548e-10
+ 1.0454969456218147e-05 2.3999998033813589e-10
+ 1.0467176487468147e-05 2.3999998042749197e-10
+ 1.0479383518718147e-05 2.3999998045576412e-10
+ 1.0491590549968148e-05 2.3999998040668088e-10
+ 1.0503797581218148e-05 2.3999998041015307e-10
+ 1.0516004612468148e-05 2.3999998038280188e-10
+ 1.0528211643718149e-05 2.399999804963409e-10
+ 1.0540418674968149e-05 2.3999998050724164e-10
+ 1.0552625706218149e-05 2.3999998043757132e-10
+ 1.056483273746815e-05 2.3999998042873677e-10
+ 1.057703976871815e-05 2.3999998048062938e-10
+ 1.058924679996815e-05 2.3999998046244087e-10
+ 1.0601453831218151e-05 2.3999998047367506e-10
+ 1.0613660862468151e-05 2.3999998045481209e-10
+ 1.0625867893718151e-05 2.3999998043752122e-10
+ 1.0638074924968152e-05 2.3999998042446345e-10
+ 1.0650281956218152e-05 2.3999998041722252e-10
+ 1.0662488987468153e-05 2.3999998041674074e-10
+ 1.0674696018718153e-05 2.3999998042357827e-10
+ 1.0686903049968153e-05 2.3999998043806778e-10
+ 1.0699110081218154e-05 2.3999998047660411e-10
+ 1.0711317112468154e-05 2.3999998051655456e-10
+ 1.0723524143718154e-05 2.3999998052591767e-10
+ 1.0735731174968155e-05 2.3999998048427911e-10
+ 1.0747938206218155e-05 2.3999998054712477e-10
+ 1.0760145237468155e-05 2.3999998057013456e-10
+ 1.0772352268718156e-05 2.3999998051176627e-10
+ 1.0784559299968156e-05 2.3999998057450993e-10
+ 1.0796766331218156e-05 2.3999998053652084e-10
+ 1.0808973362468157e-05 2.3999998056705243e-10
+ 1.0821180393718157e-05 2.399999805326457e-10
+ 1.0833387424968157e-05 2.399999805718764e-10
+ 1.0845594456218158e-05 2.3999998054921403e-10
+ 1.0857801487468158e-05 2.3999998061819825e-10
+ 1.0870008518718158e-05 2.399999805688973e-10
+ 1.0882215549968159e-05 2.3999998054792621e-10
+ 1.0894422581218159e-05 2.39999980627754e-10
+ 1.090662961246816e-05 2.3999998059474422e-10
+ 1.091883664371816e-05 2.399999805933057e-10
+ 1.093104367496816e-05 2.3999998057922352e-10
+ 1.0943250706218161e-05 2.3999998056088616e-10
+ 1.0955457737468161e-05 2.3999998058786213e-10
+ 1.0967664768718161e-05 2.399999806005213e-10
+ 1.0979871799968162e-05 2.3999998060792622e-10
+ 1.0992078831218162e-05 2.3999998061547279e-10
+ 1.1004285862468162e-05 2.3999998062637359e-10
+ 1.1016492893718163e-05 2.3999998064254068e-10
+ 1.1028699924968163e-05 2.399999806651119e-10
+ 1.1040906956218163e-05 2.3999998065019003e-10
+ 1.1053113987468164e-05 2.3999998066078063e-10
+ 1.1065321018718164e-05 2.399999807158811e-10
+ 1.1077528049968164e-05 2.3999998065933043e-10
+ 1.1089735081218165e-05 2.3999998069949765e-10
+ 1.1101942112468165e-05 2.3999998071137632e-10
+ 1.1114149143718165e-05 2.3999998066492584e-10
+ 1.1126356174968166e-05 2.3999998067631891e-10
+ 1.1138563206218166e-05 2.3999998068067386e-10
+ 1.1150770237468167e-05 2.3999998072884115e-10
+ 1.1162977268718167e-05 2.3999998071703879e-10
+ 1.1175184299968167e-05 2.399999807620995e-10
+ 1.1187391331218168e-05 2.3999998071038665e-10
+ 1.1199598362468168e-05 2.3999998068359319e-10
+ 1.1211805393718168e-05 2.3999998073934671e-10
+ 1.1224012424968169e-05 2.3999998074833904e-10
+ 1.1236219456218169e-05 2.3999998072288318e-10
+ 1.1248426487468169e-05 2.3999998078919143e-10
+ 1.126063351871817e-05 2.3999998076965073e-10
+ 1.127284054996817e-05 2.399999807468099e-10
+ 1.128504758121817e-05 2.3999998076982682e-10
+ 1.1297254612468171e-05 2.3999998077882701e-10
+ 1.1309461643718171e-05 2.3999998078272732e-10
+ 1.1321668674968171e-05 2.3999998077698307e-10
+ 1.1333875706218172e-05 2.3999998078844893e-10
+ 1.1346082737468172e-05 2.3999998080355428e-10
+ 1.1358289768718172e-05 2.3999998082407074e-10
+ 1.1370496799968173e-05 2.3999998085105249e-10
+ 1.1382703831218173e-05 2.3999998076975625e-10
+ 1.1394910862468173e-05 2.399999808033618e-10
+ 1.1407117893718174e-05 2.3999998080328762e-10
+ 1.1419324924968174e-05 2.3999998084082399e-10
+ 1.1431531956218175e-05 2.3999998077877215e-10
+ 1.1443738987468175e-05 2.3999998083679345e-10
+ 1.1455946018718175e-05 2.3999998087406507e-10
+ 1.1468153049968176e-05 2.3999998083776306e-10
+ 1.1480360081218176e-05 2.3999998086990843e-10
+ 1.1492567112468176e-05 2.3999998083702247e-10
+ 1.1504774143718177e-05 2.399999808776692e-10
+ 1.1516981174968177e-05 2.3999998085631119e-10
+ 1.1529188206218177e-05 2.3999998083949021e-10
+ 1.1541395237468178e-05 2.3999929577393646e-10
+ 1.1553602268718178e-05 2.3999721430085655e-10
+ 1.1565809299968178e-05 2.3999541801853927e-10
+ 1.1578016331218179e-05 2.3999352441667849e-10
+ 1.1590223362468179e-05 2.3998998231508299e-10
+ 1.1602430393718179e-05 2.3998269751518182e-10
+ 1.161463742496818e-05 2.3996731785187146e-10
+ 1.1620740940593179e-05 2.3994983464395233e-10
+ 1.162684445621818e-05 2.3990674100743305e-10
+ 1.1629896214030681e-05 2.3985615585153402e-10
+ 1.1632947971843181e-05 2.3973456609508262e-10
+ 1.1634473850749431e-05 2.3959023649420816e-10
+ 1.1635999729655681e-05 2.3924487360909957e-10
+ 1.1636991106889184e-05 2.3866252493064795e-10
+ 1.1637269733896242e-05 2.3836567845599657e-10
+ 1.16375483609033e-05 2.3795958755937176e-10
+ 1.163809883562797e-05 2.3707317678626589e-10
+ 1.1640875273912434e-05 2.3289947932096134e-10
+ 1.1653082305162436e-05 2.1857108082062022e-10
+ 1.1665289336412435e-05 2.0744394567167327e-10
+ 1.1677496367662437e-05 1.9657101424192844e-10
+ 1.1689703398912436e-05 1.8444183633608339e-10
+ 1.1701910430162438e-05 1.7048236032410772e-10
+ 1.1714117461412436e-05 1.5473832156939622e-10
+ 1.1726324492662438e-05 1.376643966131987e-10
+ 1.1738531523912437e-05 1.1997405552563603e-10
+ 1.1750738555162439e-05 1.0252468847149855e-10
+ 1.1762945586412438e-05 8.622433036431135e-11
+ 1.177515261766244e-05 7.1953269034585456e-11
+ 1.1787359648912438e-05 6.0497851486217764e-11
+ 1.179956668016244e-05 5.2496010132610782e-11
+ 1.1811773711412439e-05 4.8395088933560857e-11
+ 1.1823980742662441e-05 4.8422873289603413e-11
+ 1.183618777391244e-05 5.2572582289997926e-11
+ 1.1848394805162442e-05 6.0602144636946106e-11
+ 1.1860601836412441e-05 7.2047475992215135e-11
+ 1.1872808867662443e-05 8.6248800170538565e-11
+ 1.1885015898912441e-05 1.0238838404643464e-10
+ 1.1897222930162443e-05 1.19537446121802e-10
+ 1.1909429961412442e-05 1.367094991032434e-10
+ 1.1921636992662444e-05 1.5291703382970249e-10
+ 1.1933844023912443e-05 1.6722827017382802e-10
+ 1.1936895781724942e-05 1.7041028620342427e-10
+ 1.1937048369615568e-05 1.7056469761267313e-10
+ 1.193742983934213e-05 1.7094872387604414e-10
+ 1.1937467986314788e-05 1.7098696858623529e-10
+ 1.1937475615709319e-05 1.7099461407315297e-10
+ 1.1937490874498382e-05 1.7100990159048815e-10
+ 1.1937496978014007e-05 1.7101601530675094e-10
+ 1.1937499419420257e-05 1.7101846058671687e-10
+ 1.1937499604455785e-05 1.7101864591102341e-10
+ 1.1937499974526838e-05 1.710190165576025e-10
+ 1.1937500714668947e-05 2.9362295535076986e-10
+ 1.1937501454811056e-05 6.7955376462053112e-10
+ 1.1937508856232146e-05 1.9019685483973129e-08
+ 1.1937516257653236e-05 6.3680162617685321e-08
+ 1.1937523659074325e-05 1.3464578979540883e-07
+ 1.1937531060495415e-05 2.3189729697639808e-07
+ 1.1937538461916505e-05 3.5541134357275011e-07
+ 1.1937547512355687e-05 5.4209487018455778e-07
+ 1.1937556562794869e-05 7.6794744751962639e-07
+ 1.1937565613234049e-05 1.032901665904789e-06
+ 1.1937574663673229e-05 1.3368810846168448e-06
+ 1.1937583714112411e-05 1.6798002590529673e-06
+ 1.193759504453351e-05 2.1638522289015684e-06
+ 1.1937606374954608e-05 2.7085809274094572e-06
+ 1.1937617705375707e-05 3.3137595140903088e-06
+ 1.1937629035796805e-05 3.9791394372703589e-06
+ 1.1937643214653362e-05 4.8961848891924115e-06
+ 1.1937657393509916e-05 5.9065041934527361e-06
+ 1.1937671572366471e-05 7.0094688242501652e-06
+ 1.1937689032396936e-05 8.4939484121898285e-06
+ 1.1937706492427397e-05 1.011650368403691e-05
+ 1.1937723952457862e-05 1.187564441966631e-05
+ 1.1937746268477831e-05 1.4320324258348367e-05
+ 1.1937768584497801e-05 1.6981891243476683e-05
+ 1.1937790900517771e-05 1.9856448881756975e-05
+ 1.193781909021724e-05 2.3785542948120637e-05
+ 1.1937847279916709e-05 2.8038794641957824e-05
+ 1.193787546961618e-05 3.2606525910010655e-05
+ 1.1937903659315651e-05 3.7478440563006991e-05
+ 1.1937931849015121e-05 4.2643660624918842e-05
+ 1.193796003871459e-05 4.809076449946518e-05
+ 1.1937988228414061e-05 5.3807826764352856e-05
+ 1.1938019414106471e-05 6.0432058501488789e-05
+ 1.1938050599798884e-05 6.7354141141263776e-05
+ 1.1938081785491296e-05 7.4556149339010216e-05
+ 1.1938112971183706e-05 8.2019674226669682e-05
+ 1.1938150418414337e-05 9.1300740447793598e-05
+ 1.1938187865644966e-05 0.00010089852928503813
+ 1.1938225312875596e-05 0.00011077933330704341
+ 1.1938270844195809e-05 0.00012312530862772575
+ 1.1938316375516022e-05 0.00013577798574481139
+ 1.1938361906836234e-05 0.00014867616552750304
+ 1.1938407438156445e-05 0.00016175929991125412
+ 1.1938441084028111e-05 0.00017151113091571656
+ 1.1938474729899776e-05 0.00018130797963939794
+ 1.1938508375771442e-05 0.00019112690048319055
+ 1.1938542021643107e-05 0.000200945563836072
+ 1.1938575667514773e-05 0.0002107423308290232
+ 1.1938609313386438e-05 0.00022049632214156449
+ 1.1938642959258104e-05 0.00023018748061678874
+ 1.1938676605129769e-05 0.00023979662749408118
+ 1.1938710251001435e-05 0.0002493055121224335
+ 1.1938736870668146e-05 0.00025674620625396695
+ 1.1938763490334858e-05 0.00026410519322842072
+ 1.1938790110001568e-05 0.00027137476557784006
+ 1.1938816729668278e-05 0.00027854762813939171
+ 1.1938843349334989e-05 0.00028561690431054267
+ 1.1938869969001701e-05 0.0002925761407342706
+ 1.1938896588668411e-05 0.0002994193104460534
+ 1.1938923208335121e-05 0.00030614081452042582
+ 1.1938949828001832e-05 0.00031273548226053464
+ 1.1938976447668544e-05 0.00031919856997935221
+ 1.1939003067335254e-05 0.00032552575842600295
+ 1.1939029687001964e-05 0.00033171314891500655
+ 1.1939056306668675e-05 0.00033775725822013397
+ 1.1939082926335387e-05 0.00034365501229800138
+ 1.1939109546002097e-05 0.00034940373890948994
+ 1.1939136165668807e-05 0.00035500115920957621
+ 1.1939162785335518e-05 0.00036044537837818884
+ 1.193918940500223e-05 0.00036573487536628151
+ 1.193921602466894e-05 0.00037086849183281574
+ 1.1939239404935228e-05 0.00037524816041470616
+ 1.1939262785201516e-05 0.00037950661982143294
+ 1.1939286165467804e-05 0.00038364373347733212
+ 1.1939309545734093e-05 0.00038765955240256639
+ 1.1939332926000381e-05 0.00039155430797307712
+ 1.1939356306266669e-05 0.00039532840450424615
+ 1.1939379686532957e-05 0.00039898241168751826
+ 1.1939403066799245e-05 0.00040251705690861332
+ 1.1939426447065534e-05 0.00040593321747524688
+ 1.1939449827331822e-05 0.0004092319127814815
+ 1.193947320759811e-05 0.00041241429643495774
+ 1.1939496587864398e-05 0.00041548164837231091
+ 1.1939519968130686e-05 0.00041843536698707185
+ 1.1939543348396975e-05 0.00042127696129328835
+ 1.1939566728663263e-05 0.00042400804314699181
+ 1.1939590108929551e-05 0.00042663031954648096
+ 1.1939613489195839e-05 0.00042914558503120656
+ 1.1939636869462127e-05 0.00043155571419782471
+ 1.1939660249728416e-05 0.00043386265435075173
+ 1.1939683629994704e-05 0.0004360684183033
+ 1.1939707010260992e-05 0.00043817507734421687
+ 1.1939735591237516e-05 0.00044061881915944171
+ 1.193976417221404e-05 0.00044292160557832261
+ 1.1939792753190564e-05 0.00044508748731897325
+ 1.1939821334167088e-05 0.0004471205811035718
+ 1.1939849915143611e-05 0.00044902505354874717
+ 1.1939886199806211e-05 0.00045126415767136695
+ 1.1939925453373381e-05 0.00045347065125915753
+ 1.1939946977215264e-05 0.00045458914938144757
+ 1.19399736967147e-05 0.00045589098737442259
+ 1.1940000416214136e-05 0.00045710004038524538
+ 1.1940027135713572e-05 0.00045821970861944291
+ 1.1940053855213008e-05 0.00045925335947318648
+ 1.1940080574712444e-05 0.00046020432082601948
+ 1.194010729421188e-05 0.00046107587487371744
+ 1.1940134013711316e-05 0.00046187125249194449
+ 1.1940160733210752e-05 0.00046259362811953432
+ 1.1940187452710188e-05 0.00046324611514856153
+ 1.1940214172209624e-05 0.00046383176180687778
+ 1.194024089170906e-05 0.00046435354751746608
+ 1.194026254885961e-05 0.00046473161709406521
+ 1.1940284206010164e-05 0.00046507115570231151
+ 1.1940305863160714e-05 0.00046537364255429416
+ 1.1940327520311267e-05 0.00046564052306956875
+ 1.1940349177461817e-05 0.00046587320827894959
+ 1.1940370834612371e-05 0.00046607307433484731
+ 1.1940392491762921e-05 0.00046624146212347479
+ 1.1940414148913474e-05 0.00046637967697419719
+ 1.1940435806064024e-05 0.00046648898846127722
+ 1.1940457463214578e-05 0.00046657063029325929
+ 1.1940479120365128e-05 0.0004666258002852115
+ 1.1940496765399602e-05 0.00046665198683365781
+ 1.1940514410434077e-05 0.00046666198405394353
+ 1.194053205546855e-05 0.00046665638716889121
+ 1.1940549700503023e-05 0.00046663577581361698
+ 1.1940567345537498e-05 0.00046660071413966874
+ 1.1940584990571972e-05 0.00046655175093608377
+ 1.1940602635606445e-05 0.00046648941976632619
+ 1.1940620280640918e-05 0.00046641423912008399
+ 1.1940637925675393e-05 0.00046632671257892689
+ 1.1940655570709867e-05 0.00046622732899484812
+ 1.194067321574434e-05 0.00046611656268073646
+ 1.1940690860778813e-05 0.00046599487361184948
+ 1.1940708505813288e-05 0.00046586270763738396
+ 1.1940726150847762e-05 0.00046572049670126538
+ 1.1940743795882235e-05 0.00046556865907130521
+ 1.1940761440916708e-05 0.00046540759957590188
+ 1.1940779085951183e-05 0.00046523770984748908
+ 1.1940796730985657e-05 0.00046505936857196291
+ 1.194081437602013e-05 0.00046487294174334804
+ 1.1940832021054603e-05 0.00046467878292299136
+ 1.1940849666089078e-05 0.00046447723350260048
+ 1.1940867311123552e-05 0.00046426862297047311
+ 1.1940884956158025e-05 0.00046405326918029163
+ 1.1940902601192498e-05 0.00046383147862188659
+ 1.1940920246226973e-05 0.0004636035466933999
+ 1.1940937891261448e-05 0.00046336975797430831
+ 1.194095553629592e-05 0.00046313038649879376
+ 1.1940973181330393e-05 0.00046288569602897633
+ 1.1940990826364868e-05 0.00046263594032755121
+ 1.1941008471399343e-05 0.00046238136342939871
+ 1.1941026116433816e-05 0.00046212219991176166
+ 1.1941043761468288e-05 0.00046185867516261082
+ 1.1941061406502763e-05 0.00046159100564684353
+ 1.1941079051537238e-05 0.00046131939916998468
+ 1.1941096696571711e-05 0.00046104405513908457
+ 1.1941114341606184e-05 0.00046076516482052872
+ 1.1941131986640658e-05 0.00046048291159450004
+ 1.1941149631675133e-05 0.00046019747120585279
+ 1.1941167276709606e-05 0.00045990901201118061
+ 1.1941184921744079e-05 0.00045961769522188066
+ 1.1941202566778553e-05 0.00045932367514303494
+ 1.1941220211813028e-05 0.00045902709940794936
+ 1.1941237856847501e-05 0.00045872810920820898
+ 1.1941255501881974e-05 0.00045842683951912496
+ 1.1941273146916448e-05 0.00045812341932046545
+ 1.1941290791950923e-05 0.00045781797181237863
+ 1.1941308436985396e-05 0.00045751061462643097
+ 1.1941326082019869e-05 0.00045720146003169808
+ 1.1941343727054343e-05 0.00045689061513585962
+ 1.1941361372088818e-05 0.00045657818208126165
+ 1.1941379017123291e-05 0.00045626425823592343
+ 1.1941396662157764e-05 0.0004559489363794755
+ 1.1941414307192238e-05 0.0004556323048840281
+ 1.1941431952226713e-05 0.00045531444788997848
+ 1.1941449597261186e-05 0.00045499544547677518
+ 1.1941467242295659e-05 0.00045467537382866608
+ 1.1941484887330133e-05 0.00045435430539546583
+ 1.1941502532364608e-05 0.00045403230904838535
+ 1.1941520177399081e-05 0.00045370945023097327
+ 1.1941537822433554e-05 0.00045338579110522598
+ 1.1941555467468029e-05 0.00045306139069292836
+ 1.1941573112502503e-05 0.00045273630501229328
+ 1.1941590757536976e-05 0.00045241058720997258
+ 1.1941608402571449e-05 0.00045208428768851668
+ 1.1941626047605924e-05 0.00045175745422936376
+ 1.1941643692640398e-05 0.00045143013211144381
+ 1.1941661337674871e-05 0.00045110236422548483
+ 1.1941682620107574e-05 0.00045070649383213837
+ 1.1941702745281678e-05 0.00045033166770387813
+ 1.1941722870455781e-05 0.00044995642757493547
+ 1.1941742995629883e-05 0.00044958082330929242
+ 1.1941763120803985e-05 0.00044920490166811688
+ 1.1941783245978088e-05 0.00044882870648050557
+ 1.1941803371152192e-05 0.00044845227880637947
+ 1.1941823496326293e-05 0.00044807565709178331
+ 1.1941843621500395e-05 0.00044769887731683952
+ 1.1941863746674499e-05 0.00044732197313660687
+ 1.1941888110746126e-05 0.00044686556133260454
+ 1.1941912474817754e-05 0.00044640906499999366
+ 1.1941936838889381e-05 0.00044595253182312878
+ 1.1941961202961009e-05 0.00044549600565976083
+ 1.1941985567032636e-05 0.00044503952681690417
+ 1.1942009931104264e-05 0.00044458313230938829
+ 1.1942034295175891e-05 0.00044412685610195336
+ 1.1942058659247519e-05 0.00044367072933572632
+ 1.1942083023319146e-05 0.00044321478053989036
+ 1.1942107387390774e-05 0.00044275903582933563
+ 1.1942136719683569e-05 0.00044221066197735565
+ 1.1942166051976363e-05 0.00044166265618977781
+ 1.1942195384269158e-05 0.00044111505229614979
+ 1.1942224716561953e-05 0.000440567880571222
+ 1.1942254048854748e-05 0.0004400211680723513
+ 1.1942283381147543e-05 0.0004394749389480193
+ 1.1942312713440338e-05 0.0004389292147195882
+ 1.1942342045733132e-05 0.00043838401453830063
+ 1.1942377848029195e-05 0.00043771929099924211
+ 1.1942412335454628e-05 0.00043707976746529866
+ 1.1942446822880062e-05 0.00043644103787377733
+ 1.1942481310305497e-05 0.00043580312030283216
+ 1.1942515797730929e-05 0.00043516603032572377
+ 1.1942557828321209e-05 0.00043439073279079223
+ 1.1942599858911487e-05 0.00043361670459320404
+ 1.1942641889501765e-05 0.00043284396248195208
+ 1.1942683920092045e-05 0.00043207252012209858
+ 1.1942725950682324e-05 0.00043130238856505936
+ 1.1942777518503423e-05 0.00043035930871672526
+ 1.1942828186666482e-05 0.00042943462880424378
+ 1.1942878854829539e-05 0.00042851188736760037
+ 1.1942929522992595e-05 0.00042759109050169295
+ 1.194299321514346e-05 0.00042643637215815307
+ 1.1943056907294324e-05 0.0004252847370223043
+ 1.1943120599445189e-05 0.00042413618616643506
+ 1.1943198945610713e-05 0.00042272760989246018
+ 1.194327865764969e-05 0.00042129925771114857
+ 1.1943358369688668e-05 0.00041987571829712041
+ 1.1943461292370764e-05 0.00041804477075287836
+ 1.1943569508909819e-05 0.00041612824858809757
+ 1.1943701914804436e-05 0.00041379527174881443
+ 1.1943847065030183e-05 0.00041125276249577136
+ 1.1944034315235684e-05 0.00040799587225246868
+ 1.1944255865010424e-05 0.00040417569543334638
+ 1.1944554034092502e-05 0.00039909077578923559
+ 1.1944998769870886e-05 0.00039162496079868337
+ 1.1945805003988994e-05 0.00037844492463713218
+ 1.1946711764368314e-05 0.00036415075183872955
+ 1.1947737475686441e-05 0.00034863113834200367
+ 1.1948801143402342e-05 0.00033323544260725887
+ 1.1949944764949545e-05 0.00031744009309453978
+ 1.195223164627891e-05 0.00028806442739914481
+ 1.1954182681216658e-05 0.00026516169925578173
+ 1.1956291228517249e-05 0.00024245284579639417
+ 1.1958581467436159e-05 0.00021998507757767748
+ 1.1960926666850022e-05 0.00019913410083615226
+ 1.1963271866263887e-05 0.00018025945489984468
+ 1.196559053717963e-05 0.00016335772611693962
+ 1.196847456948428e-05 0.00014452917890563918
+ 1.1971358601788929e-05 0.00012787080313841811
+ 1.1974242634093577e-05 0.00011313246567173927
+ 1.1977126666398227e-05 0.00010009286360866482
+ 1.1980010698702877e-05 8.8556201336288662e-05
+ 1.1982894731007525e-05 7.8349250567829904e-05
+ 1.1985778763312173e-05 6.9318749243295542e-05
+ 1.1989342797663593e-05 5.9583601550415324e-05
+ 1.1992906832015014e-05 5.12156620124964e-05
+ 1.1996470866366433e-05 4.4022919356413453e-05
+ 1.2000034900717851e-05 3.7840328450154061e-05
+ 1.2003598935069272e-05 3.2526023165760874e-05
+ 1.2007899961127362e-05 2.7096692323683933e-05
+ 1.201220098718545e-05 2.2573641128908005e-05
+ 1.2016502013243538e-05 1.8805590756409222e-05
+ 1.2020803039301627e-05 1.5666514280396347e-05
+ 1.2025104065359717e-05 1.3051421554109079e-05
+ 1.2030502505986983e-05 1.0377818664489998e-05
+ 1.2035900946614248e-05 8.251909089995107e-06
+ 1.2041299387241515e-05 6.5614966739560858e-06
+ 1.2046697827868782e-05 5.2173688876777125e-06
+ 1.205346824765747e-05 3.9138135354349389e-06
+ 1.2060238667446158e-05 2.9359531577328348e-06
+ 1.2067009087234845e-05 2.2024124497970242e-06
+ 1.2075385304343958e-05 1.5432541258101081e-06
+ 1.208376152145307e-05 1.081378721967762e-06
+ 1.2092137738562183e-05 7.5774041132707628e-07
+ 1.2103043385488655e-05 4.7689837631713853e-07
+ 1.2113949032415131e-05 3.0015113649486665e-07
+ 1.212615606366513e-05 1.7876217937191045e-07
+ 1.2138363094915132e-05 1.0647330757921957e-07
+ 1.215057012616513e-05 6.3424252544034479e-08
+ 1.2162777157415132e-05 3.7787934734000867e-08
+ 1.2174984188665131e-05 2.2521155841269887e-08
+ 1.2187191219915133e-05 1.3429588576020001e-08
+ 1.2199398251165132e-05 8.015449872567151e-09
+ 1.2211605282415134e-05 4.7912734917149069e-09
+ 1.2223812313665132e-05 2.871251600636248e-09
+ 1.2236019344915135e-05 1.7278727196949598e-09
+ 1.2248226376165133e-05 1.0469960699243559e-09
+ 1.2260433407415135e-05 6.4154623608527275e-10
+ 1.2272640438665134e-05 4.0011708092908531e-10
+ 1.2284847469915136e-05 2.563646256420896e-10
+ 1.2297054501165135e-05 1.7078006330613652e-10
+ 1.2309261532415137e-05 1.1983532309874618e-10
+ 1.2321468563665135e-05 8.9519095817165878e-11
+ 1.2333675594915137e-05 7.14874426319846e-11
+ 1.2345882626165136e-05 6.0771426293748156e-11
+ 1.2358089657415138e-05 5.4411972164600532e-11
+ 1.2370296688665137e-05 5.0646908151112081e-11
+ 1.2382503719915139e-05 4.8426835103990855e-11
+ 1.2394710751165137e-05 4.7126820532761082e-11
+ 1.2406917782415139e-05 4.6374708016315066e-11
+ 1.2419124813665138e-05 4.594887297816922e-11
+ 1.243133184491514e-05 4.5717334758833713e-11
+ 1.2443538876165139e-05 4.5601496954841019e-11
+ 1.2455745907415141e-05 4.5554554261028926e-11
+ 1.2467952938665139e-05 4.5548633436145208e-11
+ 1.2480159969915142e-05 4.5567135561437956e-11
+ 1.249236700116514e-05 4.5600175741221697e-11
+ 1.2500000000000001e-05 4.5624752229059989e-11
+ 1.2512207031250001e-05 4.5669966819297461e-11
+ 1.2524414062500001e-05 4.5718898557805248e-11
+ 1.253662109375e-05 4.5770037749483043e-11
+ 1.2548828125e-05 4.5822485350610839e-11
+ 1.2561035156250001e-05 4.5875705969269391e-11
+ 1.2573242187500001e-05 4.5929380773488921e-11
+ 1.2585449218750001e-05 4.5983319895906806e-11
+ 1.259765625e-05 4.6037410269464089e-11
+ 1.260986328125e-05 4.6091584562801975e-11
+ 1.2622070312500001e-05 4.6145802680837535e-11
+ 1.2634277343750001e-05 4.6200040748086769e-11
+ 1.2646484375000001e-05 4.6254284548072891e-11
+ 1.265869140625e-05 4.6308525616398256e-11
+ 1.26708984375e-05 4.6362758914111761e-11
+ 1.2683105468750001e-05 4.641698144216514e-11
+ 1.2695312500000001e-05 4.6471191416301583e-11
+ 1.2707519531250001e-05 4.6525387775689795e-11
+ 1.27197265625e-05 4.6579569890308451e-11
+ 1.273193359375e-05 4.663373738668933e-11
+ 1.2744140625000001e-05 4.6687890044144897e-11
+ 1.2756347656250001e-05 4.6742027732970226e-11
+ 1.27685546875e-05 4.6796150377641402e-11
+ 1.278076171875e-05 4.6850257934899579e-11
+ 1.2792968750000001e-05 4.690435038069982e-11
+ 1.2805175781250001e-05 4.695842770243876e-11
+ 1.2817382812500001e-05 4.7012489894326265e-11
+ 1.282958984375e-05 4.7066536954629075e-11
+ 1.2841796875e-05 4.7120568884029375e-11
+ 1.2854003906250001e-05 4.7174585684647293e-11
+ 1.2866210937500001e-05 4.7228587359458799e-11
+ 1.2878417968750001e-05 4.728257391194907e-11
+ 1.2890625e-05 4.7336545345906017e-11
+ 1.290283203125e-05 4.7390501665297362e-11
+ 1.2915039062500001e-05 4.7444442874197415e-11
+ 1.2927246093750001e-05 4.7498368976743532e-11
+ 1.2939453125e-05 4.7552279977110043e-11
+ 1.295166015625e-05 4.7606175879492929e-11
+ 1.29638671875e-05 4.76600566881005e-11
+ 1.2976074218750001e-05 4.771392240714795e-11
+ 1.2988281250000001e-05 4.7767773040854128e-11
+ 1.300048828125e-05 4.7821608593439534e-11
+ 1.30126953125e-05 4.7875429069125182e-11
+ 1.302490234375e-05 4.7929234472131972e-11
+ 1.3037109375000001e-05 4.7983024806680162e-11
+ 1.3049316406250001e-05 4.8036800076989225e-11
+ 1.30615234375e-05 4.8090560287277661e-11
+ 1.307373046875e-05 4.81443054417629e-11
+ 1.30859375e-05 4.8198035544661283e-11
+ 1.3098144531250001e-05 4.8251750600188019e-11
+ 1.3110351562500001e-05 4.8305450612557161e-11
+ 1.3122558593750001e-05 4.835913558598157e-11
+ 1.3134765625e-05 4.8412805524672993e-11
+ 1.314697265625e-05 4.846646043284194e-11
+ 1.3159179687500001e-05 4.8520100314697792e-11
+ 1.3171386718750001e-05 4.8573725174448732e-11
+ 1.3183593750000002e-05 4.8627335016301782e-11
+ 1.319580078125e-05 4.8680929844462761e-11
+ 1.3208007812500001e-05 4.8734509663136332e-11
+ 1.3220214843750001e-05 4.8788074476525962e-11
+ 1.3232421875000001e-05 4.8841624288833967e-11
+ 1.3244628906250002e-05 4.8895159104261467e-11
+ 1.32568359375e-05 4.894867892700839e-11
+ 1.3269042968750001e-05 4.9002183761273549e-11
+ 1.3281250000000001e-05 4.905567361125451e-11
+ 1.3293457031250001e-05 4.9109148481147716e-11
+ 1.3305664062500002e-05 4.9162608375148381e-11
+ 1.331787109375e-05 4.9216053297450589e-11
+ 1.3330078125000001e-05 4.9269483252247235e-11
+ 1.3342285156250001e-05 4.932289824373005e-11
+ 1.3354492187500001e-05 4.9376298276089576e-11
+ 1.3366699218750002e-05 4.9429683353515166e-11
+ 1.3378906250000002e-05 4.9483053480195042e-11
+ 1.3391113281250001e-05 4.9536408660316226e-11
+ 1.3403320312500001e-05 4.9589748898064572e-11
+ 1.3415527343750001e-05 4.9643074197624777e-11
+ 1.3427734375000002e-05 4.9696384563180337e-11
+ 1.3439941406250002e-05 4.9749679998913594e-11
+ 1.3452148437500001e-05 4.980296050900572e-11
+ 1.3464355468750001e-05 4.9856226097636712e-11
+ 1.3476562500000001e-05 4.99094767689854e-11
+ 1.3488769531250002e-05 4.9962712527229435e-11
+ 1.35009765625e-05 5.0015933376545304e-11
+ 1.3513183593750001e-05 5.0069139321108297e-11
+ 1.3525390625000001e-05 5.0122330365092602e-11
+ 1.3537597656250002e-05 5.0175506512671175e-11
+ 1.3549804687500002e-05 5.0228667768015851e-11
+ 1.3562011718750001e-05 5.0281814135297241e-11
+ 1.3574218750000001e-05 5.0334945618684835e-11
+ 1.3586425781250001e-05 5.0388062222346936e-11
+ 1.35986328125e-05 5.0441163950450669e-11
+ 1.361083984375e-05 5.0494250807162017e-11
+ 1.3623046875000001e-05 5.0547322796645784e-11
+ 1.3635253906250001e-05 5.060037992306559e-11
+ 1.3647460937500001e-05 5.0653422190583924e-11
+ 1.365966796875e-05 5.0706449603362099e-11
+ 1.3671875e-05 5.0759462165560252e-11
+ 1.3684082031250001e-05 5.0812459881337356e-11
+ 1.3696289062499999e-05 5.086544275485121e-11
+ 1.370849609375e-05 5.0918410790258479e-11
+ 1.3720703125e-05 5.0971363991714641e-11
+ 1.373291015625e-05 5.1024302363374004e-11
+ 1.3745117187500001e-05 5.1077225909389738e-11
+ 1.3757324218749999e-05 5.1130134633913832e-11
+ 1.376953125e-05 5.1183028541097097e-11
+ 1.378173828125e-05 5.123590763508922e-11
+ 1.3793945312499999e-05 5.1288771920038706e-11
+ 1.3806152343749999e-05 5.1341621400092889e-11
+ 1.3818359374999999e-05 5.1394456079397949e-11
+ 1.383056640625e-05 5.1447275962098919e-11
+ 1.38427734375e-05 5.1500081052339658e-11
+ 1.3854980468749999e-05 5.1552871354262853e-11
+ 1.3867187499999999e-05 5.1605646872010057e-11
+ 1.3879394531249999e-05 5.1658407609721638e-11
+ 1.3891601562499998e-05 5.171115357153682e-11
+ 1.3903808593749998e-05 5.1763884761593666e-11
+ 1.3916015624999999e-05 5.1816601184029079e-11
+ 1.3928222656249999e-05 5.1869302842978788e-11
+ 1.39404296875e-05 5.1921989742577379e-11
+ 1.3952636718749998e-05 5.1974661886958285e-11
+ 1.3964843749999999e-05 5.2027319280253771e-11
+ 1.3977050781249999e-05 5.2079961926594946e-11
+ 1.3989257812499998e-05 5.2132589830111786e-11
+ 1.4001464843749998e-05 5.2185202994933079e-11
+ 1.4013671874999998e-05 5.2237801425186463e-11
+ 1.4025878906249999e-05 5.2290385124998426e-11
+ 1.4038085937499999e-05 5.2342954098494298e-11
+ 1.4050292968749998e-05 5.2395508349798247e-11
+ 1.4062499999999998e-05 5.2448047883033309e-11
+ 1.4074707031249998e-05 5.2500572702321331e-11
+ 1.4086914062499997e-05 5.2553082811783024e-11
+ 1.4099121093749997e-05 5.260557821553798e-11
+ 1.4111328124999998e-05 5.265805891770455e-11
+ 1.4123535156249998e-05 5.2710524922400013e-11
+ 1.4135742187499998e-05 5.2762976233740464e-11
+ 1.4147949218749997e-05 5.281541285584085e-11
+ 1.4160156249999997e-05 5.2867834792814952e-11
+ 1.4172363281249998e-05 5.2920242048775429e-11
+ 1.4184570312499996e-05 5.297263462783375e-11
+ 1.4196777343749997e-05 5.3025012534100265e-11
+ 1.4208984374999997e-05 5.3077375771684144e-11
+ 1.4221191406249997e-05 5.3129724344693429e-11
+ 1.4233398437499998e-05 5.3182058257235008e-11
+ 1.4245605468749996e-05 5.3234377513414598e-11
+ 1.4257812499999997e-05 5.3286682117336819e-11
+ 1.4270019531249997e-05 5.3338972073105086e-11
+ 1.4282226562499996e-05 5.339124738482168e-11
+ 1.4294433593749996e-05 5.3443508056587737e-11
+ 1.4306640624999996e-05 5.349575409250326e-11
+ 1.4318847656249997e-05 5.3547985496667078e-11
+ 1.4331054687499997e-05 5.3600202273176877e-11
+ 1.4343261718749996e-05 5.3652404426129203e-11
+ 1.4355468749999996e-05 5.3704591959619454e-11
+ 1.4367675781249996e-05 5.3756764877741888e-11
+ 1.4379882812499995e-05 5.3808923184589598e-11
+ 1.4392089843749996e-05 5.3861066884254534e-11
+ 1.4404296874999996e-05 5.3913195980827531e-11
+ 1.4416503906249996e-05 5.3965310478398236e-11
+ 1.4428710937499997e-05 5.4017410381055188e-11
+ 1.4440917968749995e-05 5.4069495692885746e-11
+ 1.4453124999999996e-05 5.4121566417976143e-11
+ 1.4465332031249996e-05 5.4173622560411455e-11
+ 1.4477539062499995e-05 5.4225664124275648e-11
+ 1.4489746093749995e-05 5.4277691113651499e-11
+ 1.4501953124999995e-05 5.4329703532620677e-11
+ 1.4514160156249996e-05 5.4381701385263697e-11
+ 1.4526367187499996e-05 5.4433684675659917e-11
+ 1.4538574218749995e-05 5.4485653407887576e-11
+ 1.4550781249999995e-05 5.4537607586023745e-11
+ 1.4562988281249995e-05 5.4589547214144361e-11
+ 1.4575195312499994e-05 5.4641472296324253e-11
+ 1.4587402343749994e-05 5.4693382836637059e-11
+ 1.4599609374999995e-05 5.4745278839155299e-11
+ 1.4611816406249995e-05 5.4797160307950356e-11
+ 1.4624023437499995e-05 5.4849027247092475e-11
+ 1.4636230468749994e-05 5.4900879660650734e-11
+ 1.4648437499999994e-05 5.4952717552693121e-11
+ 1.4660644531249995e-05 5.5004540927286431e-11
+ 1.4672851562499993e-05 5.5055228596414379e-11
+ 1.4685058593749994e-05 5.510627065877697e-11
+ 1.4697265624999994e-05 5.5158092921228189e-11
+ 1.4709472656249994e-05 5.5210849104087091e-11
+ 1.4721679687499995e-05 5.5264521350196526e-11
+ 1.4733886718749993e-05 5.5318219478297029e-11
+ 1.4739990234374993e-05 5.5343709041866146e-11
+ 1.4746093749999994e-05 5.5365175813779936e-11
+ 1.4749145507812493e-05 5.537183500008943e-11
+ 1.4752197265624995e-05 5.5371668509114686e-11
+ 1.4755249023437494e-05 5.5354771851498252e-11
+ 1.4756606790774086e-05 5.5334751403020664e-11
+ 1.4756998216660861e-05 5.5326313558461538e-11
+ 1.4757389642547635e-05 5.5316205768572161e-11
+ 1.4758368207264575e-05 5.5280832763072969e-11
+ 1.4759409502908185e-05 5.5216998316807767e-11
+ 1.4759970598735322e-05 5.5162661637241072e-11
+ 1.4760339629298368e-05 5.5114439869388932e-11
+ 1.4761110323815841e-05 5.4960015216721681e-11
+ 1.4761741481233848e-05 5.4732817211499076e-11
+ 1.476211308400901e-05 5.4516300482441227e-11
+ 1.4762434193795789e-05 5.42419953316085e-11
+ 1.476264709792541e-05 5.400886072195258e-11
+ 1.4762860002055032e-05 5.3774257755821461e-11
+ 1.4764989043351244e-05 5.1549852354822979e-11
+ 1.4777196074601245e-05 4.2855387214314058e-11
+ 1.4789403105851243e-05 4.053247294954365e-11
+ 1.4801610137101244e-05 4.3931039996784842e-11
+ 1.4813817168351244e-05 5.2388572167819672e-11
+ 1.4826024199601245e-05 6.5140225940715896e-11
+ 1.4838231230851245e-05 8.1286621114128428e-11
+ 1.4850438262101244e-05 9.9800201152591339e-11
+ 1.4862645293351244e-05 1.1955731974057662e-10
+ 1.4874852324601244e-05 1.3938677731239894e-10
+ 1.4887059355851243e-05 1.581275910662053e-10
+ 1.4899266387101243e-05 1.7469004130247602e-10
+ 1.4911473418351244e-05 1.881149150311095e-10
+ 1.4923680449601244e-05 1.9762660690176225e-10
+ 1.4935887480851244e-05 2.026764694324815e-10
+ 1.4948094512101243e-05 2.0297359093770258e-10
+ 1.4960301543351243e-05 1.9850103705845601e-10
+ 1.4972508574601244e-05 1.8951650785639057e-10
+ 1.4984715605851242e-05 1.7653730627935789e-10
+ 1.4996922637101243e-05 1.6031044421422816e-10
+ 1.5009129668351243e-05 1.4176958358946107e-10
+ 1.5021336699601243e-05 1.2198127662112241e-10
+ 1.5033543730851244e-05 1.0208359001036545e-10
+ 1.5045750762101242e-05 8.3220638681385549e-11
+ 1.5057957793351243e-05 6.6476791169901555e-11
+ 1.5061009551163742e-05 6.2738216402259133e-11
+ 1.5061314726944993e-05 6.2375524734021021e-11
+ 1.5062077666398118e-05 6.1477937832984702e-11
+ 1.5062459136124681e-05 6.1034090082773124e-11
+ 1.506248297798259e-05 6.1006459924724939e-11
+ 1.5062487746354172e-05 6.1000935454857881e-11
+ 1.5062497283097336e-05 6.0989888077255491e-11
+ 1.5062498046036789e-05 6.0989004377034889e-11
+ 1.5062499571915695e-05 6.0987237016591268e-11
+ 1.5062499693986007e-05 6.0987095630059761e-11
+ 1.5062499938126632e-05 6.0986812858020706e-11
+ 1.5062499957657882e-05 6.0986790236316644e-11
+ 1.5062499996720382e-05 6.098674499293473e-11
+ 1.5062500074845381e-05 6.2330481534674083e-11
+ 1.5062500152970381e-05 6.6608198187672893e-11
+ 1.5062500934220378e-05 2.7075208822833839e-10
+ 1.5062508051845974e-05 1.5641542586395462e-08
+ 1.5062515169471572e-05 5.5354276368357439e-08
+ 1.5062522287097168e-05 1.1939590331347595e-07
+ 1.5062529404722764e-05 2.0774988808958391e-07
+ 1.5062536522348361e-05 3.2039621340029153e-07
+ 1.5062543639973957e-05 4.5731138406416947e-07
+ 1.5062550757599553e-05 6.1846843192454422e-07
+ 1.5062557875225149e-05 8.0383692158836119e-07
+ 1.5062564992850745e-05 1.0133829569922963e-06
+ 1.5062572110476343e-05 1.2470691887940203e-06
+ 1.5062579228101939e-05 1.5048548225862434e-06
+ 1.5062587807568571e-05 1.8475543476526228e-06
+ 1.5062596387035203e-05 2.2251205386231599e-06
+ 1.5062604966501835e-05 2.637462112110794e-06
+ 1.5062613545968467e-05 3.0844806091734263e-06
+ 1.5062622125435099e-05 3.5660704276185103e-06
+ 1.5062630704901731e-05 4.0821188567621002e-06
+ 1.5062639284368363e-05 4.6325061146258863e-06
+ 1.5062647863834995e-05 5.2171053875545835e-06
+ 1.506265818077025e-05 5.965211217502911e-06
+ 1.5062668497705506e-05 6.7623492313414161e-06
+ 1.5062678814640761e-05 7.6082590651614992e-06
+ 1.5062689131576017e-05 8.5026660760363497e-06
+ 1.5062699448511272e-05 9.4452814742207388e-06
+ 1.5062709765446527e-05 1.0435802462230257e-05
+ 1.5062720082381783e-05 1.147391238070454e-05
+ 1.5062730399317038e-05 1.25592808609545e-05
+ 1.5062742902012257e-05 1.393744004677843e-05
+ 1.5062755404707478e-05 1.538385928477854e-05
+ 1.5062767907402697e-05 1.6897871760843825e-05
+ 1.5062780410097916e-05 1.8478782715895571e-05
+ 1.5062792912793135e-05 2.0125869935940648e-05
+ 1.5062805415488354e-05 2.1838384260846487e-05
+ 1.5062817918183575e-05 2.3615550111329756e-05
+ 1.5062830420878794e-05 2.5456566033633845e-05
+ 1.5062845592253874e-05 2.7775100207116592e-05
+ 1.5062860763628954e-05 3.0184906039223483e-05
+ 1.5062875935004033e-05 3.2684405463249104e-05
+ 1.5062891106379113e-05 3.5271969973378807e-05
+ 1.5062906277754193e-05 3.7945922288216153e-05
+ 1.5062921449129273e-05 4.0704538058428326e-05
+ 1.5062936620504353e-05 4.3546047616054653e-05
+ 1.506295486051956e-05 4.7069469432613542e-05
+ 1.5062973100534768e-05 5.0706855826657106e-05
+ 1.5062991340549974e-05 5.4454893918205257e-05
+ 1.5063009580565182e-05 5.8310193146384224e-05
+ 1.506302782058039e-05 6.2269290123695639e-05
+ 1.5063046060595596e-05 6.6328653564053143e-05
+ 1.5063068199865846e-05 7.1385338233594827e-05
+ 1.5063090339136094e-05 7.6577901326810804e-05
+ 1.5063112478406342e-05 8.189969012601315e-05
+ 1.5063134617676592e-05 8.7343953274172687e-05
+ 1.5063161293011317e-05 9.4056657818521804e-05
+ 1.5063187873095807e-05 0.00010090035482762358
+ 1.5063214453180296e-05 0.00010788664307091889
+ 1.5063248688484341e-05 0.00011707548567577072
+ 1.5063282923788384e-05 0.00012645461865043843
+ 1.5063315356127047e-05 0.00013549167951766453
+ 1.5063347788465712e-05 0.00014465398332574899
+ 1.5063380220804375e-05 0.00015391958689944246
+ 1.5063412653143038e-05 0.00016326679416820027
+ 1.5063445085481701e-05 0.00017267423453976973
+ 1.5063477517820364e-05 0.00018212093762926101
+ 1.5063509950159029e-05 0.00019158640400330904
+ 1.5063542382497692e-05 0.00020105067163597072
+ 1.5063569584998146e-05 0.00020897371829601134
+ 1.50635967874986e-05 0.00021687121736840308
+ 1.5063623989999053e-05 0.0002247324443841368
+ 1.5063651192499507e-05 0.00023254704172942061
+ 1.506367839499996e-05 0.00024030503688061725
+ 1.5063705597500414e-05 0.00024799685880477063
+ 1.5063732800000867e-05 0.00025561335251051022
+ 1.5063760002501321e-05 0.00026314579174345146
+ 1.5063787205001774e-05 0.00027058588982929906
+ 1.5063814407502228e-05 0.00027792580867665878
+ 1.5063841610002681e-05 0.0002851581659600263
+ 1.5063868812503135e-05 0.00029227604051150784
+ 1.5063896015003588e-05 0.00029927297595749906
+ 1.5063923217504042e-05 0.00030614298264376868
+ 1.5063950420004495e-05 0.00031288053789913813
+ 1.5063977622504949e-05 0.00031948058469418605
+ 1.5064004825005403e-05 0.00032593852875712024
+ 1.5064032027505856e-05 0.00033225023421413059
+ 1.506405923000631e-05 0.00033841201782615327
+ 1.5064086432506763e-05 0.0003444206418985982
+ 1.5064115300883499e-05 0.00035062659892727544
+ 1.5064144169260233e-05 0.0003566540934654631
+ 1.5064173037636967e-05 0.00036250083298786399
+ 1.5064201906013703e-05 0.00036816503744223664
+ 1.5064230774390439e-05 0.00037364542226806104
+ 1.5064259642767173e-05 0.00037894118026981165
+ 1.5064288511143907e-05 0.00038405196247931109
+ 1.5064317379520643e-05 0.000388977858140999
+ 1.5064346247897379e-05 0.00039371937395252178
+ 1.5064381135166683e-05 0.0003992047348763101
+ 1.5064416022435987e-05 0.00040442447430172904
+ 1.5064449985506051e-05 0.00040925368585940502
+ 1.5064483948576112e-05 0.00041383750344981278
+ 1.5064517911646177e-05 0.00041817993390062743
+ 1.5064551874716238e-05 0.00042228549548244641
+ 1.5064585837786302e-05 0.00042615916749456922
+ 1.5064627381082817e-05 0.0004305900119691504
+ 1.5064668924379333e-05 0.00043469258490726371
+ 1.5064710467675849e-05 0.0004384781612780042
+ 1.5064752010972364e-05 0.00044195857402361564
+ 1.5064802322523098e-05 0.00044578261210212054
+ 1.5064853125173635e-05 0.00044923093231022854
+ 1.5064903927824171e-05 0.00045228765276156626
+ 1.5064971607266246e-05 0.00045579239535176001
+ 1.5065039286708322e-05 0.00045870005395461338
+ 1.5065091919396566e-05 0.00046058369469111949
+ 1.5065144552084811e-05 0.00046216451732223918
+ 1.5065197184773056e-05 0.00046346681282214352
+ 1.5065249817461301e-05 0.00046451393123718372
+ 1.5065297809929104e-05 0.00046526519657479943
+ 1.5065345802396906e-05 0.00046583893527304737
+ 1.5065393794864709e-05 0.00046625041073407677
+ 1.5065441787332512e-05 0.00046651403875466578
+ 1.5065489779800313e-05 0.0004666433740508164
+ 1.5065537261554863e-05 0.00046665162291553914
+ 1.5065584743309412e-05 0.000466552308242554
+ 1.5065632225063962e-05 0.00046635608374731292
+ 1.5065679706818511e-05 0.00046607281339991539
+ 1.5065727188573059e-05 0.00046571159614456351
+ 1.5065774670327608e-05 0.00046528079492301239
+ 1.5065824358583365e-05 0.00046476378468933915
+ 1.5065874046839123e-05 0.00046418694952370777
+ 1.5065923735094879e-05 0.00046355752837163748
+ 1.5065973423350635e-05 0.00046288205221083837
+ 1.5066023111606392e-05 0.00046216639229460844
+ 1.5066072799862148e-05 0.00046141580830294233
+ 1.5066127951386075e-05 0.00046054748419045071
+ 1.5066183102910002e-05 0.00045964758393211987
+ 1.5066238254433927e-05 0.00045872107390199996
+ 1.5066293405957853e-05 0.00045777228079549998
+ 1.506634855748178e-05 0.00045680495887963081
+ 1.5066411640520538e-05 0.000455679953428722
+ 1.5066474723559299e-05 0.00045453907391423655
+ 1.5066537806598058e-05 0.0004533857886546739
+ 1.5066600889636816e-05 0.00045222299034028662
+ 1.5066674140146426e-05 0.00045086399130210022
+ 1.5066747390656035e-05 0.00044949844535668453
+ 1.5066820641165644e-05 0.00044812878579885432
+ 1.5066905619421584e-05 0.00044653719761490697
+ 1.5066990597677523e-05 0.0004449449586312652
+ 1.5067093836844785e-05 0.00044301214871122791
+ 1.5067198171769413e-05 0.00044106269601017851
+ 1.5067302506694043e-05 0.00043911870626636078
+ 1.5067426664469163e-05 0.00043681393387383496
+ 1.5067550822244285e-05 0.00043451951813961668
+ 1.5067705800806533e-05 0.00043167106196547318
+ 1.5067884937131787e-05 0.00042840086834201771
+ 1.5068098556602389e-05 0.00042453293757745131
+ 1.5068364485722952e-05 0.00041976628303681877
+ 1.5068717982712204e-05 0.00041351261779238365
+ 1.5069242097564144e-05 0.00040441158298440465
+ 1.5070136340120474e-05 0.00038934346113524376
+ 1.5072132807185035e-05 0.00035769765454050228
+ 1.5073988816858016e-05 0.00033058981538904275
+ 1.507642166844308e-05 0.00029814348467284587
+ 1.5078854520028143e-05 0.00026888165874455468
+ 1.5081287371613207e-05 0.00024249178888257299
+ 1.508372022319827e-05 0.00021869200206866874
+ 1.5086153074783334e-05 0.00019722808975099272
+ 1.5088585926368396e-05 0.00017787079297825666
+ 1.5091018777953461e-05 0.00016041335425741158
+ 1.5093451629538523e-05 0.0001446693086575522
+ 1.5095767705239779e-05 0.00013111903917235234
+ 1.5098819440406719e-05 0.00011518312547724692
+ 1.5101871175573658e-05 0.00010118403045864018
+ 1.5104922910740596e-05 8.8886357108097517e-05
+ 1.5107974645907536e-05 7.8083318131395906e-05
+ 1.5111026381074474e-05 6.8593258842393536e-05
+ 1.5114078116241413e-05 6.025660181923537e-05
+ 1.51177736187736e-05 5.1505809187250614e-05
+ 1.512113428861091e-05 4.4656271026532631e-05
+ 1.512449495844822e-05 3.8717628008379948e-05
+ 1.5128620731690278e-05 3.2495702272495222e-05
+ 1.5132746504932338e-05 2.7273646663031209e-05
+ 1.5136872278174396e-05 2.2890780980831938e-05
+ 1.5140998051416456e-05 1.9212246512347876e-05
+ 1.5145123824658514e-05 1.6124856494297113e-05
+ 1.5150251138437097e-05 1.2970141364146993e-05
+ 1.5155378452215678e-05 1.0432633172092827e-05
+ 1.5160505765994261e-05 8.3915781182774641e-06
+ 1.5165633079772843e-05 6.7498471833962207e-06
+ 1.5171995979825151e-05 5.1518189724579756e-06
+ 1.517835887987746e-05 3.9321378049054371e-06
+ 1.5184721779929769e-05 3.0012267671564931e-06
+ 1.519249725625451e-05 2.15737185496337e-06
+ 1.5200272732579251e-05 1.5508026051292012e-06
+ 1.5208048208903992e-05 1.1147960586695601e-06
+ 1.5217983441936068e-05 7.3118840550782522e-07
+ 1.5227918674968143e-05 4.7961075194826108e-07
+ 1.5240125706218143e-05 2.8571159964289929e-07
+ 1.5252332737468142e-05 1.7024209705967684e-07
+ 1.526453976871814e-05 1.0147848625806179e-07
+ 1.5276746799968142e-05 6.0528851952355526e-08
+ 1.5288953831218141e-05 3.6142806128821739e-08
+ 1.5301160862468143e-05 2.1620593980565466e-08
+ 1.5313367893718142e-05 1.2972424953734794e-08
+ 1.532557492496814e-05 7.8223266739669589e-09
+ 1.5337781956218142e-05 4.7553755500354248e-09
+ 1.5349988987468141e-05 2.9289656540459339e-09
+ 1.5362196018718143e-05 1.8413143839828223e-09
+ 1.5374403049968142e-05 1.1936037658401295e-09
+ 1.538661008121814e-05 8.078836241498485e-10
+ 1.5398817112468142e-05 5.7818218790680653e-10
+ 1.5411024143718141e-05 4.4139192644487092e-10
+ 1.542323117496814e-05 3.5993152647751398e-10
+ 1.5435438206218142e-05 3.1142080027758294e-10
+ 1.5447645237468141e-05 2.8253202431124535e-10
+ 1.5459852268718139e-05 2.653283707170538e-10
+ 1.5472059299968141e-05 2.5508336753526945e-10
+ 1.548426633121814e-05 2.4898233649178344e-10
+ 1.5496473362468142e-05 2.4534909287155193e-10
+ 1.5508680393718141e-05 2.4318544696123555e-10
+ 1.5520887424968139e-05 2.4189696683490067e-10
+ 1.5533094456218141e-05 2.411296605642883e-10
+ 1.554530148746814e-05 2.406727199550333e-10
+ 1.5557508518718142e-05 2.4040060549918595e-10
+ 1.5569715549968141e-05 2.4023855751768804e-10
+ 1.5581922581218139e-05 2.4014205601586099e-10
+ 1.5594129612468141e-05 2.4008458822552009e-10
+ 1.560633664371814e-05 2.4005036536744095e-10
+ 1.5618543674968139e-05 2.4002998505548136e-10
+ 1.5630750706218141e-05 2.4001784836154639e-10
+ 1.5642957737468139e-05 2.4001062082534474e-10
+ 1.5655164768718138e-05 2.4000631674323626e-10
+ 1.566737179996814e-05 2.4000375361391963e-10
+ 1.5679578831218139e-05 2.4000222718017004e-10
+ 1.5691785862468141e-05 2.4000131819356677e-10
+ 1.5703992893718139e-05 2.4000077702242996e-10
+ 1.5716199924968138e-05 2.4000045459933931e-10
+ 1.572840695621814e-05 2.4000026257884156e-10
+ 1.5740613987468139e-05 2.4000014832025053e-10
+ 1.5752821018718141e-05 2.4000008023582484e-10
+ 1.5765028049968139e-05 2.4000003966625581e-10
+ 1.5777235081218138e-05 2.400000155533385e-10
+ 1.578944211246814e-05 2.4000000121814107e-10
+ 1.5801649143718139e-05 2.3999999261673205e-10
+ 1.5813856174968137e-05 2.3999998758456908e-10
+ 1.5826063206218139e-05 2.3999998453222656e-10
+ 1.5838270237468138e-05 2.3999998265390494e-10
+ 1.5850477268718137e-05 2.3999998161732485e-10
+ 1.5862684299968139e-05 2.3999998104358188e-10
+ 1.5874891331218137e-05 2.3999998057389865e-10
+ 1.588709836246814e-05 2.3999998026292464e-10
+ 1.5899305393718138e-05 2.3999998019001177e-10
+ 1.5911512424968137e-05 2.3999998019899801e-10
+ 1.5923719456218139e-05 2.3999998020597388e-10
+ 1.5935926487468138e-05 2.3999998012855701e-10
+ 1.594813351871814e-05 2.3999998005534517e-10
+ 1.5960340549968138e-05 2.3999998008389102e-10
+ 1.5972547581218137e-05 2.3999998009224399e-10
+ 1.5984754612468139e-05 2.3999998012219294e-10
+ 1.5996961643718138e-05 2.3999998013282356e-10
+ 1.6009168674968136e-05 2.3999998009115475e-10
+ 1.6021375706218138e-05 2.3999998009706464e-10
+ 1.6033582737468137e-05 2.3999998010363494e-10
+ 1.6045789768718136e-05 2.3999998011314167e-10
+ 1.6057996799968138e-05 2.3999998013616955e-10
+ 1.6070203831218136e-05 2.3999998011363462e-10
+ 1.6082410862468138e-05 2.3999998009274014e-10
+ 1.6094617893718137e-05 2.399999801011231e-10
+ 1.6106824924968136e-05 2.399999800977465e-10
+ 1.6119031956218138e-05 2.3999998010717031e-10
+ 1.6131238987468136e-05 2.3999998026497155e-10
+ 1.6143446018718138e-05 2.3999998018940695e-10
+ 1.6155653049968137e-05 2.399999801489314e-10
+ 1.6167860081218136e-05 2.3999998016252337e-10
+ 1.6180067112468138e-05 2.3999998017736873e-10
+ 1.6192274143718136e-05 2.3999998008841631e-10
+ 1.6204481174968135e-05 2.399999801406156e-10
+ 1.6216688206218137e-05 2.3999998027111368e-10
+ 1.6228895237468136e-05 2.399999803096209e-10
+ 1.6241102268718134e-05 2.399999801745041e-10
+ 1.6253309299968136e-05 2.3999998014351678e-10
+ 1.6265516331218135e-05 2.399999802735929e-10
+ 1.6277723362468137e-05 2.3999998026179471e-10
+ 1.6289930393718136e-05 2.3999998016976751e-10
+ 1.6302137424968134e-05 2.3999998022820648e-10
+ 1.6314344456218137e-05 2.3999998018386391e-10
+ 1.6326551487468135e-05 2.3999998024457121e-10
+ 1.6338758518718137e-05 2.399999802712344e-10
+ 1.6350965549968136e-05 2.3999998016906244e-10
+ 1.6363172581218138e-05 2.399999802251944e-10
+ 1.6375379612468137e-05 2.3999998029674961e-10
+ 1.6387586643718139e-05 2.3999998024490881e-10
+ 1.6399793674968137e-05 2.3999998022841694e-10
+ 1.6412000706218139e-05 2.3999998027402318e-10
+ 1.6424207737468138e-05 2.3999998031284179e-10
+ 1.643641476871814e-05 2.3999998024592236e-10
+ 1.6448621799968139e-05 2.3999998028900653e-10
+ 1.6460828831218141e-05 2.3999998029018118e-10
+ 1.6473035862468139e-05 2.3999998020407995e-10
+ 1.6485242893718141e-05 2.3999998030027903e-10
+ 1.649744992496814e-05 2.3999998034659856e-10
+ 1.6509656956218142e-05 2.3999998035710371e-10
+ 1.6521863987468141e-05 2.3999998035781327e-10
+ 1.6534071018718143e-05 2.3999998028429372e-10
+ 1.6546278049968141e-05 2.3999998026462584e-10
+ 1.6558485081218144e-05 2.3999998034401652e-10
+ 1.6570692112468142e-05 2.3999998040748526e-10
+ 1.6582899143718144e-05 2.399999802904164e-10
+ 1.6595106174968143e-05 2.3999998026488739e-10
+ 1.6607313206218145e-05 2.399999803948264e-10
+ 1.6619520237468144e-05 2.399999803901337e-10
+ 1.6631727268718146e-05 2.3999998030809217e-10
+ 1.6643934299968144e-05 2.3999998036169063e-10
+ 1.6656141331218146e-05 2.3999998033495331e-10
+ 1.6668348362468145e-05 2.3999998039429674e-10
+ 1.6680555393718147e-05 2.3999998043834603e-10
+ 1.6692762424968146e-05 2.3999998042747548e-10
+ 1.6704969456218148e-05 2.3999998033813589e-10
+ 1.6717176487468146e-05 2.3999998042749197e-10
+ 1.6729383518718148e-05 2.3999998045576412e-10
+ 1.6741590549968147e-05 2.3999998040668088e-10
+ 1.6753797581218149e-05 2.3999998041015307e-10
+ 1.6766004612468148e-05 2.3999998038280188e-10
+ 1.677821164371815e-05 2.399999804963409e-10
+ 1.6790418674968148e-05 2.3999998050724164e-10
+ 1.6802625706218151e-05 2.3999998043757132e-10
+ 1.6814832737468149e-05 2.3999998042873677e-10
+ 1.6827039768718151e-05 2.3999998048062938e-10
+ 1.683924679996815e-05 2.3999998046244087e-10
+ 1.6851453831218152e-05 2.3999998047367506e-10
+ 1.6863660862468151e-05 2.3999998045481209e-10
+ 1.6875867893718153e-05 2.3999998043752122e-10
+ 1.6888074924968151e-05 2.3999998042446345e-10
+ 1.6900281956218153e-05 2.3999998041722252e-10
+ 1.6912488987468152e-05 2.3999998041674074e-10
+ 1.6924696018718154e-05 2.3999998042357827e-10
+ 1.6936903049968153e-05 2.3999998043806778e-10
+ 1.6949110081218155e-05 2.3999998047660411e-10
+ 1.6961317112468153e-05 2.3999998051655456e-10
+ 1.6973524143718155e-05 2.3999998052591767e-10
+ 1.6985731174968154e-05 2.3999998048427911e-10
+ 1.6997938206218156e-05 2.3999998054712477e-10
+ 1.7010145237468155e-05 2.3999998057013456e-10
+ 1.7022352268718157e-05 2.3999998051176627e-10
+ 1.7034559299968155e-05 2.3999998057450993e-10
+ 1.7046766331218158e-05 2.3999998053652084e-10
+ 1.7058973362468156e-05 2.3999998056705243e-10
+ 1.7071180393718158e-05 2.399999805326457e-10
+ 1.7083387424968157e-05 2.399999805718764e-10
+ 1.7095594456218159e-05 2.3999998054921403e-10
+ 1.7107801487468158e-05 2.3999998061819825e-10
+ 1.712000851871816e-05 2.399999805688973e-10
+ 1.7132215549968158e-05 2.3999998054792621e-10
+ 1.714442258121816e-05 2.39999980627754e-10
+ 1.7156629612468159e-05 2.3999998059474422e-10
+ 1.7168836643718161e-05 2.399999805933057e-10
+ 1.718104367496816e-05 2.3999998057922352e-10
+ 1.7193250706218162e-05 2.3999998056088616e-10
+ 1.720545773746816e-05 2.3999998058786213e-10
+ 1.7217664768718162e-05 2.399999806005213e-10
+ 1.7229871799968161e-05 2.3999998060792622e-10
+ 1.7242078831218163e-05 2.3999998061547279e-10
+ 1.7254285862468162e-05 2.3999998062637359e-10
+ 1.7266492893718164e-05 2.3999998064254068e-10
+ 1.7278699924968162e-05 2.399999806651119e-10
+ 1.7290906956218165e-05 2.3999998065019003e-10
+ 1.7303113987468163e-05 2.3999998066078063e-10
+ 1.7315321018718165e-05 2.399999807158811e-10
+ 1.7327528049968164e-05 2.3999998065933043e-10
+ 1.7339735081218166e-05 2.3999998069949765e-10
+ 1.7351942112468165e-05 2.3999998071137632e-10
+ 1.7364149143718167e-05 2.3999998066492584e-10
+ 1.7376356174968165e-05 2.3999998067631891e-10
+ 1.7388563206218167e-05 2.3999998068067386e-10
+ 1.7400770237468166e-05 2.3999998072884115e-10
+ 1.7412977268718168e-05 2.3999998071703879e-10
+ 1.7425184299968167e-05 2.399999807620995e-10
+ 1.7437391331218169e-05 2.3999998071038665e-10
+ 1.7449598362468167e-05 2.3999998068359319e-10
+ 1.7461805393718169e-05 2.3999998073934671e-10
+ 1.7474012424968168e-05 2.3999998074833904e-10
+ 1.748621945621817e-05 2.3999998072288318e-10
+ 1.7498426487468169e-05 2.3999998078919143e-10
+ 1.7510633518718171e-05 2.3999998076965073e-10
+ 1.7522840549968169e-05 2.399999807468099e-10
+ 1.7535047581218171e-05 2.3999998076982682e-10
+ 1.754725461246817e-05 2.3999998077882701e-10
+ 1.7559461643718172e-05 2.3999998078272732e-10
+ 1.7571668674968171e-05 2.3999998077698307e-10
+ 1.7583875706218173e-05 2.3999998078844893e-10
+ 1.7596082737468172e-05 2.3999998080355428e-10
+ 1.7608289768718174e-05 2.3999998082407074e-10
+ 1.7620496799968172e-05 2.3999998085105249e-10
+ 1.7632703831218174e-05 2.3999998076975625e-10
+ 1.7644910862468173e-05 2.399999808033618e-10
+ 1.7657117893718175e-05 2.3999998080328762e-10
+ 1.7669324924968174e-05 2.3999998084082399e-10
+ 1.7681531956218176e-05 2.3999998077877215e-10
+ 1.7693738987468174e-05 2.3999998083679345e-10
+ 1.7705946018718176e-05 2.3999998087406507e-10
+ 1.7718153049968175e-05 2.3999998083776306e-10
+ 1.7730360081218177e-05 2.3999998086990843e-10
+ 1.7742567112468176e-05 2.3999998083702247e-10
+ 1.7754774143718178e-05 2.399999808776692e-10
+ 1.7766981174968176e-05 2.3999998085631119e-10
+ 1.7779188206218178e-05 2.3999998083949021e-10
+ 1.7791395237468177e-05 2.3999929577393646e-10
+ 1.7803602268718179e-05 2.3999721430085655e-10
+ 1.7815809299968178e-05 2.3999541801853927e-10
+ 1.782801633121818e-05 2.3999352441667849e-10
+ 1.7840223362468179e-05 2.3998998231508299e-10
+ 1.7852430393718181e-05 2.3998269751518182e-10
+ 1.7864637424968179e-05 2.3996731785187146e-10
+ 1.7870740940593179e-05 2.3994983464395233e-10
+ 1.7876844456218181e-05 2.3990674100743305e-10
+ 1.7879896214030681e-05 2.3985615585153402e-10
+ 1.7882947971843181e-05 2.3973456609508262e-10
+ 1.788447385074943e-05 2.3959023649420816e-10
+ 1.788599972965568e-05 2.3924487360909957e-10
+ 1.7886991106889184e-05 2.3866252493064795e-10
+ 1.7887269733896243e-05 2.3836567845599657e-10
+ 1.7887548360903299e-05 2.3795958755937176e-10
+ 1.7888098835627971e-05 2.3707317678626589e-10
+ 1.7890875273912437e-05 2.3289947932096134e-10
+ 1.7903082305162436e-05 2.1857108082062022e-10
+ 1.7915289336412434e-05 2.0744394567167327e-10
+ 1.7927496367662436e-05 1.9657101424192844e-10
+ 1.7939703398912438e-05 1.8444183633608339e-10
+ 1.7951910430162437e-05 1.7048236032410772e-10
+ 1.7964117461412436e-05 1.5473832156939622e-10
+ 1.7976324492662438e-05 1.376643966131987e-10
+ 1.798853152391244e-05 1.1997405552563603e-10
+ 1.8000738555162439e-05 1.0252468847149855e-10
+ 1.8012945586412437e-05 8.622433036431135e-11
+ 1.8025152617662439e-05 7.1953269034585456e-11
+ 1.8037359648912441e-05 6.0497851486217764e-11
+ 1.804956668016244e-05 5.2496010132610782e-11
+ 1.8061773711412439e-05 4.8395088933560857e-11
+ 1.8073980742662441e-05 4.8422873289603413e-11
+ 1.8086187773912443e-05 5.2572582289997926e-11
+ 1.8098394805162441e-05 6.0602144636946106e-11
+ 1.811060183641244e-05 7.2047475992215135e-11
+ 1.8122808867662442e-05 8.6248800170538565e-11
+ 1.8135015898912444e-05 1.0238838404643464e-10
+ 1.8147222930162443e-05 1.19537446121802e-10
+ 1.8159429961412441e-05 1.367094991032434e-10
+ 1.8171636992662443e-05 1.5291703382970249e-10
+ 1.8183844023912445e-05 1.6722827017382802e-10
+ 1.8186895781724945e-05 1.7041028620342427e-10
+ 1.8187048369615568e-05 1.7056469761267313e-10
+ 1.8187429839342133e-05 1.7094872387604414e-10
+ 1.8187467986314788e-05 1.7098696858623529e-10
+ 1.818747561570932e-05 1.7099461407315297e-10
+ 1.8187490874498381e-05 1.7100990159048815e-10
+ 1.8187496978014006e-05 1.7101601530675094e-10
+ 1.8187499419420258e-05 1.7101846058671687e-10
+ 1.8187499604455785e-05 1.7101864591102341e-10
+ 1.8187499974526841e-05 1.710190165576025e-10
+ 1.8187500714668947e-05 2.9362295535076986e-10
+ 1.8187501454811059e-05 6.7955376462053112e-10
+ 1.8187508856232149e-05 1.9019685483973129e-08
+ 1.8187516257653239e-05 6.3680162617685321e-08
+ 1.8187523659074328e-05 1.3464578979540883e-07
+ 1.8187531060495418e-05 2.3189729697639808e-07
+ 1.8187538461916508e-05 3.5541134357275011e-07
+ 1.8187547512355688e-05 5.4209487018455778e-07
+ 1.8187556562794868e-05 7.6794744751962639e-07
+ 1.8187565613234049e-05 1.032901665904789e-06
+ 1.8187574663673229e-05 1.3368810846168448e-06
+ 1.8187583714112412e-05 1.6798002590529673e-06
+ 1.8187595044533511e-05 2.1638522289015684e-06
+ 1.8187606374954609e-05 2.7085809274094572e-06
+ 1.8187617705375708e-05 3.3137595140903088e-06
+ 1.8187629035796806e-05 3.9791394372703589e-06
+ 1.8187643214653361e-05 4.8961848891924115e-06
+ 1.8187657393509916e-05 5.9065041934527361e-06
+ 1.8187671572366471e-05 7.0094688242501652e-06
+ 1.8187689032396935e-05 8.4939484121898285e-06
+ 1.81877064924274e-05 1.011650368403691e-05
+ 1.8187723952457861e-05 1.187564441966631e-05
+ 1.8187746268477831e-05 1.4320324258348367e-05
+ 1.8187768584497801e-05 1.6981891243476683e-05
+ 1.818779090051777e-05 1.9856448881756975e-05
+ 1.818781909021724e-05 2.3785542948120637e-05
+ 1.8187847279916712e-05 2.8038794641957824e-05
+ 1.8187875469616182e-05 3.2606525910010655e-05
+ 1.8187903659315651e-05 3.7478440563006991e-05
+ 1.818793184901512e-05 4.2643660624918842e-05
+ 1.8187960038714589e-05 4.809076449946518e-05
+ 1.8187988228414062e-05 5.3807826764352856e-05
+ 1.8188019414106474e-05 6.0432058501488789e-05
+ 1.8188050599798883e-05 6.7354141141263776e-05
+ 1.8188081785491295e-05 7.4556149339010216e-05
+ 1.8188112971183707e-05 8.2019674226669682e-05
+ 1.8188150418414336e-05 9.1300740447793598e-05
+ 1.8188187865644966e-05 0.00010089852928503813
+ 1.8188225312875598e-05 0.00011077933330704341
+ 1.8188270844195808e-05 0.00012312530862772575
+ 1.8188316375516022e-05 0.00013577798574481139
+ 1.8188361906836235e-05 0.00014867616552750304
+ 1.8188407438156445e-05 0.00016175929991125412
+ 1.818844108402811e-05 0.00017151113091571656
+ 1.8188474729899776e-05 0.00018130797963939794
+ 1.8188508375771441e-05 0.00019112690048319055
+ 1.8188542021643107e-05 0.000200945563836072
+ 1.8188575667514772e-05 0.0002107423308290232
+ 1.8188609313386438e-05 0.00022049632214156449
+ 1.8188642959258103e-05 0.00023018748061678874
+ 1.8188676605129769e-05 0.00023979662749408118
+ 1.8188710251001434e-05 0.0002493055121224335
+ 1.8188736870668147e-05 0.00025674620625396695
+ 1.8188763490334857e-05 0.00026410519322842072
+ 1.8188790110001567e-05 0.00027137476557784006
+ 1.818881672966828e-05 0.00027854762813939171
+ 1.818884334933499e-05 0.00028561690431054267
+ 1.81888699690017e-05 0.0002925761407342706
+ 1.818889658866841e-05 0.0002994193104460534
+ 1.818892320833512e-05 0.00030614081452042582
+ 1.8188949828001833e-05 0.00031273548226053464
+ 1.8188976447668543e-05 0.00031919856997935221
+ 1.8189003067335253e-05 0.00032552575842600295
+ 1.8189029687001966e-05 0.00033171314891500655
+ 1.8189056306668676e-05 0.00033775725822013397
+ 1.8189082926335386e-05 0.00034365501229800138
+ 1.8189109546002096e-05 0.00034940373890948994
+ 1.8189136165668806e-05 0.00035500115920957621
+ 1.8189162785335519e-05 0.00036044537837818884
+ 1.8189189405002229e-05 0.00036573487536628151
+ 1.8189216024668939e-05 0.00037086849183281574
+ 1.8189239404935229e-05 0.00037524816041470616
+ 1.8189262785201516e-05 0.00037950661982143294
+ 1.8189286165467805e-05 0.00038364373347733212
+ 1.8189309545734092e-05 0.00038765955240256639
+ 1.8189332926000382e-05 0.00039155430797307712
+ 1.8189356306266668e-05 0.00039532840450424615
+ 1.8189379686532958e-05 0.00039898241168751826
+ 1.8189403066799245e-05 0.00040251705690861332
+ 1.8189426447065535e-05 0.00040593321747524688
+ 1.8189449827331821e-05 0.0004092319127814815
+ 1.8189473207598111e-05 0.00041241429643495774
+ 1.8189496587864398e-05 0.00041548164837231091
+ 1.8189519968130688e-05 0.00041843536698707185
+ 1.8189543348396974e-05 0.00042127696129328835
+ 1.8189566728663264e-05 0.00042400804314699181
+ 1.818959010892955e-05 0.00042663031954648096
+ 1.818961348919584e-05 0.00042914558503120656
+ 1.8189636869462127e-05 0.00043155571419782471
+ 1.8189660249728417e-05 0.00043386265435075173
+ 1.8189683629994703e-05 0.0004360684183033
+ 1.8189707010260993e-05 0.00043817507734421687
+ 1.8189735591237517e-05 0.00044061881915944171
+ 1.8189764172214041e-05 0.00044292160557832261
+ 1.8189792753190565e-05 0.00044508748731897325
+ 1.8189821334167089e-05 0.0004471205811035718
+ 1.8189849915143613e-05 0.00044902505354874717
+ 1.8189886199806211e-05 0.00045126415767136695
+ 1.8189925453373381e-05 0.00045347065125915753
+ 1.8189946977215263e-05 0.00045458914938144757
+ 1.8189973696714699e-05 0.00045589098737442259
+ 1.8190000416214135e-05 0.00045710004038524538
+ 1.8190027135713571e-05 0.00045821970861944291
+ 1.8190053855213007e-05 0.00045925335947318648
+ 1.8190080574712443e-05 0.00046020432082601948
+ 1.8190107294211879e-05 0.00046107587487371744
+ 1.8190134013711316e-05 0.00046187125249194449
+ 1.8190160733210752e-05 0.00046259362811953432
+ 1.8190187452710188e-05 0.00046324611514856153
+ 1.8190214172209624e-05 0.00046383176180687778
+ 1.819024089170906e-05 0.00046435354751746608
+ 1.8190262548859613e-05 0.00046473161709406521
+ 1.8190284206010163e-05 0.00046507115570231151
+ 1.8190305863160713e-05 0.00046537364255429416
+ 1.8190327520311267e-05 0.00046564052306956875
+ 1.819034917746182e-05 0.00046587320827894959
+ 1.819037083461237e-05 0.00046607307433484731
+ 1.819039249176292e-05 0.00046624146212347479
+ 1.8190414148913474e-05 0.00046637967697419719
+ 1.8190435806064027e-05 0.00046648898846127722
+ 1.8190457463214577e-05 0.00046657063029325929
+ 1.8190479120365127e-05 0.0004666258002852115
+ 1.8190496765399602e-05 0.00046665198683365781
+ 1.8190514410434077e-05 0.00046666198405394353
+ 1.8190532055468551e-05 0.00046665638716889121
+ 1.8190549700503026e-05 0.00046663577581361698
+ 1.8190567345537497e-05 0.00046660071413966874
+ 1.8190584990571972e-05 0.00046655175093608377
+ 1.8190602635606446e-05 0.00046648941976632619
+ 1.8190620280640917e-05 0.00046641423912008399
+ 1.8190637925675392e-05 0.00046632671257892689
+ 1.8190655570709867e-05 0.00046622732899484812
+ 1.8190673215744341e-05 0.00046611656268073646
+ 1.8190690860778816e-05 0.00046599487361184948
+ 1.8190708505813287e-05 0.00046586270763738396
+ 1.8190726150847762e-05 0.00046572049670126538
+ 1.8190743795882236e-05 0.00046556865907130521
+ 1.8190761440916708e-05 0.00046540759957590188
+ 1.8190779085951182e-05 0.00046523770984748908
+ 1.8190796730985657e-05 0.00046505936857196291
+ 1.8190814376020131e-05 0.00046487294174334804
+ 1.8190832021054606e-05 0.00046467878292299136
+ 1.8190849666089077e-05 0.00046447723350260048
+ 1.8190867311123552e-05 0.00046426862297047311
+ 1.8190884956158027e-05 0.00046405326918029163
+ 1.8190902601192498e-05 0.00046383147862188659
+ 1.8190920246226972e-05 0.0004636035466933999
+ 1.8190937891261447e-05 0.00046336975797430831
+ 1.8190955536295922e-05 0.00046313038649879376
+ 1.8190973181330396e-05 0.00046288569602897633
+ 1.8190990826364867e-05 0.00046263594032755121
+ 1.8191008471399342e-05 0.00046238136342939871
+ 1.8191026116433817e-05 0.00046212219991176166
+ 1.8191043761468288e-05 0.00046185867516261082
+ 1.8191061406502763e-05 0.00046159100564684353
+ 1.8191079051537237e-05 0.00046131939916998468
+ 1.8191096696571712e-05 0.00046104405513908457
+ 1.8191114341606186e-05 0.00046076516482052872
+ 1.8191131986640658e-05 0.00046048291159450004
+ 1.8191149631675132e-05 0.00046019747120585279
+ 1.8191167276709607e-05 0.00045990901201118061
+ 1.8191184921744078e-05 0.00045961769522188066
+ 1.8191202566778553e-05 0.00045932367514303494
+ 1.8191220211813027e-05 0.00045902709940794936
+ 1.8191237856847502e-05 0.00045872810920820898
+ 1.8191255501881976e-05 0.00045842683951912496
+ 1.8191273146916448e-05 0.00045812341932046545
+ 1.8191290791950922e-05 0.00045781797181237863
+ 1.8191308436985397e-05 0.00045751061462643097
+ 1.8191326082019868e-05 0.00045720146003169808
+ 1.8191343727054343e-05 0.00045689061513585962
+ 1.8191361372088817e-05 0.00045657818208126165
+ 1.8191379017123292e-05 0.00045626425823592343
+ 1.8191396662157767e-05 0.0004559489363794755
+ 1.8191414307192238e-05 0.0004556323048840281
+ 1.8191431952226712e-05 0.00045531444788997848
+ 1.8191449597261187e-05 0.00045499544547677518
+ 1.8191467242295658e-05 0.00045467537382866608
+ 1.8191484887330133e-05 0.00045435430539546583
+ 1.8191502532364608e-05 0.00045403230904838535
+ 1.8191520177399082e-05 0.00045370945023097327
+ 1.8191537822433557e-05 0.00045338579110522598
+ 1.8191555467468028e-05 0.00045306139069292836
+ 1.8191573112502503e-05 0.00045273630501229328
+ 1.8191590757536977e-05 0.00045241058720997258
+ 1.8191608402571448e-05 0.00045208428768851668
+ 1.8191626047605923e-05 0.00045175745422936376
+ 1.8191643692640398e-05 0.00045143013211144381
+ 1.8191661337674872e-05 0.00045110236422548483
+ 1.8191682620107577e-05 0.00045070649383213837
+ 1.8191702745281677e-05 0.00045033166770387813
+ 1.8191722870455781e-05 0.00044995642757493547
+ 1.8191742995629884e-05 0.00044958082330929242
+ 1.8191763120803984e-05 0.00044920490166811688
+ 1.8191783245978088e-05 0.00044882870648050557
+ 1.8191803371152191e-05 0.00044845227880637947
+ 1.8191823496326295e-05 0.00044807565709178331
+ 1.8191843621500398e-05 0.00044769887731683952
+ 1.8191863746674498e-05 0.00044732197313660687
+ 1.8191888110746127e-05 0.00044686556133260454
+ 1.8191912474817753e-05 0.00044640906499999366
+ 1.8191936838889382e-05 0.00044595253182312878
+ 1.8191961202961008e-05 0.00044549600565976083
+ 1.8191985567032637e-05 0.00044503952681690417
+ 1.8192009931104263e-05 0.00044458313230938829
+ 1.8192034295175892e-05 0.00044412685610195336
+ 1.8192058659247518e-05 0.00044367072933572632
+ 1.8192083023319147e-05 0.00044321478053989036
+ 1.8192107387390773e-05 0.00044275903582933563
+ 1.819213671968357e-05 0.00044221066197735565
+ 1.8192166051976363e-05 0.00044166265618977781
+ 1.8192195384269159e-05 0.00044111505229614979
+ 1.8192224716561953e-05 0.000440567880571222
+ 1.8192254048854749e-05 0.0004400211680723513
+ 1.8192283381147542e-05 0.0004394749389480193
+ 1.8192312713440339e-05 0.0004389292147195882
+ 1.8192342045733132e-05 0.00043838401453830063
+ 1.8192377848029196e-05 0.00043771929099924211
+ 1.8192412335454631e-05 0.00043707976746529866
+ 1.8192446822880062e-05 0.00043644103787377733
+ 1.8192481310305496e-05 0.00043580312030283216
+ 1.819251579773093e-05 0.00043516603032572377
+ 1.8192557828321208e-05 0.00043439073279079223
+ 1.8192599858911486e-05 0.00043361670459320404
+ 1.8192641889501768e-05 0.00043284396248195208
+ 1.8192683920092046e-05 0.00043207252012209858
+ 1.8192725950682324e-05 0.00043130238856505936
+ 1.8192777518503423e-05 0.00043035930871672526
+ 1.8192828186666481e-05 0.00042943462880424378
+ 1.819287885482954e-05 0.00042851188736760037
+ 1.8192929522992598e-05 0.00042759109050169295
+ 1.8192993215143463e-05 0.00042643637215815307
+ 1.8193056907294327e-05 0.0004252847370223043
+ 1.8193120599445191e-05 0.00042413618616643506
+ 1.8193198945610715e-05 0.00042272760989246018
+ 1.8193278657649689e-05 0.00042129925771114857
+ 1.8193358369688668e-05 0.00041987571829712041
+ 1.8193461292370763e-05 0.00041804477075287836
+ 1.8193569508909819e-05 0.00041612824858809757
+ 1.8193701914804437e-05 0.00041379527174881443
+ 1.8193847065030182e-05 0.00041125276249577136
+ 1.8194034315235683e-05 0.00040799587225246868
+ 1.8194255865010425e-05 0.00040417569543334638
+ 1.8194554034092505e-05 0.00039909077578923559
+ 1.8194998769870887e-05 0.00039162496079868337
+ 1.8195805003988993e-05 0.00037844492463713218
+ 1.8196711764368317e-05 0.00036415075183872955
+ 1.8197737475686441e-05 0.00034863113834200367
+ 1.8198801143402341e-05 0.00033323544260725887
+ 1.8199944764949548e-05 0.00031744009309453978
+ 1.820223164627891e-05 0.00028806442739914481
+ 1.8204182681216658e-05 0.00026516169925578173
+ 1.8206291228517249e-05 0.00024245284579639417
+ 1.820858146743616e-05 0.00021998507757767748
+ 1.8210926666850022e-05 0.00019913410083615226
+ 1.8213271866263886e-05 0.00018025945489984468
+ 1.821559053717963e-05 0.00016335772611693962
+ 1.821847456948428e-05 0.00014452917890563918
+ 1.822135860178893e-05 0.00012787080313841811
+ 1.8224242634093576e-05 0.00011313246567173927
+ 1.8227126666398226e-05 0.00010009286360866482
+ 1.8230010698702876e-05 8.8556201336288662e-05
+ 1.8232894731007526e-05 7.8349250567829904e-05
+ 1.8235778763312176e-05 6.9318749243295542e-05
+ 1.8239342797663593e-05 5.9583601550415324e-05
+ 1.8242906832015013e-05 5.12156620124964e-05
+ 1.8246470866366434e-05 4.4022919356413453e-05
+ 1.8250034900717851e-05 3.7840328450154061e-05
+ 1.8253598935069271e-05 3.2526023165760874e-05
+ 1.8257899961127361e-05 2.7096692323683933e-05
+ 1.8262200987185451e-05 2.2573641128908005e-05
+ 1.8266502013243541e-05 1.8805590756409222e-05
+ 1.8270803039301627e-05 1.5666514280396347e-05
+ 1.8275104065359717e-05 1.3051421554109079e-05
+ 1.8280502505986984e-05 1.0377818664489998e-05
+ 1.8285900946614247e-05 8.251909089995107e-06
+ 1.8291299387241515e-05 6.5614966739560858e-06
+ 1.8296697827868782e-05 5.2173688876777125e-06
+ 1.8303468247657469e-05 3.9138135354349389e-06
+ 1.8310238667446157e-05 2.9359531577328348e-06
+ 1.8317009087234845e-05 2.2024124497970242e-06
+ 1.8325385304343957e-05 1.5432541258101081e-06
+ 1.833376152145307e-05 1.081378721967762e-06
+ 1.8342137738562182e-05 7.5774041132707628e-07
+ 1.8353043385488655e-05 4.7689837631713853e-07
+ 1.836394903241513e-05 3.0015113649486665e-07
+ 1.8376156063665133e-05 1.7876217937191045e-07
+ 1.8388363094915131e-05 1.0647330757921957e-07
+ 1.840057012616513e-05 6.3424252544034479e-08
+ 1.8412777157415132e-05 3.7787934734000867e-08
+ 1.8424984188665134e-05 2.2521155841269887e-08
+ 1.8437191219915133e-05 1.3429588576020001e-08
+ 1.8449398251165131e-05 8.015449872567151e-09
+ 1.8461605282415133e-05 4.7912734917149069e-09
+ 1.8473812313665135e-05 2.871251600636248e-09
+ 1.8486019344915134e-05 1.7278727196949598e-09
+ 1.8498226376165133e-05 1.0469960699243559e-09
+ 1.8510433407415135e-05 6.4154623608527275e-10
+ 1.8522640438665137e-05 4.0011708092908531e-10
+ 1.8534847469915135e-05 2.563646256420896e-10
+ 1.8547054501165134e-05 1.7078006330613652e-10
+ 1.8559261532415136e-05 1.1983532309874618e-10
+ 1.8571468563665138e-05 8.9519095817165878e-11
+ 1.8583675594915137e-05 7.14874426319846e-11
+ 1.8595882626165135e-05 6.0771426293748156e-11
+ 1.8608089657415137e-05 5.4411972164600532e-11
+ 1.862029668866514e-05 5.0646908151112081e-11
+ 1.8632503719915138e-05 4.8426835103990855e-11
+ 1.8644710751165137e-05 4.7126820532761082e-11
+ 1.8656917782415139e-05 4.6374708016315066e-11
+ 1.8669124813665141e-05 4.594887297816922e-11
+ 1.868133184491514e-05 4.5717334758833713e-11
+ 1.8693538876165138e-05 4.5601496954841019e-11
+ 1.870574590741514e-05 4.5554554261028926e-11
+ 1.8717952938665142e-05 4.5548633436145208e-11
+ 1.8730159969915141e-05 4.5567135561437956e-11
+ 1.874236700116514e-05 4.5600175741221697e-11
+ 1.8750000000000002e-05 4.5624752229059989e-11
+ 1.876220703125e-05 4.5669966819297461e-11
+ 1.8774414062500002e-05 4.5718898557805248e-11
+ 1.8786621093750001e-05 4.5770037749483043e-11
+ 1.8798828125000003e-05 4.5822485350610839e-11
+ 1.8811035156250002e-05 4.5875705969269391e-11
+ 1.88232421875e-05 4.5929380773488921e-11
+ 1.8835449218750002e-05 4.5983319895906806e-11
+ 1.8847656250000001e-05 4.6037410269464089e-11
+ 1.8859863281250003e-05 4.6091584562801975e-11
+ 1.8872070312500002e-05 4.6145802680837535e-11
+ 1.8884277343750001e-05 4.6200040748086769e-11
+ 1.8896484375000003e-05 4.6254284548072891e-11
+ 1.8908691406250001e-05 4.6308525616398256e-11
+ 1.8920898437500003e-05 4.6362758914111761e-11
+ 1.8933105468750002e-05 4.641698144216514e-11
+ 1.8945312500000001e-05 4.6471191416301583e-11
+ 1.8957519531250003e-05 4.6525387775689795e-11
+ 1.8969726562500001e-05 4.6579569890308451e-11
+ 1.8981933593750003e-05 4.663373738668933e-11
+ 1.8994140625000002e-05 4.6687890044144897e-11
+ 1.9006347656250001e-05 4.6742027732970226e-11
+ 1.9018554687500003e-05 4.6796150377641402e-11
+ 1.9030761718750001e-05 4.6850257934899579e-11
+ 1.9042968750000003e-05 4.690435038069982e-11
+ 1.9055175781250002e-05 4.695842770243876e-11
+ 1.9067382812500001e-05 4.7012489894326265e-11
+ 1.9079589843750003e-05 4.7066536954629075e-11
+ 1.9091796875000001e-05 4.7120568884029375e-11
+ 1.910400390625e-05 4.7174585684647293e-11
+ 1.9116210937500002e-05 4.7228587359458799e-11
+ 1.9128417968750001e-05 4.728257391194907e-11
+ 1.9140625000000003e-05 4.7336545345906017e-11
+ 1.9152832031250001e-05 4.7390501665297362e-11
+ 1.91650390625e-05 4.7444442874197415e-11
+ 1.9177246093750002e-05 4.7498368976743532e-11
+ 1.9189453125000001e-05 4.7552279977110043e-11
+ 1.9201660156250003e-05 4.7606175879492929e-11
+ 1.9213867187500001e-05 4.76600566881005e-11
+ 1.922607421875e-05 4.771392240714795e-11
+ 1.9238281250000002e-05 4.7767773040854128e-11
+ 1.9250488281250001e-05 4.7821608593439534e-11
+ 1.9262695312500003e-05 4.7875429069125182e-11
+ 1.9274902343750002e-05 4.7929234472131972e-11
+ 1.9287109375e-05 4.7983024806680162e-11
+ 1.9299316406250002e-05 4.8036800076989225e-11
+ 1.9311523437500001e-05 4.8090560287277661e-11
+ 1.9323730468750003e-05 4.81443054417629e-11
+ 1.9335937500000002e-05 4.8198035544661283e-11
+ 1.934814453125e-05 4.8251750600188019e-11
+ 1.9360351562500002e-05 4.8305450612557161e-11
+ 1.9372558593750001e-05 4.835913558598157e-11
+ 1.9384765625000003e-05 4.8412805524672993e-11
+ 1.9396972656250002e-05 4.846646043284194e-11
+ 1.94091796875e-05 4.8520100314697792e-11
+ 1.9421386718750002e-05 4.8573725174448732e-11
+ 1.9433593750000001e-05 4.8627335016301782e-11
+ 1.9445800781250003e-05 4.8680929844462761e-11
+ 1.9458007812500002e-05 4.8734509663136332e-11
+ 1.9470214843750004e-05 4.8788074476525962e-11
+ 1.9482421875000002e-05 4.8841624288833967e-11
+ 1.9494628906250001e-05 4.8895159104261467e-11
+ 1.9506835937500003e-05 4.894867892700839e-11
+ 1.9519042968750002e-05 4.9002183761273549e-11
+ 1.9531250000000004e-05 4.905567361125451e-11
+ 1.9543457031250002e-05 4.9109148481147716e-11
+ 1.9555664062500001e-05 4.9162608375148381e-11
+ 1.9567871093750003e-05 4.9216053297450589e-11
+ 1.9580078125000002e-05 4.9269483252247235e-11
+ 1.9592285156250004e-05 4.932289824373005e-11
+ 1.9604492187500003e-05 4.9376298276089576e-11
+ 1.9616699218750001e-05 4.9429683353515166e-11
+ 1.9628906250000003e-05 4.9483053480195042e-11
+ 1.9641113281250002e-05 4.9536408660316226e-11
+ 1.9653320312500004e-05 4.9589748898064572e-11
+ 1.9665527343750003e-05 4.9643074197624777e-11
+ 1.9677734375000001e-05 4.9696384563180337e-11
+ 1.9689941406250003e-05 4.9749679998913594e-11
+ 1.9702148437500002e-05 4.980296050900572e-11
+ 1.9714355468750004e-05 4.9856226097636712e-11
+ 1.9726562500000003e-05 4.99094767689854e-11
+ 1.9738769531250001e-05 4.9962712527229435e-11
+ 1.9750976562500003e-05 5.0015933376545304e-11
+ 1.9763183593750002e-05 5.0069139321108297e-11
+ 1.9775390625000004e-05 5.0122330365092602e-11
+ 1.9787597656250003e-05 5.0175506512671175e-11
+ 1.9799804687500001e-05 5.0228667768015851e-11
+ 1.9812011718750003e-05 5.0281814135297241e-11
+ 1.9824218750000002e-05 5.0334945618684835e-11
+ 1.9836425781250001e-05 5.0388062222346936e-11
+ 1.9848632812500003e-05 5.0441163950450669e-11
+ 1.9860839843750001e-05 5.0494250807162017e-11
+ 1.9873046875e-05 5.0547322796645784e-11
+ 1.9885253906250002e-05 5.060037992306559e-11
+ 1.9897460937500001e-05 5.0653422190583924e-11
+ 1.9909667968750003e-05 5.0706449603362099e-11
+ 1.9921875000000001e-05 5.0759462165560252e-11
+ 1.993408203125e-05 5.0812459881337356e-11
+ 1.9946289062500002e-05 5.086544275485121e-11
+ 1.9958496093750001e-05 5.0918410790258479e-11
+ 1.9970703125000003e-05 5.0971363991714641e-11
+ 1.9982910156250001e-05 5.1024302363374004e-11
+ 1.99951171875e-05 5.1077225909389738e-11
+ 2.0007324218750002e-05 5.1130134633913832e-11
+ 2.0019531250000001e-05 5.1183028541097097e-11
+ 2.0031738281249999e-05 5.123590763508922e-11
+ 2.0043945312500002e-05 5.1288771920038706e-11
+ 2.005615234375e-05 5.1341621400092889e-11
+ 2.0068359374999999e-05 5.1394456079397949e-11
+ 2.0080566406250001e-05 5.1447275962098919e-11
+ 2.00927734375e-05 5.1500081052339658e-11
+ 2.0104980468750002e-05 5.1552871354262853e-11
+ 2.01171875e-05 5.1605646872010057e-11
+ 2.0129394531249999e-05 5.1658407609721638e-11
+ 2.0141601562500001e-05 5.171115357153682e-11
+ 2.015380859375e-05 5.1763884761593666e-11
+ 2.0166015625000002e-05 5.1816601184029079e-11
+ 2.017822265625e-05 5.1869302842978788e-11
+ 2.0190429687499999e-05 5.1921989742577379e-11
+ 2.0202636718750001e-05 5.1974661886958285e-11
+ 2.021484375e-05 5.2027319280253771e-11
+ 2.0227050781249998e-05 5.2079961926594946e-11
+ 2.02392578125e-05 5.2132589830111786e-11
+ 2.0251464843749999e-05 5.2185202994933079e-11
+ 2.0263671874999998e-05 5.2237801425186463e-11
+ 2.027587890625e-05 5.2290385124998426e-11
+ 2.0288085937499998e-05 5.2342954098494298e-11
+ 2.030029296875e-05 5.2395508349798247e-11
+ 2.0312499999999999e-05 5.2448047883033309e-11
+ 2.0324707031249998e-05 5.2500572702321331e-11
+ 2.03369140625e-05 5.2553082811783024e-11
+ 2.0349121093749998e-05 5.260557821553798e-11
+ 2.0361328125e-05 5.265805891770455e-11
+ 2.0373535156249999e-05 5.2710524922400013e-11
+ 2.0385742187499998e-05 5.2762976233740464e-11
+ 2.039794921875e-05 5.281541285584085e-11
+ 2.0410156249999998e-05 5.2867834792814952e-11
+ 2.0422363281249997e-05 5.2920242048775429e-11
+ 2.0434570312499999e-05 5.297263462783375e-11
+ 2.0446777343749998e-05 5.3025012534100265e-11
+ 2.0458984374999996e-05 5.3077375771684144e-11
+ 2.0471191406249999e-05 5.3129724344693429e-11
+ 2.0483398437499997e-05 5.3182058257235008e-11
+ 2.0495605468749999e-05 5.3234377513414598e-11
+ 2.0507812499999998e-05 5.3286682117336819e-11
+ 2.0520019531249997e-05 5.3338972073105086e-11
+ 2.0532226562499999e-05 5.339124738482168e-11
+ 2.0544433593749997e-05 5.3443508056587737e-11
+ 2.0556640624999999e-05 5.349575409250326e-11
+ 2.0568847656249998e-05 5.3547985496667078e-11
+ 2.0581054687499997e-05 5.3600202273176877e-11
+ 2.0593261718749999e-05 5.3652404426129203e-11
+ 2.0605468749999997e-05 5.3704591959619454e-11
+ 2.0617675781249996e-05 5.3756764877741888e-11
+ 2.0629882812499998e-05 5.3808923184589598e-11
+ 2.0642089843749997e-05 5.3861066884254534e-11
+ 2.0654296874999995e-05 5.3913195980827531e-11
+ 2.0666503906249997e-05 5.3965310478398236e-11
+ 2.0678710937499996e-05 5.4017410381055188e-11
+ 2.0690917968749998e-05 5.4069495692885746e-11
+ 2.0703124999999997e-05 5.4121566417976143e-11
+ 2.0715332031249995e-05 5.4173622560411455e-11
+ 2.0727539062499997e-05 5.4225664124275648e-11
+ 2.0739746093749996e-05 5.4277691113651499e-11
+ 2.0751953124999998e-05 5.4329703532620677e-11
+ 2.0764160156249997e-05 5.4381701385263697e-11
+ 2.0776367187499995e-05 5.4433684675659917e-11
+ 2.0788574218749997e-05 5.4485653407887576e-11
+ 2.0800781249999996e-05 5.4537607586023745e-11
+ 2.0812988281249995e-05 5.4589547214144361e-11
+ 2.0825195312499997e-05 5.4641472296324253e-11
+ 2.0837402343749995e-05 5.4693382836637059e-11
+ 2.0849609374999994e-05 5.4745278839155299e-11
+ 2.0861816406249996e-05 5.4797160307950356e-11
+ 2.0874023437499995e-05 5.4849027247092475e-11
+ 2.0886230468749997e-05 5.4900879660650734e-11
+ 2.0898437499999996e-05 5.4952717552693121e-11
+ 2.0910644531249994e-05 5.5004540927286431e-11
+ 2.0922851562499996e-05 5.5055228596414379e-11
+ 2.0935058593749995e-05 5.510627065877697e-11
+ 2.0947265624999997e-05 5.5158092921228189e-11
+ 2.0959472656249996e-05 5.5210849104087091e-11
+ 2.0971679687499994e-05 5.5264521350196526e-11
+ 2.0983886718749996e-05 5.5318219478297029e-11
+ 2.0989990234374996e-05 5.5343709041866146e-11
+ 2.0996093749999995e-05 5.5365175813779936e-11
+ 2.0999145507812495e-05 5.537183500008943e-11
+ 2.1002197265624994e-05 5.5371668509114686e-11
+ 2.1005249023437494e-05 5.5354771851498252e-11
+ 2.1006606790774089e-05 5.5334751403020664e-11
+ 2.1006998216660862e-05 5.5326313558461538e-11
+ 2.1007389642547638e-05 5.5316205768572161e-11
+ 2.1008368207264574e-05 5.5280832763072969e-11
+ 2.1009409502908188e-05 5.5216998316807767e-11
+ 2.1009970598735324e-05 5.5162661637241072e-11
+ 2.1010339629298369e-05 5.5114439869388932e-11
+ 2.1011110323815844e-05 5.4960015216721681e-11
+ 2.101174148123385e-05 5.4732817211499076e-11
+ 2.1012113084009009e-05 5.4516300482441227e-11
+ 2.101243419379579e-05 5.42419953316085e-11
+ 2.1012647097925413e-05 5.400886072195258e-11
+ 2.1012860002055031e-05 5.3774257755821461e-11
+ 2.1014989043351246e-05 5.1549852354822979e-11
+ 2.1027196074601244e-05 4.2855387214314058e-11
+ 2.1039403105851246e-05 4.053247294954365e-11
+ 2.1051610137101245e-05 4.3931039996784842e-11
+ 2.1063817168351247e-05 5.2388572167819672e-11
+ 2.1076024199601246e-05 6.5140225940715896e-11
+ 2.1088231230851244e-05 8.1286621114128428e-11
+ 2.1100438262101246e-05 9.9800201152591339e-11
+ 2.1112645293351245e-05 1.1955731974057662e-10
+ 2.1124852324601244e-05 1.3938677731239894e-10
+ 2.1137059355851246e-05 1.581275910662053e-10
+ 2.1149266387101244e-05 1.7469004130247602e-10
+ 2.1161473418351243e-05 1.881149150311095e-10
+ 2.1173680449601245e-05 1.9762660690176225e-10
+ 2.1185887480851244e-05 2.026764694324815e-10
+ 2.1198094512101246e-05 2.0297359093770258e-10
+ 2.1210301543351244e-05 1.9850103705845601e-10
+ 2.1222508574601243e-05 1.8951650785639057e-10
+ 2.1234715605851245e-05 1.7653730627935789e-10
+ 2.1246922637101244e-05 1.6031044421422816e-10
+ 2.1259129668351246e-05 1.4176958358946107e-10
+ 2.1271336699601245e-05 1.2198127662112241e-10
+ 2.1283543730851243e-05 1.0208359001036545e-10
+ 2.1295750762101245e-05 8.3220638681385549e-11
+ 2.1307957793351244e-05 6.6476791169901555e-11
+ 2.1311009551163744e-05 6.2738216402259133e-11
+ 2.1311314726944992e-05 6.2375524734021021e-11
+ 2.1312077666398119e-05 6.1477937832984702e-11
+ 2.131245913612468e-05 6.1034090082773124e-11
+ 2.1312482977982591e-05 6.1006459924724939e-11
+ 2.1312487746354171e-05 6.1000935454857881e-11
+ 2.1312497283097339e-05 6.0989888077255491e-11
+ 2.131249804603679e-05 6.0989004377034889e-11
+ 2.1312499571915698e-05 6.0987237016591268e-11
+ 2.131249969398601e-05 6.0987095630059761e-11
+ 2.1312499938126635e-05 6.0986812858020706e-11
+ 2.1312499957657883e-05 6.0986790236316644e-11
+ 2.1312499996720383e-05 6.098674499293473e-11
+ 2.1312500074845383e-05 6.2330481534674083e-11
+ 2.1312500152970382e-05 6.6608198187672893e-11
+ 2.1312500934220379e-05 2.7075208822833839e-10
+ 2.1312508051845977e-05 1.5641542586395462e-08
+ 2.1312515169471571e-05 5.5354276368357439e-08
+ 2.1312522287097169e-05 1.1939590331347595e-07
+ 2.1312529404722766e-05 2.0774988808958391e-07
+ 2.1312536522348361e-05 3.2039621340029153e-07
+ 2.1312543639973958e-05 4.5731138406416947e-07
+ 2.1312550757599556e-05 6.1846843192454422e-07
+ 2.131255787522515e-05 8.0383692158836119e-07
+ 2.1312564992850748e-05 1.0133829569922963e-06
+ 2.1312572110476342e-05 1.2470691887940203e-06
+ 2.131257922810194e-05 1.5048548225862434e-06
+ 2.1312587807568572e-05 1.8475543476526228e-06
+ 2.1312596387035204e-05 2.2251205386231599e-06
+ 2.1312604966501836e-05 2.637462112110794e-06
+ 2.1312613545968468e-05 3.0844806091734263e-06
+ 2.13126221254351e-05 3.5660704276185103e-06
+ 2.1312630704901732e-05 4.0821188567621002e-06
+ 2.1312639284368364e-05 4.6325061146258863e-06
+ 2.1312647863834996e-05 5.2171053875545835e-06
+ 2.131265818077025e-05 5.965211217502911e-06
+ 2.1312668497705507e-05 6.7623492313414161e-06
+ 2.1312678814640764e-05 7.6082590651614992e-06
+ 2.1312689131576018e-05 8.5026660760363497e-06
+ 2.1312699448511271e-05 9.4452814742207388e-06
+ 2.1312709765446529e-05 1.0435802462230257e-05
+ 2.1312720082381786e-05 1.147391238070454e-05
+ 2.1312730399317039e-05 1.25592808609545e-05
+ 2.1312742902012258e-05 1.393744004677843e-05
+ 2.1312755404707477e-05 1.538385928477854e-05
+ 2.1312767907402696e-05 1.6897871760843825e-05
+ 2.1312780410097916e-05 1.8478782715895571e-05
+ 2.1312792912793138e-05 2.0125869935940648e-05
+ 2.1312805415488357e-05 2.1838384260846487e-05
+ 2.1312817918183576e-05 2.3615550111329756e-05
+ 2.1312830420878795e-05 2.5456566033633845e-05
+ 2.1312845592253873e-05 2.7775100207116592e-05
+ 2.1312860763628955e-05 3.0184906039223483e-05
+ 2.1312875935004036e-05 3.2684405463249104e-05
+ 2.1312891106379114e-05 3.5271969973378807e-05
+ 2.1312906277754193e-05 3.7945922288216153e-05
+ 2.1312921449129274e-05 4.0704538058428326e-05
+ 2.1312936620504356e-05 4.3546047616054653e-05
+ 2.131295486051956e-05 4.7069469432613542e-05
+ 2.1312973100534768e-05 5.0706855826657106e-05
+ 2.1312991340549975e-05 5.4454893918205257e-05
+ 2.1313009580565183e-05 5.8310193146384224e-05
+ 2.1313027820580391e-05 6.2269290123695639e-05
+ 2.1313046060595599e-05 6.6328653564053143e-05
+ 2.1313068199865847e-05 7.1385338233594827e-05
+ 2.1313090339136095e-05 7.6577901326810804e-05
+ 2.1313112478406344e-05 8.189969012601315e-05
+ 2.1313134617676592e-05 8.7343953274172687e-05
+ 2.131316129301132e-05 9.4056657818521804e-05
+ 2.1313187873095808e-05 0.00010090035482762358
+ 2.1313214453180299e-05 0.00010788664307091889
+ 2.131324868848434e-05 0.00011707548567577072
+ 2.1313282923788385e-05 0.00012645461865043843
+ 2.131331535612705e-05 0.00013549167951766453
+ 2.1313347788465711e-05 0.00014465398332574899
+ 2.1313380220804376e-05 0.00015391958689944246
+ 2.1313412653143038e-05 0.00016326679416820027
+ 2.1313445085481702e-05 0.00017267423453976973
+ 2.1313477517820367e-05 0.00018212093762926101
+ 2.1313509950159029e-05 0.00019158640400330904
+ 2.1313542382497694e-05 0.00020105067163597072
+ 2.1313569584998149e-05 0.00020897371829601134
+ 2.1313596787498601e-05 0.00021687121736840308
+ 2.1313623989999053e-05 0.0002247324443841368
+ 2.1313651192499508e-05 0.00023254704172942061
+ 2.1313678394999963e-05 0.00024030503688061725
+ 2.1313705597500415e-05 0.00024799685880477063
+ 2.1313732800000867e-05 0.00025561335251051022
+ 2.1313760002501322e-05 0.00026314579174345146
+ 2.1313787205001777e-05 0.00027058588982929906
+ 2.1313814407502229e-05 0.00027792580867665878
+ 2.1313841610002681e-05 0.0002851581659600263
+ 2.1313868812503136e-05 0.00029227604051150784
+ 2.1313896015003591e-05 0.00029927297595749906
+ 2.1313923217504043e-05 0.00030614298264376868
+ 2.1313950420004495e-05 0.00031288053789913813
+ 2.131397762250495e-05 0.00031948058469418605
+ 2.1314004825005405e-05 0.00032593852875712024
+ 2.1314032027505857e-05 0.00033225023421413059
+ 2.1314059230006309e-05 0.00033841201782615327
+ 2.1314086432506764e-05 0.0003444206418985982
+ 2.1314115300883498e-05 0.00035062659892727544
+ 2.1314144169260236e-05 0.0003566540934654631
+ 2.131417303763697e-05 0.00036250083298786399
+ 2.1314201906013704e-05 0.00036816503744223664
+ 2.1314230774390438e-05 0.00037364542226806104
+ 2.1314259642767172e-05 0.00037894118026981165
+ 2.131428851114391e-05 0.00038405196247931109
+ 2.1314317379520644e-05 0.000388977858140999
+ 2.1314346247897378e-05 0.00039371937395252178
+ 2.1314381135166684e-05 0.0003992047348763101
+ 2.1314416022435989e-05 0.00040442447430172904
+ 2.131444998550605e-05 0.00040925368585940502
+ 2.1314483948576115e-05 0.00041383750344981278
+ 2.1314517911646176e-05 0.00041817993390062743
+ 2.1314551874716241e-05 0.00042228549548244641
+ 2.1314585837786302e-05 0.00042615916749456922
+ 2.1314627381082818e-05 0.0004305900119691504
+ 2.1314668924379334e-05 0.00043469258490726371
+ 2.131471046767585e-05 0.0004384781612780042
+ 2.1314752010972367e-05 0.00044195857402361564
+ 2.1314802322523099e-05 0.00044578261210212054
+ 2.1314853125173634e-05 0.00044923093231022854
+ 2.1314903927824173e-05 0.00045228765276156626
+ 2.1314971607266247e-05 0.00045579239535176001
+ 2.1315039286708322e-05 0.00045870005395461338
+ 2.1315091919396568e-05 0.00046058369469111949
+ 2.1315144552084812e-05 0.00046216451732223918
+ 2.1315197184773055e-05 0.00046346681282214352
+ 2.1315249817461302e-05 0.00046451393123718372
+ 2.1315297809929104e-05 0.00046526519657479943
+ 2.1315345802396908e-05 0.00046583893527304737
+ 2.131539379486471e-05 0.00046625041073407677
+ 2.1315441787332511e-05 0.00046651403875466578
+ 2.1315489779800316e-05 0.0004666433740508164
+ 2.1315537261554864e-05 0.00046665162291553914
+ 2.1315584743309412e-05 0.000466552308242554
+ 2.1315632225063963e-05 0.00046635608374731292
+ 2.1315679706818511e-05 0.00046607281339991539
+ 2.1315727188573062e-05 0.00046571159614456351
+ 2.1315774670327609e-05 0.00046528079492301239
+ 2.1315824358583367e-05 0.00046476378468933915
+ 2.1315874046839122e-05 0.00046418694952370777
+ 2.131592373509488e-05 0.00046355752837163748
+ 2.1315973423350635e-05 0.00046288205221083837
+ 2.1316023111606393e-05 0.00046216639229460844
+ 2.1316072799862151e-05 0.00046141580830294233
+ 2.1316127951386076e-05 0.00046054748419045071
+ 2.1316183102910001e-05 0.00045964758393211987
+ 2.1316238254433927e-05 0.00045872107390199996
+ 2.1316293405957855e-05 0.00045777228079549998
+ 2.1316348557481781e-05 0.00045680495887963081
+ 2.1316411640520539e-05 0.000455679953428722
+ 2.1316474723559298e-05 0.00045453907391423655
+ 2.1316537806598057e-05 0.0004533857886546739
+ 2.1316600889636819e-05 0.00045222299034028662
+ 2.1316674140146427e-05 0.00045086399130210022
+ 2.1316747390656034e-05 0.00044949844535668453
+ 2.1316820641165645e-05 0.00044812878579885432
+ 2.1316905619421584e-05 0.00044653719761490697
+ 2.1316990597677525e-05 0.0004449449586312652
+ 2.1317093836844785e-05 0.00044301214871122791
+ 2.1317198171769416e-05 0.00044106269601017851
+ 2.1317302506694044e-05 0.00043911870626636078
+ 2.1317426664469166e-05 0.00043681393387383496
+ 2.1317550822244288e-05 0.00043451951813961668
+ 2.1317705800806532e-05 0.00043167106196547318
+ 2.1317884937131789e-05 0.00042840086834201771
+ 2.1318098556602388e-05 0.00042453293757745131
+ 2.1318364485722953e-05 0.00041976628303681877
+ 2.1318717982712206e-05 0.00041351261779238365
+ 2.1319242097564147e-05 0.00040441158298440465
+ 2.1320136340120474e-05 0.00038934346113524376
+ 2.1322132807185036e-05 0.00035769765454050228
+ 2.1323988816858017e-05 0.00033058981538904275
+ 2.1326421668443081e-05 0.00029814348467284587
+ 2.1328854520028145e-05 0.00026888165874455468
+ 2.1331287371613206e-05 0.00024249178888257299
+ 2.1333720223198271e-05 0.00021869200206866874
+ 2.1336153074783335e-05 0.00019722808975099272
+ 2.1338585926368399e-05 0.00017787079297825666
+ 2.134101877795346e-05 0.00016041335425741158
+ 2.1343451629538525e-05 0.0001446693086575522
+ 2.1345767705239782e-05 0.00013111903917235234
+ 2.1348819440406721e-05 0.00011518312547724692
+ 2.1351871175573659e-05 0.00010118403045864018
+ 2.1354922910740597e-05 8.8886357108097517e-05
+ 2.1357974645907535e-05 7.8083318131395906e-05
+ 2.1361026381074474e-05 6.8593258842393536e-05
+ 2.1364078116241415e-05 6.025660181923537e-05
+ 2.1367773618773599e-05 5.1505809187250614e-05
+ 2.1371134288610911e-05 4.4656271026532631e-05
+ 2.1374494958448219e-05 3.8717628008379948e-05
+ 2.1378620731690279e-05 3.2495702272495222e-05
+ 2.1382746504932339e-05 2.7273646663031209e-05
+ 2.1386872278174399e-05 2.2890780980831938e-05
+ 2.1390998051416455e-05 1.9212246512347876e-05
+ 2.1395123824658515e-05 1.6124856494297113e-05
+ 2.1400251138437098e-05 1.2970141364146993e-05
+ 2.1405378452215681e-05 1.0432633172092827e-05
+ 2.1410505765994261e-05 8.3915781182774641e-06
+ 2.1415633079772844e-05 6.7498471833962207e-06
+ 2.1421995979825154e-05 5.1518189724579756e-06
+ 2.1428358879877461e-05 3.9321378049054371e-06
+ 2.1434721779929771e-05 3.0012267671564931e-06
+ 2.1442497256254513e-05 2.15737185496337e-06
+ 2.1450272732579254e-05 1.5508026051292012e-06
+ 2.1458048208903995e-05 1.1147960586695601e-06
+ 2.1467983441936068e-05 7.3118840550782522e-07
+ 2.1477918674968144e-05 4.7961075194826108e-07
+ 2.1490125706218142e-05 2.8571159964289929e-07
+ 2.1502332737468145e-05 1.7024209705967684e-07
+ 2.1514539768718143e-05 1.0147848625806179e-07
+ 2.1526746799968142e-05 6.0528851952355526e-08
+ 2.1538953831218144e-05 3.6142806128821739e-08
+ 2.1551160862468143e-05 2.1620593980565466e-08
+ 2.1563367893718145e-05 1.2972424953734794e-08
+ 2.1575574924968143e-05 7.8223266739669589e-09
+ 2.1587781956218142e-05 4.7553755500354248e-09
+ 2.1599988987468144e-05 2.9289656540459339e-09
+ 2.1612196018718143e-05 1.8413143839828223e-09
+ 2.1624403049968141e-05 1.1936037658401295e-09
+ 2.1636610081218143e-05 8.078836241498485e-10
+ 2.1648817112468142e-05 5.7818218790680653e-10
+ 2.1661024143718141e-05 4.4139192644487092e-10
+ 2.1673231174968143e-05 3.5993152647751398e-10
+ 2.1685438206218141e-05 3.1142080027758294e-10
+ 2.1697645237468143e-05 2.8253202431124535e-10
+ 2.1709852268718142e-05 2.653283707170538e-10
+ 2.1722059299968141e-05 2.5508336753526945e-10
+ 2.1734266331218143e-05 2.4898233649178344e-10
+ 2.1746473362468141e-05 2.4534909287155193e-10
+ 2.1758680393718143e-05 2.4318544696123555e-10
+ 2.1770887424968142e-05 2.4189696683490067e-10
+ 2.1783094456218141e-05 2.411296605642883e-10
+ 2.1795301487468143e-05 2.406727199550333e-10
+ 2.1807508518718141e-05 2.4040060549918595e-10
+ 2.181971554996814e-05 2.4023855751768804e-10
+ 2.1831922581218142e-05 2.4014205601586099e-10
+ 2.1844129612468141e-05 2.4008458822552009e-10
+ 2.1856336643718139e-05 2.4005036536744095e-10
+ 2.1868543674968141e-05 2.4002998505548136e-10
+ 2.188075070621814e-05 2.4001784836154639e-10
+ 2.1892957737468142e-05 2.4001062082534474e-10
+ 2.1905164768718141e-05 2.4000631674323626e-10
+ 2.1917371799968139e-05 2.4000375361391963e-10
+ 2.1929578831218142e-05 2.4000222718017004e-10
+ 2.194178586246814e-05 2.4000131819356677e-10
+ 2.1953992893718142e-05 2.4000077702242996e-10
+ 2.1966199924968141e-05 2.4000045459933931e-10
+ 2.197840695621814e-05 2.4000026257884156e-10
+ 2.1990613987468142e-05 2.4000014832025053e-10
+ 2.200282101871814e-05 2.4000008023582484e-10
+ 2.2015028049968139e-05 2.4000003966625581e-10
+ 2.2027235081218141e-05 2.400000155533385e-10
+ 2.203944211246814e-05 2.4000000121814107e-10
+ 2.2051649143718138e-05 2.3999999261673205e-10
+ 2.206385617496814e-05 2.3999998758456908e-10
+ 2.2076063206218139e-05 2.3999998453222656e-10
+ 2.2088270237468141e-05 2.3999998265390494e-10
+ 2.210047726871814e-05 2.3999998161732485e-10
+ 2.2112684299968138e-05 2.3999998104358188e-10
+ 2.212489133121814e-05 2.3999998057389865e-10
+ 2.2137098362468139e-05 2.3999998026292464e-10
+ 2.2149305393718141e-05 2.3999998019001177e-10
+ 2.216151242496814e-05 2.3999998019899801e-10
+ 2.2173719456218138e-05 2.3999998020597388e-10
+ 2.218592648746814e-05 2.3999998012855701e-10
+ 2.2198133518718139e-05 2.3999998005534517e-10
+ 2.2210340549968138e-05 2.3999998008389102e-10
+ 2.222254758121814e-05 2.3999998009224399e-10
+ 2.2234754612468138e-05 2.3999998012219294e-10
+ 2.2246961643718137e-05 2.3999998013282356e-10
+ 2.2259168674968139e-05 2.3999998009115475e-10
+ 2.2271375706218138e-05 2.3999998009706464e-10
+ 2.228358273746814e-05 2.3999998010363494e-10
+ 2.2295789768718138e-05 2.3999998011314167e-10
+ 2.2307996799968137e-05 2.3999998013616955e-10
+ 2.2320203831218139e-05 2.3999998011363462e-10
+ 2.2332410862468138e-05 2.3999998009274014e-10
+ 2.234461789371814e-05 2.399999801011231e-10
+ 2.2356824924968139e-05 2.399999800977465e-10
+ 2.2369031956218137e-05 2.3999998010717031e-10
+ 2.2381238987468139e-05 2.3999998026497155e-10
+ 2.2393446018718138e-05 2.3999998018940695e-10
+ 2.2405653049968137e-05 2.399999801489314e-10
+ 2.2417860081218139e-05 2.3999998016252337e-10
+ 2.2430067112468137e-05 2.3999998017736873e-10
+ 2.2442274143718136e-05 2.3999998008841631e-10
+ 2.2454481174968138e-05 2.399999801406156e-10
+ 2.2466688206218137e-05 2.3999998027111368e-10
+ 2.2478895237468139e-05 2.399999803096209e-10
+ 2.2491102268718137e-05 2.399999801745041e-10
+ 2.2503309299968136e-05 2.3999998014351678e-10
+ 2.2515516331218138e-05 2.399999802735929e-10
+ 2.2527723362468137e-05 2.3999998026179471e-10
+ 2.2539930393718139e-05 2.3999998016976751e-10
+ 2.2552137424968137e-05 2.3999998022820648e-10
+ 2.2564344456218136e-05 2.3999998018386391e-10
+ 2.2576551487468138e-05 2.3999998024457121e-10
+ 2.2588758518718137e-05 2.399999802712344e-10
+ 2.2600965549968139e-05 2.3999998016906244e-10
+ 2.2613172581218137e-05 2.399999802251944e-10
+ 2.2625379612468139e-05 2.3999998029674961e-10
+ 2.2637586643718138e-05 2.3999998024490881e-10
+ 2.264979367496814e-05 2.3999998022841694e-10
+ 2.2662000706218139e-05 2.3999998027402318e-10
+ 2.2674207737468141e-05 2.3999998031284179e-10
+ 2.2686414768718139e-05 2.3999998024592236e-10
+ 2.2698621799968142e-05 2.3999998028900653e-10
+ 2.271082883121814e-05 2.3999998029018118e-10
+ 2.2723035862468142e-05 2.3999998020407995e-10
+ 2.2735242893718141e-05 2.3999998030027903e-10
+ 2.2747449924968143e-05 2.3999998034659856e-10
+ 2.2759656956218142e-05 2.3999998035710371e-10
+ 2.2771863987468144e-05 2.3999998035781327e-10
+ 2.2784071018718142e-05 2.3999998028429372e-10
+ 2.2796278049968144e-05 2.3999998026462584e-10
+ 2.2808485081218143e-05 2.3999998034401652e-10
+ 2.2820692112468145e-05 2.3999998040748526e-10
+ 2.2832899143718144e-05 2.399999802904164e-10
+ 2.2845106174968146e-05 2.3999998026488739e-10
+ 2.2857313206218144e-05 2.399999803948264e-10
+ 2.2869520237468146e-05 2.399999803901337e-10
+ 2.2881727268718145e-05 2.3999998030809217e-10
+ 2.2893934299968147e-05 2.3999998036169063e-10
+ 2.2906141331218146e-05 2.3999998033495331e-10
+ 2.2918348362468148e-05 2.3999998039429674e-10
+ 2.2930555393718146e-05 2.3999998043834603e-10
+ 2.2942762424968149e-05 2.3999998042747548e-10
+ 2.2954969456218147e-05 2.3999998033813589e-10
+ 2.2967176487468149e-05 2.3999998042749197e-10
+ 2.2979383518718148e-05 2.3999998045576412e-10
+ 2.299159054996815e-05 2.3999998040668088e-10
+ 2.3003797581218149e-05 2.3999998041015307e-10
+ 2.3016004612468151e-05 2.3999998038280188e-10
+ 2.3028211643718149e-05 2.399999804963409e-10
+ 2.3040418674968151e-05 2.3999998050724164e-10
+ 2.305262570621815e-05 2.3999998043757132e-10
+ 2.3064832737468152e-05 2.3999998042873677e-10
+ 2.3077039768718151e-05 2.3999998048062938e-10
+ 2.3089246799968153e-05 2.3999998046244087e-10
+ 2.3101453831218151e-05 2.3999998047367506e-10
+ 2.3113660862468153e-05 2.3999998045481209e-10
+ 2.3125867893718152e-05 2.3999998043752122e-10
+ 2.3138074924968154e-05 2.3999998042446345e-10
+ 2.3150281956218153e-05 2.3999998041722252e-10
+ 2.3162488987468155e-05 2.3999998041674074e-10
+ 2.3174696018718153e-05 2.3999998042357827e-10
+ 2.3186903049968156e-05 2.3999998043806778e-10
+ 2.3199110081218154e-05 2.3999998047660411e-10
+ 2.3211317112468156e-05 2.3999998051655456e-10
+ 2.3223524143718155e-05 2.3999998052591767e-10
+ 2.3235731174968157e-05 2.3999998048427911e-10
+ 2.3247938206218156e-05 2.3999998054712477e-10
+ 2.3260145237468158e-05 2.3999998057013456e-10
+ 2.3272352268718156e-05 2.3999998051176627e-10
+ 2.3284559299968158e-05 2.3999998057450993e-10
+ 2.3296766331218157e-05 2.3999998053652084e-10
+ 2.3308973362468159e-05 2.3999998056705243e-10
+ 2.3321180393718158e-05 2.399999805326457e-10
+ 2.333338742496816e-05 2.399999805718764e-10
+ 2.3345594456218158e-05 2.3999998054921403e-10
+ 2.335780148746816e-05 2.3999998061819825e-10
+ 2.3370008518718159e-05 2.399999805688973e-10
+ 2.3382215549968161e-05 2.3999998054792621e-10
+ 2.339442258121816e-05 2.39999980627754e-10
+ 2.3406629612468162e-05 2.3999998059474422e-10
+ 2.341883664371816e-05 2.399999805933057e-10
+ 2.3431043674968163e-05 2.3999998057922352e-10
+ 2.3443250706218161e-05 2.3999998056088616e-10
+ 2.3455457737468163e-05 2.3999998058786213e-10
+ 2.3467664768718162e-05 2.399999806005213e-10
+ 2.3479871799968164e-05 2.3999998060792622e-10
+ 2.3492078831218163e-05 2.3999998061547279e-10
+ 2.3504285862468165e-05 2.3999998062637359e-10
+ 2.3516492893718163e-05 2.3999998064254068e-10
+ 2.3528699924968165e-05 2.399999806651119e-10
+ 2.3540906956218164e-05 2.3999998065019003e-10
+ 2.3553113987468166e-05 2.3999998066078063e-10
+ 2.3565321018718165e-05 2.399999807158811e-10
+ 2.3577528049968167e-05 2.3999998065933043e-10
+ 2.3589735081218165e-05 2.3999998069949765e-10
+ 2.3601942112468167e-05 2.3999998071137632e-10
+ 2.3614149143718166e-05 2.3999998066492584e-10
+ 2.3626356174968168e-05 2.3999998067631891e-10
+ 2.3638563206218167e-05 2.3999998068067386e-10
+ 2.3650770237468169e-05 2.3999998072884115e-10
+ 2.3662977268718167e-05 2.3999998071703879e-10
+ 2.3675184299968169e-05 2.399999807620995e-10
+ 2.3687391331218168e-05 2.3999998071038665e-10
+ 2.369959836246817e-05 2.3999998068359319e-10
+ 2.3711805393718169e-05 2.3999998073934671e-10
+ 2.3724012424968171e-05 2.3999998074833904e-10
+ 2.373621945621817e-05 2.3999998072288318e-10
+ 2.3748426487468172e-05 2.3999998078919143e-10
+ 2.376063351871817e-05 2.3999998076965073e-10
+ 2.3772840549968172e-05 2.399999807468099e-10
+ 2.3785047581218171e-05 2.3999998076982682e-10
+ 2.3797254612468173e-05 2.3999998077882701e-10
+ 2.3809461643718172e-05 2.3999998078272732e-10
+ 2.3821668674968174e-05 2.3999998077698307e-10
+ 2.3833875706218172e-05 2.3999998078844893e-10
+ 2.3846082737468174e-05 2.3999998080355428e-10
+ 2.3858289768718173e-05 2.3999998082407074e-10
+ 2.3870496799968175e-05 2.3999998085105249e-10
+ 2.3882703831218174e-05 2.3999998076975625e-10
+ 2.3894910862468176e-05 2.399999808033618e-10
+ 2.3907117893718174e-05 2.3999998080328762e-10
+ 2.3919324924968176e-05 2.3999998084082399e-10
+ 2.3931531956218175e-05 2.3999998077877215e-10
+ 2.3943738987468177e-05 2.3999998083679345e-10
+ 2.3955946018718176e-05 2.3999998087406507e-10
+ 2.3968153049968178e-05 2.3999998083776306e-10
+ 2.3980360081218177e-05 2.3999998086990843e-10
+ 2.3992567112468179e-05 2.3999998083702247e-10
+ 2.4004774143718177e-05 2.399999808776692e-10
+ 2.4016981174968179e-05 2.3999998085631119e-10
+ 2.4029188206218178e-05 2.3999998083949021e-10
+ 2.404139523746818e-05 2.3999929577393646e-10
+ 2.4053602268718179e-05 2.3999721430085655e-10
+ 2.4065809299968181e-05 2.3999541801853927e-10
+ 2.4078016331218179e-05 2.3999352441667849e-10
+ 2.4090223362468181e-05 2.3998998231508299e-10
+ 2.410243039371818e-05 2.3998269751518182e-10
+ 2.4114637424968182e-05 2.3996731785187146e-10
+ 2.4120740940593181e-05 2.3994983464395233e-10
+ 2.4126844456218181e-05 2.3990674100743305e-10
+ 2.412989621403068e-05 2.3985615585153402e-10
+ 2.413294797184318e-05 2.3973456609508262e-10
+ 2.4134473850749433e-05 2.3959023649420816e-10
+ 2.413599972965568e-05 2.3924487360909957e-10
+ 2.4136991106889186e-05 2.3866252493064795e-10
+ 2.4137269733896243e-05 2.3836567845599657e-10
+ 2.4137548360903299e-05 2.3795958755937176e-10
+ 2.413809883562797e-05 2.3707317678626589e-10
+ 2.4140875273912437e-05 2.3289947932096134e-10
+ 2.4153082305162439e-05 2.1857108082062022e-10
+ 2.4165289336412437e-05 2.0744394567167327e-10
+ 2.4177496367662436e-05 1.9657101424192844e-10
+ 2.4189703398912438e-05 1.8444183633608339e-10
+ 2.420191043016244e-05 1.7048236032410772e-10
+ 2.4214117461412439e-05 1.5473832156939622e-10
+ 2.4226324492662437e-05 1.376643966131987e-10
+ 2.4238531523912439e-05 1.1997405552563603e-10
+ 2.4250738555162441e-05 1.0252468847149855e-10
+ 2.426294558641244e-05 8.622433036431135e-11
+ 2.4275152617662439e-05 7.1953269034585456e-11
+ 2.4287359648912441e-05 6.0497851486217764e-11
+ 2.4299566680162443e-05 5.2496010132610782e-11
+ 2.4311773711412441e-05 4.8395088933560857e-11
+ 2.432398074266244e-05 4.8422873289603413e-11
+ 2.4336187773912442e-05 5.2572582289997926e-11
+ 2.4348394805162444e-05 6.0602144636946106e-11
+ 2.4360601836412443e-05 7.2047475992215135e-11
+ 2.4372808867662441e-05 8.6248800170538565e-11
+ 2.4385015898912444e-05 1.0238838404643464e-10
+ 2.4397222930162446e-05 1.19537446121802e-10
+ 2.4409429961412444e-05 1.367094991032434e-10
+ 2.4421636992662443e-05 1.5291703382970249e-10
+ 2.4433844023912445e-05 1.6722827017382802e-10
+ 2.4436895781724945e-05 1.7041028620342427e-10
+ 2.4437048369615571e-05 1.7056469761267313e-10
+ 2.4437429839342132e-05 1.7094872387604414e-10
+ 2.443746798631479e-05 1.7098696858623529e-10
+ 2.4437475615709319e-05 1.7099461407315297e-10
+ 2.4437490874498384e-05 1.7100990159048815e-10
+ 2.4437496978014009e-05 1.7101601530675094e-10
+ 2.4437499419420258e-05 1.7101846058671687e-10
+ 2.4437499604455784e-05 1.7101864591102341e-10
+ 2.443749997452684e-05 1.710190165576025e-10
+ 2.4437500714668949e-05 2.9362295535076986e-10
+ 2.4437501454811058e-05 6.7955376462053112e-10
+ 2.4437508856232148e-05 1.9019685483973129e-08
+ 2.4437516257653238e-05 6.3680162617685321e-08
+ 2.4437523659074328e-05 1.3464578979540883e-07
+ 2.4437531060495418e-05 2.3189729697639808e-07
+ 2.4437538461916507e-05 3.5541134357275011e-07
+ 2.4437547512355688e-05 5.4209487018455778e-07
+ 2.4437556562794871e-05 7.6794744751962639e-07
+ 2.4437565613234051e-05 1.032901665904789e-06
+ 2.4437574663673232e-05 1.3368810846168448e-06
+ 2.4437583714112412e-05 1.6798002590529673e-06
+ 2.443759504453351e-05 2.1638522289015684e-06
+ 2.4437606374954609e-05 2.7085809274094572e-06
+ 2.4437617705375707e-05 3.3137595140903088e-06
+ 2.4437629035796806e-05 3.9791394372703589e-06
+ 2.4437643214653364e-05 4.8961848891924115e-06
+ 2.4437657393509919e-05 5.9065041934527361e-06
+ 2.4437671572366474e-05 7.0094688242501652e-06
+ 2.4437689032396938e-05 8.4939484121898285e-06
+ 2.4437706492427399e-05 1.011650368403691e-05
+ 2.4437723952457861e-05 1.187564441966631e-05
+ 2.443774626847783e-05 1.4320324258348367e-05
+ 2.44377685844978e-05 1.6981891243476683e-05
+ 2.443779090051777e-05 1.9856448881756975e-05
+ 2.4437819090217242e-05 2.3785542948120637e-05
+ 2.4437847279916712e-05 2.8038794641957824e-05
+ 2.4437875469616181e-05 3.2606525910010655e-05
+ 2.4437903659315654e-05 3.7478440563006991e-05
+ 2.4437931849015123e-05 4.2643660624918842e-05
+ 2.4437960038714592e-05 4.809076449946518e-05
+ 2.4437988228414062e-05 5.3807826764352856e-05
+ 2.4438019414106474e-05 6.0432058501488789e-05
+ 2.4438050599798886e-05 6.7354141141263776e-05
+ 2.4438081785491295e-05 7.4556149339010216e-05
+ 2.4438112971183707e-05 8.2019674226669682e-05
+ 2.4438150418414336e-05 9.1300740447793598e-05
+ 2.4438187865644969e-05 0.00010089852928503813
+ 2.4438225312875598e-05 0.00011077933330704341
+ 2.4438270844195811e-05 0.00012312530862772575
+ 2.4438316375516021e-05 0.00013577798574481139
+ 2.4438361906836234e-05 0.00014867616552750304
+ 2.4438407438156448e-05 0.00016175929991125412
+ 2.4438441084028113e-05 0.00017151113091571656
+ 2.4438474729899779e-05 0.00018130797963939794
+ 2.4438508375771444e-05 0.00019112690048319055
+ 2.443854202164311e-05 0.000200945563836072
+ 2.4438575667514775e-05 0.0002107423308290232
+ 2.443860931338644e-05 0.00022049632214156449
+ 2.4438642959258106e-05 0.00023018748061678874
+ 2.4438676605129771e-05 0.00023979662749408118
+ 2.4438710251001437e-05 0.0002493055121224335
+ 2.4438736870668147e-05 0.00025674620625396695
+ 2.4438763490334857e-05 0.00026410519322842072
+ 2.443879011000157e-05 0.00027137476557784006
+ 2.443881672966828e-05 0.00027854762813939171
+ 2.443884334933499e-05 0.00028561690431054267
+ 2.4438869969001703e-05 0.0002925761407342706
+ 2.4438896588668413e-05 0.0002994193104460534
+ 2.4438923208335123e-05 0.00030614081452042582
+ 2.4438949828001833e-05 0.00031273548226053464
+ 2.4438976447668543e-05 0.00031919856997935221
+ 2.4439003067335256e-05 0.00032552575842600295
+ 2.4439029687001966e-05 0.00033171314891500655
+ 2.4439056306668676e-05 0.00033775725822013397
+ 2.4439082926335389e-05 0.00034365501229800138
+ 2.4439109546002099e-05 0.00034940373890948994
+ 2.4439136165668809e-05 0.00035500115920957621
+ 2.4439162785335519e-05 0.00036044537837818884
+ 2.4439189405002229e-05 0.00036573487536628151
+ 2.4439216024668942e-05 0.00037086849183281574
+ 2.4439239404935228e-05 0.00037524816041470616
+ 2.4439262785201518e-05 0.00037950661982143294
+ 2.4439286165467805e-05 0.00038364373347733212
+ 2.4439309545734095e-05 0.00038765955240256639
+ 2.4439332926000381e-05 0.00039155430797307712
+ 2.4439356306266671e-05 0.00039532840450424615
+ 2.4439379686532958e-05 0.00039898241168751826
+ 2.4439403066799248e-05 0.00040251705690861332
+ 2.4439426447065534e-05 0.00040593321747524688
+ 2.4439449827331824e-05 0.0004092319127814815
+ 2.4439473207598111e-05 0.00041241429643495774
+ 2.44394965878644e-05 0.00041548164837231091
+ 2.4439519968130687e-05 0.00041843536698707185
+ 2.4439543348396977e-05 0.00042127696129328835
+ 2.4439566728663263e-05 0.00042400804314699181
+ 2.4439590108929553e-05 0.00042663031954648096
+ 2.443961348919584e-05 0.00042914558503120656
+ 2.443963686946213e-05 0.00043155571419782471
+ 2.4439660249728416e-05 0.00043386265435075173
+ 2.4439683629994706e-05 0.0004360684183033
+ 2.4439707010260993e-05 0.00043817507734421687
+ 2.4439735591237517e-05 0.00044061881915944171
+ 2.443976417221404e-05 0.00044292160557832261
+ 2.4439792753190564e-05 0.00044508748731897325
+ 2.4439821334167088e-05 0.0004471205811035718
+ 2.4439849915143612e-05 0.00044902505354874717
+ 2.4439886199806214e-05 0.00045126415767136695
+ 2.443992545337338e-05 0.00045347065125915753
+ 2.4439946977215266e-05 0.00045458914938144757
+ 2.4439973696714702e-05 0.00045589098737442259
+ 2.4440000416214138e-05 0.00045710004038524538
+ 2.4440027135713574e-05 0.00045821970861944291
+ 2.444005385521301e-05 0.00045925335947318648
+ 2.4440080574712446e-05 0.00046020432082601948
+ 2.4440107294211882e-05 0.00046107587487371744
+ 2.4440134013711318e-05 0.00046187125249194449
+ 2.4440160733210754e-05 0.00046259362811953432
+ 2.4440187452710191e-05 0.00046324611514856153
+ 2.4440214172209627e-05 0.00046383176180687778
+ 2.4440240891709063e-05 0.00046435354751746608
+ 2.4440262548859613e-05 0.00046473161709406521
+ 2.4440284206010163e-05 0.00046507115570231151
+ 2.4440305863160716e-05 0.00046537364255429416
+ 2.444032752031127e-05 0.00046564052306956875
+ 2.444034917746182e-05 0.00046587320827894959
+ 2.444037083461237e-05 0.00046607307433484731
+ 2.4440392491762923e-05 0.00046624146212347479
+ 2.4440414148913477e-05 0.00046637967697419719
+ 2.4440435806064027e-05 0.00046648898846127722
+ 2.4440457463214577e-05 0.00046657063029325929
+ 2.444047912036513e-05 0.0004666258002852115
+ 2.4440496765399605e-05 0.00046665198683365781
+ 2.4440514410434079e-05 0.00046666198405394353
+ 2.4440532055468551e-05 0.00046665638716889121
+ 2.4440549700503025e-05 0.00046663577581361698
+ 2.44405673455375e-05 0.00046660071413966874
+ 2.4440584990571971e-05 0.00046655175093608377
+ 2.4440602635606446e-05 0.00046648941976632619
+ 2.444062028064092e-05 0.00046641423912008399
+ 2.4440637925675395e-05 0.00046632671257892689
+ 2.444065557070987e-05 0.00046622732899484812
+ 2.4440673215744341e-05 0.00046611656268073646
+ 2.4440690860778815e-05 0.00046599487361184948
+ 2.444070850581329e-05 0.00046586270763738396
+ 2.4440726150847761e-05 0.00046572049670126538
+ 2.4440743795882236e-05 0.00046556865907130521
+ 2.444076144091671e-05 0.00046540759957590188
+ 2.4440779085951185e-05 0.00046523770984748908
+ 2.444079673098566e-05 0.00046505936857196291
+ 2.4440814376020131e-05 0.00046487294174334804
+ 2.4440832021054606e-05 0.00046467878292299136
+ 2.444084966608908e-05 0.00046447723350260048
+ 2.4440867311123551e-05 0.00046426862297047311
+ 2.4440884956158026e-05 0.00046405326918029163
+ 2.4440902601192501e-05 0.00046383147862188659
+ 2.4440920246226975e-05 0.0004636035466933999
+ 2.444093789126145e-05 0.00046336975797430831
+ 2.4440955536295921e-05 0.00046313038649879376
+ 2.4440973181330396e-05 0.00046288569602897633
+ 2.444099082636487e-05 0.00046263594032755121
+ 2.4441008471399342e-05 0.00046238136342939871
+ 2.4441026116433816e-05 0.00046212219991176166
+ 2.4441043761468291e-05 0.00046185867516261082
+ 2.4441061406502765e-05 0.00046159100564684353
+ 2.444107905153724e-05 0.00046131939916998468
+ 2.4441096696571711e-05 0.00046104405513908457
+ 2.4441114341606186e-05 0.00046076516482052872
+ 2.444113198664066e-05 0.00046048291159450004
+ 2.4441149631675132e-05 0.00046019747120585279
+ 2.4441167276709606e-05 0.00045990901201118061
+ 2.4441184921744081e-05 0.00045961769522188066
+ 2.4441202566778555e-05 0.00045932367514303494
+ 2.444122021181303e-05 0.00045902709940794936
+ 2.4441237856847501e-05 0.00045872810920820898
+ 2.4441255501881976e-05 0.00045842683951912496
+ 2.4441273146916451e-05 0.00045812341932046545
+ 2.4441290791950922e-05 0.00045781797181237863
+ 2.4441308436985396e-05 0.00045751061462643097
+ 2.4441326082019871e-05 0.00045720146003169808
+ 2.4441343727054346e-05 0.00045689061513585962
+ 2.444136137208882e-05 0.00045657818208126165
+ 2.4441379017123291e-05 0.00045626425823592343
+ 2.4441396662157766e-05 0.0004559489363794755
+ 2.4441414307192241e-05 0.0004556323048840281
+ 2.4441431952226712e-05 0.00045531444788997848
+ 2.4441449597261187e-05 0.00045499544547677518
+ 2.4441467242295661e-05 0.00045467537382866608
+ 2.4441484887330136e-05 0.00045435430539546583
+ 2.444150253236461e-05 0.00045403230904838535
+ 2.4441520177399082e-05 0.00045370945023097327
+ 2.4441537822433556e-05 0.00045338579110522598
+ 2.4441555467468031e-05 0.00045306139069292836
+ 2.4441573112502502e-05 0.00045273630501229328
+ 2.4441590757536977e-05 0.00045241058720997258
+ 2.4441608402571451e-05 0.00045208428768851668
+ 2.4441626047605926e-05 0.00045175745422936376
+ 2.4441643692640401e-05 0.00045143013211144381
+ 2.4441661337674872e-05 0.00045110236422548483
+ 2.4441682620107577e-05 0.00045070649383213837
+ 2.444170274528168e-05 0.00045033166770387813
+ 2.444172287045578e-05 0.00044995642757493547
+ 2.4441742995629884e-05 0.00044958082330929242
+ 2.4441763120803987e-05 0.00044920490166811688
+ 2.4441783245978091e-05 0.00044882870648050557
+ 2.4441803371152194e-05 0.00044845227880637947
+ 2.4441823496326294e-05 0.00044807565709178331
+ 2.4441843621500397e-05 0.00044769887731683952
+ 2.4441863746674501e-05 0.00044732197313660687
+ 2.4441888110746127e-05 0.00044686556133260454
+ 2.4441912474817756e-05 0.00044640906499999366
+ 2.4441936838889382e-05 0.00044595253182312878
+ 2.4441961202961011e-05 0.00044549600565976083
+ 2.4441985567032637e-05 0.00044503952681690417
+ 2.4442009931104266e-05 0.00044458313230938829
+ 2.4442034295175892e-05 0.00044412685610195336
+ 2.4442058659247521e-05 0.00044367072933572632
+ 2.4442083023319147e-05 0.00044321478053989036
+ 2.4442107387390776e-05 0.00044275903582933563
+ 2.4442136719683569e-05 0.00044221066197735565
+ 2.4442166051976366e-05 0.00044166265618977781
+ 2.4442195384269159e-05 0.00044111505229614979
+ 2.4442224716561955e-05 0.000440567880571222
+ 2.4442254048854748e-05 0.0004400211680723513
+ 2.4442283381147545e-05 0.0004394749389480193
+ 2.4442312713440338e-05 0.0004389292147195882
+ 2.4442342045733135e-05 0.00043838401453830063
+ 2.4442377848029196e-05 0.00043771929099924211
+ 2.444241233545463e-05 0.00043707976746529866
+ 2.4442446822880064e-05 0.00043644103787377733
+ 2.4442481310305495e-05 0.00043580312030283216
+ 2.444251579773093e-05 0.00043516603032572377
+ 2.4442557828321208e-05 0.00043439073279079223
+ 2.4442599858911489e-05 0.00043361670459320404
+ 2.4442641889501767e-05 0.00043284396248195208
+ 2.4442683920092045e-05 0.00043207252012209858
+ 2.4442725950682327e-05 0.00043130238856505936
+ 2.4442777518503426e-05 0.00043035930871672526
+ 2.4442828186666484e-05 0.00042943462880424378
+ 2.4442878854829539e-05 0.00042851188736760037
+ 2.4442929522992598e-05 0.00042759109050169295
+ 2.4442993215143462e-05 0.00042643637215815307
+ 2.4443056907294326e-05 0.0004252847370223043
+ 2.4443120599445191e-05 0.00042413618616643506
+ 2.4443198945610714e-05 0.00042272760989246018
+ 2.4443278657649692e-05 0.00042129925771114857
+ 2.4443358369688671e-05 0.00041987571829712041
+ 2.4443461292370766e-05 0.00041804477075287836
+ 2.4443569508909822e-05 0.00041612824858809757
+ 2.4443701914804437e-05 0.00041379527174881443
+ 2.4443847065030182e-05 0.00041125276249577136
+ 2.4444034315235683e-05 0.00040799587225246868
+ 2.4444255865010425e-05 0.00040417569543334638
+ 2.4444554034092504e-05 0.00039909077578923559
+ 2.4444998769870887e-05 0.00039162496079868337
+ 2.4445805003988996e-05 0.00037844492463713218
+ 2.4446711764368316e-05 0.00036415075183872955
+ 2.444773747568644e-05 0.00034863113834200367
+ 2.4448801143402344e-05 0.00033323544260725887
+ 2.4449944764949547e-05 0.00031744009309453978
+ 2.4452231646278909e-05 0.00028806442739914481
+ 2.4454182681216661e-05 0.00026516169925578173
+ 2.4456291228517252e-05 0.00024245284579639417
+ 2.445858146743616e-05 0.00021998507757767748
+ 2.4460926666850024e-05 0.00019913410083615226
+ 2.4463271866263889e-05 0.00018025945489984468
+ 2.4465590537179633e-05 0.00016335772611693962
+ 2.4468474569484279e-05 0.00014452917890563918
+ 2.4471358601788929e-05 0.00012787080313841811
+ 2.4474242634093579e-05 0.00011313246567173927
+ 2.4477126666398229e-05 0.00010009286360866482
+ 2.4480010698702879e-05 8.8556201336288662e-05
+ 2.4482894731007525e-05 7.8349250567829904e-05
+ 2.4485778763312175e-05 6.9318749243295542e-05
+ 2.4489342797663596e-05 5.9583601550415324e-05
+ 2.4492906832015013e-05 5.12156620124964e-05
+ 2.4496470866366433e-05 4.4022919356413453e-05
+ 2.4500034900717854e-05 3.7840328450154061e-05
+ 2.4503598935069274e-05 3.2526023165760874e-05
+ 2.4507899961127364e-05 2.7096692323683933e-05
+ 2.451220098718545e-05 2.2573641128908005e-05
+ 2.451650201324354e-05 1.8805590756409222e-05
+ 2.452080303930163e-05 1.5666514280396347e-05
+ 2.4525104065359716e-05 1.3051421554109079e-05
+ 2.4530502505986983e-05 1.0377818664489998e-05
+ 2.453590094661425e-05 8.251909089995107e-06
+ 2.4541299387241517e-05 6.5614966739560858e-06
+ 2.4546697827868785e-05 5.2173688876777125e-06
+ 2.4553468247657472e-05 3.9138135354349389e-06
+ 2.456023866744616e-05 2.9359531577328348e-06
+ 2.4567009087234848e-05 2.2024124497970242e-06
+ 2.457538530434396e-05 1.5432541258101081e-06
+ 2.4583761521453072e-05 1.081378721967762e-06
+ 2.4592137738562185e-05 7.5774041132707628e-07
+ 2.4603043385488657e-05 4.7689837631713853e-07
+ 2.461394903241513e-05 3.0015113649486665e-07
+ 2.4626156063665132e-05 1.7876217937191045e-07
+ 2.4638363094915134e-05 1.0647330757921957e-07
+ 2.4650570126165133e-05 6.3424252544034479e-08
+ 2.4662777157415131e-05 3.7787934734000867e-08
+ 2.4674984188665133e-05 2.2521155841269887e-08
+ 2.4687191219915135e-05 1.3429588576020001e-08
+ 2.4699398251165134e-05 8.015449872567151e-09
+ 2.4711605282415133e-05 4.7912734917149069e-09
+ 2.4723812313665135e-05 2.871251600636248e-09
+ 2.4736019344915137e-05 1.7278727196949598e-09
+ 2.4748226376165135e-05 1.0469960699243559e-09
+ 2.4760433407415134e-05 6.4154623608527275e-10
+ 2.4772640438665136e-05 4.0011708092908531e-10
+ 2.4784847469915138e-05 2.563646256420896e-10
+ 2.4797054501165137e-05 1.7078006330613652e-10
+ 2.4809261532415136e-05 1.1983532309874618e-10
+ 2.4821468563665138e-05 8.9519095817165878e-11
+ 2.483367559491514e-05 7.14874426319846e-11
+ 2.4845882626165138e-05 6.0771426293748156e-11
+ 2.4858089657415137e-05 5.4411972164600532e-11
+ 2.4870296688665139e-05 5.0646908151112081e-11
+ 2.4882503719915141e-05 4.8426835103990855e-11
+ 2.489471075116514e-05 4.7126820532761082e-11
+ 2.4906917782415138e-05 4.6374708016315066e-11
+ 2.491912481366514e-05 4.594887297816922e-11
+ 2.4931331844915142e-05 4.5717334758833713e-11
+ 2.4943538876165141e-05 4.5601496954841019e-11
+ 2.495574590741514e-05 4.5554554261028926e-11
+ 2.4967952938665142e-05 4.5548633436145208e-11
+ 2.4980159969915144e-05 4.5567135561437956e-11
+ 2.4992367001165142e-05 4.5600175741221697e-11
+ 2.5000000000000001e-05 4.5624752229059989e-11
+ 2.501220703125e-05 4.5669966819297461e-11
+ 2.5024414062500002e-05 4.5718898557805248e-11
+ 2.5036621093750001e-05 4.5770037749483043e-11
+ 2.5048828125000003e-05 4.5822485350610839e-11
+ 2.5061035156250001e-05 4.5875705969269391e-11
+ 2.50732421875e-05 4.5929380773488921e-11
+ 2.5085449218750002e-05 4.5983319895906806e-11
+ 2.5097656250000001e-05 4.6037410269464089e-11
+ 2.5109863281250003e-05 4.6091584562801975e-11
+ 2.5122070312500001e-05 4.6145802680837535e-11
+ 2.513427734375e-05 4.6200040748086769e-11
+ 2.5146484375000002e-05 4.6254284548072891e-11
+ 2.5158691406250001e-05 4.6308525616398256e-11
+ 2.5170898437500003e-05 4.6362758914111761e-11
+ 2.5183105468750001e-05 4.641698144216514e-11
+ 2.51953125e-05 4.6471191416301583e-11
+ 2.5207519531250002e-05 4.6525387775689795e-11
+ 2.5219726562500001e-05 4.6579569890308451e-11
+ 2.5231933593750003e-05 4.663373738668933e-11
+ 2.5244140625000001e-05 4.6687890044144897e-11
+ 2.525634765625e-05 4.6742027732970226e-11
+ 2.5268554687500002e-05 4.6796150377641402e-11
+ 2.5280761718750001e-05 4.6850257934899579e-11
+ 2.5292968750000003e-05 4.690435038069982e-11
+ 2.5305175781250001e-05 4.695842770243876e-11
+ 2.53173828125e-05 4.7012489894326265e-11
+ 2.5329589843750002e-05 4.7066536954629075e-11
+ 2.5341796875000001e-05 4.7120568884029375e-11
+ 2.5354003906249999e-05 4.7174585684647293e-11
+ 2.5366210937500002e-05 4.7228587359458799e-11
+ 2.537841796875e-05 4.728257391194907e-11
+ 2.5390625000000002e-05 4.7336545345906017e-11
+ 2.5402832031250001e-05 4.7390501665297362e-11
+ 2.54150390625e-05 4.7444442874197415e-11
+ 2.5427246093750002e-05 4.7498368976743532e-11
+ 2.5439453125e-05 4.7552279977110043e-11
+ 2.5451660156250002e-05 4.7606175879492929e-11
+ 2.5463867187500001e-05 4.76600566881005e-11
+ 2.547607421875e-05 4.771392240714795e-11
+ 2.5488281250000002e-05 4.7767773040854128e-11
+ 2.550048828125e-05 4.7821608593439534e-11
+ 2.5512695312500002e-05 4.7875429069125182e-11
+ 2.5524902343750001e-05 4.7929234472131972e-11
+ 2.5537109375e-05 4.7983024806680162e-11
+ 2.5549316406250002e-05 4.8036800076989225e-11
+ 2.55615234375e-05 4.8090560287277661e-11
+ 2.5573730468750002e-05 4.81443054417629e-11
+ 2.5585937500000001e-05 4.8198035544661283e-11
+ 2.559814453125e-05 4.8251750600188019e-11
+ 2.5610351562500002e-05 4.8305450612557161e-11
+ 2.562255859375e-05 4.835913558598157e-11
+ 2.5634765625000002e-05 4.8412805524672993e-11
+ 2.5646972656250001e-05 4.846646043284194e-11
+ 2.56591796875e-05 4.8520100314697792e-11
+ 2.5671386718750002e-05 4.8573725174448732e-11
+ 2.568359375e-05 4.8627335016301782e-11
+ 2.5695800781250002e-05 4.8680929844462761e-11
+ 2.5708007812500001e-05 4.8734509663136332e-11
+ 2.572021484375e-05 4.8788074476525962e-11
+ 2.5732421875000002e-05 4.8841624288833967e-11
+ 2.5744628906250001e-05 4.8895159104261467e-11
+ 2.5756835937500003e-05 4.894867892700839e-11
+ 2.5769042968750001e-05 4.9002183761273549e-11
+ 2.5781250000000003e-05 4.905567361125451e-11
+ 2.5793457031250002e-05 4.9109148481147716e-11
+ 2.5805664062500001e-05 4.9162608375148381e-11
+ 2.5817871093750003e-05 4.9216053297450589e-11
+ 2.5830078125000001e-05 4.9269483252247235e-11
+ 2.5842285156250003e-05 4.932289824373005e-11
+ 2.5854492187500002e-05 4.9376298276089576e-11
+ 2.5866699218750001e-05 4.9429683353515166e-11
+ 2.5878906250000003e-05 4.9483053480195042e-11
+ 2.5891113281250001e-05 4.9536408660316226e-11
+ 2.5903320312500003e-05 4.9589748898064572e-11
+ 2.5915527343750002e-05 4.9643074197624777e-11
+ 2.5927734375000001e-05 4.9696384563180337e-11
+ 2.5939941406250003e-05 4.9749679998913594e-11
+ 2.5952148437500001e-05 4.980296050900572e-11
+ 2.5964355468750003e-05 4.9856226097636712e-11
+ 2.5976562500000002e-05 4.99094767689854e-11
+ 2.5988769531250001e-05 4.9962712527229435e-11
+ 2.6000976562500003e-05 5.0015933376545304e-11
+ 2.6013183593750001e-05 5.0069139321108297e-11
+ 2.6025390625e-05 5.0122330365092602e-11
+ 2.6037597656250002e-05 5.0175506512671175e-11
+ 2.6049804687500001e-05 5.0228667768015851e-11
+ 2.6062011718750003e-05 5.0281814135297241e-11
+ 2.6074218750000001e-05 5.0334945618684835e-11
+ 2.608642578125e-05 5.0388062222346936e-11
+ 2.6098632812500002e-05 5.0441163950450669e-11
+ 2.6110839843750001e-05 5.0494250807162017e-11
+ 2.6123046875000003e-05 5.0547322796645784e-11
+ 2.6135253906250002e-05 5.060037992306559e-11
+ 2.61474609375e-05 5.0653422190583924e-11
+ 2.6159667968750002e-05 5.0706449603362099e-11
+ 2.6171875000000001e-05 5.0759462165560252e-11
+ 2.618408203125e-05 5.0812459881337356e-11
+ 2.6196289062500002e-05 5.086544275485121e-11
+ 2.620849609375e-05 5.0918410790258479e-11
+ 2.6220703124999999e-05 5.0971363991714641e-11
+ 2.6232910156250001e-05 5.1024302363374004e-11
+ 2.62451171875e-05 5.1077225909389738e-11
+ 2.6257324218750002e-05 5.1130134633913832e-11
+ 2.626953125e-05 5.1183028541097097e-11
+ 2.6281738281249999e-05 5.123590763508922e-11
+ 2.6293945312500001e-05 5.1288771920038706e-11
+ 2.630615234375e-05 5.1341621400092889e-11
+ 2.6318359375000002e-05 5.1394456079397949e-11
+ 2.633056640625e-05 5.1447275962098919e-11
+ 2.6342773437499999e-05 5.1500081052339658e-11
+ 2.6354980468750001e-05 5.1552871354262853e-11
+ 2.63671875e-05 5.1605646872010057e-11
+ 2.6379394531249998e-05 5.1658407609721638e-11
+ 2.63916015625e-05 5.171115357153682e-11
+ 2.6403808593749999e-05 5.1763884761593666e-11
+ 2.6416015624999998e-05 5.1816601184029079e-11
+ 2.642822265625e-05 5.1869302842978788e-11
+ 2.6440429687499998e-05 5.1921989742577379e-11
+ 2.645263671875e-05 5.1974661886958285e-11
+ 2.6464843749999999e-05 5.2027319280253771e-11
+ 2.6477050781249998e-05 5.2079961926594946e-11
+ 2.64892578125e-05 5.2132589830111786e-11
+ 2.6501464843749998e-05 5.2185202994933079e-11
+ 2.6513671875000001e-05 5.2237801425186463e-11
+ 2.6525878906249999e-05 5.2290385124998426e-11
+ 2.6538085937499998e-05 5.2342954098494298e-11
+ 2.655029296875e-05 5.2395508349798247e-11
+ 2.6562499999999999e-05 5.2448047883033309e-11
+ 2.6574707031249997e-05 5.2500572702321331e-11
+ 2.6586914062499999e-05 5.2553082811783024e-11
+ 2.6599121093749998e-05 5.260557821553798e-11
+ 2.6611328124999997e-05 5.265805891770455e-11
+ 2.6623535156249999e-05 5.2710524922400013e-11
+ 2.6635742187499997e-05 5.2762976233740464e-11
+ 2.6647949218749999e-05 5.281541285584085e-11
+ 2.6660156249999998e-05 5.2867834792814952e-11
+ 2.6672363281249997e-05 5.2920242048775429e-11
+ 2.6684570312499999e-05 5.297263462783375e-11
+ 2.6696777343749997e-05 5.3025012534100265e-11
+ 2.6708984374999999e-05 5.3077375771684144e-11
+ 2.6721191406249998e-05 5.3129724344693429e-11
+ 2.6733398437499997e-05 5.3182058257235008e-11
+ 2.6745605468749999e-05 5.3234377513414598e-11
+ 2.6757812499999997e-05 5.3286682117336819e-11
+ 2.6770019531249996e-05 5.3338972073105086e-11
+ 2.6782226562499998e-05 5.339124738482168e-11
+ 2.6794433593749997e-05 5.3443508056587737e-11
+ 2.6806640624999995e-05 5.349575409250326e-11
+ 2.6818847656249997e-05 5.3547985496667078e-11
+ 2.6831054687499996e-05 5.3600202273176877e-11
+ 2.6843261718749998e-05 5.3652404426129203e-11
+ 2.6855468749999997e-05 5.3704591959619454e-11
+ 2.6867675781249995e-05 5.3756764877741888e-11
+ 2.6879882812499997e-05 5.3808923184589598e-11
+ 2.6892089843749996e-05 5.3861066884254534e-11
+ 2.6904296874999998e-05 5.3913195980827531e-11
+ 2.6916503906249997e-05 5.3965310478398236e-11
+ 2.6928710937499995e-05 5.4017410381055188e-11
+ 2.6940917968749998e-05 5.4069495692885746e-11
+ 2.6953124999999996e-05 5.4121566417976143e-11
+ 2.6965332031249995e-05 5.4173622560411455e-11
+ 2.6977539062499997e-05 5.4225664124275648e-11
+ 2.6989746093749996e-05 5.4277691113651499e-11
+ 2.7001953124999994e-05 5.4329703532620677e-11
+ 2.7014160156249996e-05 5.4381701385263697e-11
+ 2.7026367187499995e-05 5.4433684675659917e-11
+ 2.7038574218749997e-05 5.4485653407887576e-11
+ 2.7050781249999996e-05 5.4537607586023745e-11
+ 2.7062988281249994e-05 5.4589547214144361e-11
+ 2.7075195312499996e-05 5.4641472296324253e-11
+ 2.7087402343749995e-05 5.4693382836637059e-11
+ 2.7099609374999997e-05 5.4745278839155299e-11
+ 2.7111816406249996e-05 5.4797160307950356e-11
+ 2.7124023437499994e-05 5.4849027247092475e-11
+ 2.7136230468749996e-05 5.4900879660650734e-11
+ 2.7148437499999995e-05 5.4952717552693121e-11
+ 2.7160644531249994e-05 5.5004540927286431e-11
+ 2.7172851562499996e-05 5.5055228596414379e-11
+ 2.7185058593749994e-05 5.510627065877697e-11
+ 2.7197265624999993e-05 5.5158092921228189e-11
+ 2.7209472656249995e-05 5.5210849104087091e-11
+ 2.7221679687499994e-05 5.5264521350196526e-11
+ 2.7233886718749996e-05 5.5318219478297029e-11
+ 2.7239990234374995e-05 5.5343709041866146e-11
+ 2.7246093749999994e-05 5.5365175813779936e-11
+ 2.7249145507812494e-05 5.537183500008943e-11
+ 2.7252197265624994e-05 5.5371668509114686e-11
+ 2.7255249023437493e-05 5.5354771851498252e-11
+ 2.7256606790774085e-05 5.5334751403020664e-11
+ 2.7256998216660861e-05 5.5326313558461538e-11
+ 2.7257389642547638e-05 5.5316205768572161e-11
+ 2.7258368207264573e-05 5.5280832763072969e-11
+ 2.7259409502908187e-05 5.5216998316807767e-11
+ 2.7259970598735323e-05 5.5162661637241072e-11
+ 2.7260339629298368e-05 5.5114439869388932e-11
+ 2.7261110323815844e-05 5.4960015216721681e-11
+ 2.726174148123385e-05 5.4732817211499076e-11
+ 2.7262113084009009e-05 5.4516300482441227e-11
+ 2.726243419379579e-05 5.42419953316085e-11
+ 2.7262647097925412e-05 5.400886072195258e-11
+ 2.7262860002055034e-05 5.3774257755821461e-11
+ 2.7264989043351245e-05 5.1549852354822979e-11
+ 2.7277196074601244e-05 4.2855387214314058e-11
+ 2.7289403105851246e-05 4.053247294954365e-11
+ 2.7301610137101244e-05 4.3931039996784842e-11
+ 2.7313817168351243e-05 5.2388572167819672e-11
+ 2.7326024199601245e-05 6.5140225940715896e-11
+ 2.7338231230851244e-05 8.1286621114128428e-11
+ 2.7350438262101246e-05 9.9800201152591339e-11
+ 2.7362645293351245e-05 1.1955731974057662e-10
+ 2.7374852324601243e-05 1.3938677731239894e-10
+ 2.7387059355851245e-05 1.581275910662053e-10
+ 2.7399266387101244e-05 1.7469004130247602e-10
+ 2.7411473418351246e-05 1.881149150311095e-10
+ 2.7423680449601245e-05 1.9762660690176225e-10
+ 2.7435887480851243e-05 2.026764694324815e-10
+ 2.7448094512101245e-05 2.0297359093770258e-10
+ 2.7460301543351244e-05 1.9850103705845601e-10
+ 2.7472508574601243e-05 1.8951650785639057e-10
+ 2.7484715605851245e-05 1.7653730627935789e-10
+ 2.7496922637101243e-05 1.6031044421422816e-10
+ 2.7509129668351242e-05 1.4176958358946107e-10
+ 2.7521336699601244e-05 1.2198127662112241e-10
+ 2.7533543730851243e-05 1.0208359001036545e-10
+ 2.7545750762101245e-05 8.3220638681385549e-11
+ 2.7557957793351243e-05 6.6476791169901555e-11
+ 2.7561009551163743e-05 6.2738216402259133e-11
+ 2.7561314726944995e-05 6.2375524734021021e-11
+ 2.7562077666398118e-05 6.1477937832984702e-11
+ 2.756245913612468e-05 6.1034090082773124e-11
+ 2.7562482977982591e-05 6.1006459924724939e-11
+ 2.7562487746354174e-05 6.1000935454857881e-11
+ 2.7562497283097335e-05 6.0989888077255491e-11
+ 2.756249804603679e-05 6.0989004377034889e-11
+ 2.7562499571915697e-05 6.0987237016591268e-11
+ 2.7562499693986009e-05 6.0987095630059761e-11
+ 2.7562499938126634e-05 6.0986812858020706e-11
+ 2.7562499957657883e-05 6.0986790236316644e-11
+ 2.7562499996720382e-05 6.098674499293473e-11
+ 2.7562500074845382e-05 6.2330481534674083e-11
+ 2.7562500152970382e-05 6.6608198187672893e-11
+ 2.7562500934220379e-05 2.7075208822833839e-10
+ 2.7562508051845976e-05 1.5641542586395462e-08
+ 2.7562515169471571e-05 5.5354276368357439e-08
+ 2.7562522287097168e-05 1.1939590331347595e-07
+ 2.7562529404722766e-05 2.0774988808958391e-07
+ 2.756253652234836e-05 3.2039621340029153e-07
+ 2.7562543639973958e-05 4.5731138406416947e-07
+ 2.7562550757599552e-05 6.1846843192454422e-07
+ 2.756255787522515e-05 8.0383692158836119e-07
+ 2.7562564992850747e-05 1.0133829569922963e-06
+ 2.7562572110476342e-05 1.2470691887940203e-06
+ 2.7562579228101939e-05 1.5048548225862434e-06
+ 2.7562587807568571e-05 1.8475543476526228e-06
+ 2.7562596387035203e-05 2.2251205386231599e-06
+ 2.7562604966501835e-05 2.637462112110794e-06
+ 2.7562613545968467e-05 3.0844806091734263e-06
+ 2.75626221254351e-05 3.5660704276185103e-06
+ 2.7562630704901732e-05 4.0821188567621002e-06
+ 2.7562639284368364e-05 4.6325061146258863e-06
+ 2.7562647863834996e-05 5.2171053875545835e-06
+ 2.7562658180770253e-05 5.965211217502911e-06
+ 2.7562668497705506e-05 6.7623492313414161e-06
+ 2.756267881464076e-05 7.6082590651614992e-06
+ 2.7562689131576017e-05 8.5026660760363497e-06
+ 2.7562699448511274e-05 9.4452814742207388e-06
+ 2.7562709765446528e-05 1.0435802462230257e-05
+ 2.7562720082381782e-05 1.147391238070454e-05
+ 2.7562730399317039e-05 1.25592808609545e-05
+ 2.7562742902012258e-05 1.393744004677843e-05
+ 2.7562755404707477e-05 1.538385928477854e-05
+ 2.7562767907402696e-05 1.6897871760843825e-05
+ 2.7562780410097918e-05 1.8478782715895571e-05
+ 2.7562792912793137e-05 2.0125869935940648e-05
+ 2.7562805415488356e-05 2.1838384260846487e-05
+ 2.7562817918183576e-05 2.3615550111329756e-05
+ 2.7562830420878795e-05 2.5456566033633845e-05
+ 2.7562845592253876e-05 2.7775100207116592e-05
+ 2.7562860763628954e-05 3.0184906039223483e-05
+ 2.7562875935004032e-05 3.2684405463249104e-05
+ 2.7562891106379114e-05 3.5271969973378807e-05
+ 2.7562906277754195e-05 3.7945922288216153e-05
+ 2.7562921449129274e-05 4.0704538058428326e-05
+ 2.7562936620504352e-05 4.3546047616054653e-05
+ 2.7562954860519559e-05 4.7069469432613542e-05
+ 2.7562973100534767e-05 5.0706855826657106e-05
+ 2.7562991340549975e-05 5.4454893918205257e-05
+ 2.7563009580565183e-05 5.8310193146384224e-05
+ 2.756302782058039e-05 6.2269290123695639e-05
+ 2.7563046060595598e-05 6.6328653564053143e-05
+ 2.7563068199865846e-05 7.1385338233594827e-05
+ 2.7563090339136095e-05 7.6577901326810804e-05
+ 2.7563112478406343e-05 8.189969012601315e-05
+ 2.7563134617676591e-05 8.7343953274172687e-05
+ 2.7563161293011316e-05 9.4056657818521804e-05
+ 2.7563187873095807e-05 0.00010090035482762358
+ 2.7563214453180298e-05 0.00010788664307091889
+ 2.756324868848434e-05 0.00011707548567577072
+ 2.7563282923788384e-05 0.00012645461865043843
+ 2.7563315356127049e-05 0.00013549167951766453
+ 2.7563347788465711e-05 0.00014465398332574899
+ 2.7563380220804376e-05 0.00015391958689944246
+ 2.756341265314304e-05 0.00016326679416820027
+ 2.7563445085481702e-05 0.00017267423453976973
+ 2.7563477517820367e-05 0.00018212093762926101
+ 2.7563509950159028e-05 0.00019158640400330904
+ 2.7563542382497693e-05 0.00020105067163597072
+ 2.7563569584998145e-05 0.00020897371829601134
+ 2.75635967874986e-05 0.00021687121736840308
+ 2.7563623989999055e-05 0.0002247324443841368
+ 2.7563651192499507e-05 0.00023254704172942061
+ 2.7563678394999959e-05 0.00024030503688061725
+ 2.7563705597500414e-05 0.00024799685880477063
+ 2.756373280000087e-05 0.00025561335251051022
+ 2.7563760002501321e-05 0.00026314579174345146
+ 2.7563787205001773e-05 0.00027058588982929906
+ 2.7563814407502228e-05 0.00027792580867665878
+ 2.7563841610002684e-05 0.0002851581659600263
+ 2.7563868812503135e-05 0.00029227604051150784
+ 2.7563896015003587e-05 0.00029927297595749906
+ 2.7563923217504043e-05 0.00030614298264376868
+ 2.7563950420004498e-05 0.00031288053789913813
+ 2.756397762250495e-05 0.00031948058469418605
+ 2.7564004825005401e-05 0.00032593852875712024
+ 2.7564032027505857e-05 0.00033225023421413059
+ 2.7564059230006312e-05 0.00033841201782615327
+ 2.7564086432506764e-05 0.0003444206418985982
+ 2.7564115300883498e-05 0.00035062659892727544
+ 2.7564144169260232e-05 0.0003566540934654631
+ 2.7564173037636969e-05 0.00036250083298786399
+ 2.7564201906013704e-05 0.00036816503744223664
+ 2.7564230774390438e-05 0.00037364542226806104
+ 2.7564259642767175e-05 0.00037894118026981165
+ 2.7564288511143909e-05 0.00038405196247931109
+ 2.7564317379520643e-05 0.000388977858140999
+ 2.7564346247897377e-05 0.00039371937395252178
+ 2.7564381135166683e-05 0.0003992047348763101
+ 2.7564416022435989e-05 0.00040442447430172904
+ 2.756444998550605e-05 0.00040925368585940502
+ 2.7564483948576114e-05 0.00041383750344981278
+ 2.7564517911646176e-05 0.00041817993390062743
+ 2.756455187471624e-05 0.00042228549548244641
+ 2.7564585837786301e-05 0.00042615916749456922
+ 2.7564627381082817e-05 0.0004305900119691504
+ 2.7564668924379334e-05 0.00043469258490726371
+ 2.756471046767585e-05 0.0004384781612780042
+ 2.7564752010972366e-05 0.00044195857402361564
+ 2.7564802322523098e-05 0.00044578261210212054
+ 2.7564853125173637e-05 0.00044923093231022854
+ 2.7564903927824172e-05 0.00045228765276156626
+ 2.7564971607266247e-05 0.00045579239535176001
+ 2.7565039286708321e-05 0.00045870005395461338
+ 2.7565091919396568e-05 0.00046058369469111949
+ 2.7565144552084811e-05 0.00046216451732223918
+ 2.7565197184773058e-05 0.00046346681282214352
+ 2.7565249817461301e-05 0.00046451393123718372
+ 2.7565297809929103e-05 0.00046526519657479943
+ 2.7565345802396908e-05 0.00046583893527304737
+ 2.7565393794864709e-05 0.00046625041073407677
+ 2.7565441787332511e-05 0.00046651403875466578
+ 2.7565489779800316e-05 0.0004666433740508164
+ 2.7565537261554863e-05 0.00046665162291553914
+ 2.7565584743309415e-05 0.000466552308242554
+ 2.7565632225063962e-05 0.00046635608374731292
+ 2.756567970681851e-05 0.00046607281339991539
+ 2.7565727188573061e-05 0.00046571159614456351
+ 2.7565774670327609e-05 0.00046528079492301239
+ 2.7565824358583367e-05 0.00046476378468933915
+ 2.7565874046839122e-05 0.00046418694952370777
+ 2.756592373509488e-05 0.00046355752837163748
+ 2.7565973423350638e-05 0.00046288205221083837
+ 2.7566023111606392e-05 0.00046216639229460844
+ 2.756607279986215e-05 0.00046141580830294233
+ 2.7566127951386076e-05 0.00046054748419045071
+ 2.7566183102910001e-05 0.00045964758393211987
+ 2.756623825443393e-05 0.00045872107390199996
+ 2.7566293405957855e-05 0.00045777228079549998
+ 2.756634855748178e-05 0.00045680495887963081
+ 2.7566411640520539e-05 0.000455679953428722
+ 2.7566474723559298e-05 0.00045453907391423655
+ 2.7566537806598056e-05 0.0004533857886546739
+ 2.7566600889636815e-05 0.00045222299034028662
+ 2.7566674140146426e-05 0.00045086399130210022
+ 2.7566747390656037e-05 0.00044949844535668453
+ 2.7566820641165645e-05 0.00044812878579885432
+ 2.7566905619421583e-05 0.00044653719761490697
+ 2.7566990597677525e-05 0.0004449449586312652
+ 2.7567093836844784e-05 0.00044301214871122791
+ 2.7567198171769415e-05 0.00044106269601017851
+ 2.7567302506694043e-05 0.00043911870626636078
+ 2.7567426664469165e-05 0.00043681393387383496
+ 2.7567550822244288e-05 0.00043451951813961668
+ 2.7567705800806531e-05 0.00043167106196547318
+ 2.7567884937131788e-05 0.00042840086834201771
+ 2.7568098556602391e-05 0.00042453293757745131
+ 2.7568364485722953e-05 0.00041976628303681877
+ 2.7568717982712205e-05 0.00041351261779238365
+ 2.7569242097564147e-05 0.00040441158298440465
+ 2.7570136340120477e-05 0.00038934346113524376
+ 2.7572132807185035e-05 0.00035769765454050228
+ 2.7573988816858016e-05 0.00033058981538904275
+ 2.7576421668443081e-05 0.00029814348467284587
+ 2.7578854520028145e-05 0.00026888165874455468
+ 2.7581287371613206e-05 0.00024249178888257299
+ 2.758372022319827e-05 0.00021869200206866874
+ 2.7586153074783334e-05 0.00019722808975099272
+ 2.7588585926368399e-05 0.00017787079297825666
+ 2.759101877795346e-05 0.00016041335425741158
+ 2.7593451629538524e-05 0.0001446693086575522
+ 2.7595767705239782e-05 0.00013111903917235234
+ 2.759881944040672e-05 0.00011518312547724692
+ 2.7601871175573658e-05 0.00010118403045864018
+ 2.7604922910740597e-05 8.8886357108097517e-05
+ 2.7607974645907535e-05 7.8083318131395906e-05
+ 2.7611026381074473e-05 6.8593258842393536e-05
+ 2.7614078116241411e-05 6.025660181923537e-05
+ 2.7617773618773598e-05 5.1505809187250614e-05
+ 2.762113428861091e-05 4.4656271026532631e-05
+ 2.7624494958448219e-05 3.8717628008379948e-05
+ 2.7628620731690278e-05 3.2495702272495222e-05
+ 2.7632746504932338e-05 2.7273646663031209e-05
+ 2.7636872278174398e-05 2.2890780980831938e-05
+ 2.7640998051416455e-05 1.9212246512347876e-05
+ 2.7645123824658515e-05 1.6124856494297113e-05
+ 2.7650251138437098e-05 1.2970141364146993e-05
+ 2.7655378452215681e-05 1.0432633172092827e-05
+ 2.766050576599426e-05 8.3915781182774641e-06
+ 2.7665633079772843e-05 6.7498471833962207e-06
+ 2.7671995979825154e-05 5.1518189724579756e-06
+ 2.767835887987746e-05 3.9321378049054371e-06
+ 2.7684721779929771e-05 3.0012267671564931e-06
+ 2.7692497256254512e-05 2.15737185496337e-06
+ 2.7700272732579253e-05 1.5508026051292012e-06
+ 2.7708048208903994e-05 1.1147960586695601e-06
+ 2.7717983441936067e-05 7.3118840550782522e-07
+ 2.7727918674968143e-05 4.7961075194826108e-07
+ 2.7740125706218142e-05 2.8571159964289929e-07
+ 2.7752332737468144e-05 1.7024209705967684e-07
+ 2.7764539768718143e-05 1.0147848625806179e-07
+ 2.7776746799968141e-05 6.0528851952355526e-08
+ 2.7788953831218143e-05 3.6142806128821739e-08
+ 2.7801160862468142e-05 2.1620593980565466e-08
+ 2.7813367893718141e-05 1.2972424953734794e-08
+ 2.7825574924968143e-05 7.8223266739669589e-09
+ 2.7837781956218141e-05 4.7553755500354248e-09
+ 2.7849988987468143e-05 2.9289656540459339e-09
+ 2.7862196018718142e-05 1.8413143839828223e-09
+ 2.7874403049968141e-05 1.1936037658401295e-09
+ 2.7886610081218143e-05 8.078836241498485e-10
+ 2.7898817112468141e-05 5.7818218790680653e-10
+ 2.7911024143718143e-05 4.4139192644487092e-10
+ 2.7923231174968142e-05 3.5993152647751398e-10
+ 2.7935438206218141e-05 3.1142080027758294e-10
+ 2.7947645237468143e-05 2.8253202431124535e-10
+ 2.7959852268718141e-05 2.653283707170538e-10
+ 2.797205929996814e-05 2.5508336753526945e-10
+ 2.7984266331218142e-05 2.4898233649178344e-10
+ 2.7996473362468141e-05 2.4534909287155193e-10
+ 2.8008680393718139e-05 2.4318544696123555e-10
+ 2.8020887424968142e-05 2.4189696683490067e-10
+ 2.803309445621814e-05 2.411296605642883e-10
+ 2.8045301487468142e-05 2.406727199550333e-10
+ 2.8057508518718141e-05 2.4040060549918595e-10
+ 2.806971554996814e-05 2.4023855751768804e-10
+ 2.8081922581218142e-05 2.4014205601586099e-10
+ 2.809412961246814e-05 2.4008458822552009e-10
+ 2.8106336643718142e-05 2.4005036536744095e-10
+ 2.8118543674968141e-05 2.4002998505548136e-10
+ 2.813075070621814e-05 2.4001784836154639e-10
+ 2.8142957737468142e-05 2.4001062082534474e-10
+ 2.815516476871814e-05 2.4000631674323626e-10
+ 2.8167371799968139e-05 2.4000375361391963e-10
+ 2.8179578831218141e-05 2.4000222718017004e-10
+ 2.819178586246814e-05 2.4000131819356677e-10
+ 2.8203992893718138e-05 2.4000077702242996e-10
+ 2.821619992496814e-05 2.4000045459933931e-10
+ 2.8228406956218139e-05 2.4000026257884156e-10
+ 2.8240613987468141e-05 2.4000014832025053e-10
+ 2.825282101871814e-05 2.4000008023582484e-10
+ 2.8265028049968138e-05 2.4000003966625581e-10
+ 2.827723508121814e-05 2.400000155533385e-10
+ 2.8289442112468139e-05 2.4000000121814107e-10
+ 2.8301649143718141e-05 2.3999999261673205e-10
+ 2.831385617496814e-05 2.3999998758456908e-10
+ 2.8326063206218138e-05 2.3999998453222656e-10
+ 2.833827023746814e-05 2.3999998265390494e-10
+ 2.8350477268718139e-05 2.3999998161732485e-10
+ 2.8362684299968138e-05 2.3999998104358188e-10
+ 2.837489133121814e-05 2.3999998057389865e-10
+ 2.8387098362468138e-05 2.3999998026292464e-10
+ 2.8399305393718137e-05 2.3999998019001177e-10
+ 2.8411512424968139e-05 2.3999998019899801e-10
+ 2.8423719456218138e-05 2.3999998020597388e-10
+ 2.843592648746814e-05 2.3999998012855701e-10
+ 2.8448133518718138e-05 2.3999998005534517e-10
+ 2.8460340549968137e-05 2.3999998008389102e-10
+ 2.8472547581218139e-05 2.3999998009224399e-10
+ 2.8484754612468138e-05 2.3999998012219294e-10
+ 2.849696164371814e-05 2.3999998013282356e-10
+ 2.8509168674968139e-05 2.3999998009115475e-10
+ 2.8521375706218137e-05 2.3999998009706464e-10
+ 2.8533582737468139e-05 2.3999998010363494e-10
+ 2.8545789768718138e-05 2.3999998011314167e-10
+ 2.8557996799968137e-05 2.3999998013616955e-10
+ 2.8570203831218139e-05 2.3999998011363462e-10
+ 2.8582410862468137e-05 2.3999998009274014e-10
+ 2.8594617893718136e-05 2.399999801011231e-10
+ 2.8606824924968138e-05 2.399999800977465e-10
+ 2.8619031956218137e-05 2.3999998010717031e-10
+ 2.8631238987468139e-05 2.3999998026497155e-10
+ 2.8643446018718137e-05 2.3999998018940695e-10
+ 2.8655653049968136e-05 2.399999801489314e-10
+ 2.8667860081218138e-05 2.3999998016252337e-10
+ 2.8680067112468137e-05 2.3999998017736873e-10
+ 2.8692274143718139e-05 2.3999998008841631e-10
+ 2.8704481174968137e-05 2.399999801406156e-10
+ 2.8716688206218136e-05 2.3999998027111368e-10
+ 2.8728895237468138e-05 2.399999803096209e-10
+ 2.8741102268718137e-05 2.399999801745041e-10
+ 2.8753309299968135e-05 2.3999998014351678e-10
+ 2.8765516331218137e-05 2.399999802735929e-10
+ 2.8777723362468136e-05 2.3999998026179471e-10
+ 2.8789930393718135e-05 2.3999998016976751e-10
+ 2.8802137424968137e-05 2.3999998022820648e-10
+ 2.8814344456218135e-05 2.3999998018386391e-10
+ 2.8826551487468137e-05 2.3999998024457121e-10
+ 2.8838758518718136e-05 2.399999802712344e-10
+ 2.8850965549968138e-05 2.3999998016906244e-10
+ 2.8863172581218137e-05 2.399999802251944e-10
+ 2.8875379612468139e-05 2.3999998029674961e-10
+ 2.8887586643718138e-05 2.3999998024490881e-10
+ 2.889979367496814e-05 2.3999998022841694e-10
+ 2.8912000706218138e-05 2.3999998027402318e-10
+ 2.892420773746814e-05 2.3999998031284179e-10
+ 2.8936414768718139e-05 2.3999998024592236e-10
+ 2.8948621799968141e-05 2.3999998028900653e-10
+ 2.896082883121814e-05 2.3999998029018118e-10
+ 2.8973035862468142e-05 2.3999998020407995e-10
+ 2.898524289371814e-05 2.3999998030027903e-10
+ 2.8997449924968142e-05 2.3999998034659856e-10
+ 2.9009656956218141e-05 2.3999998035710371e-10
+ 2.9021863987468143e-05 2.3999998035781327e-10
+ 2.9034071018718142e-05 2.3999998028429372e-10
+ 2.9046278049968144e-05 2.3999998026462584e-10
+ 2.9058485081218142e-05 2.3999998034401652e-10
+ 2.9070692112468144e-05 2.3999998040748526e-10
+ 2.9082899143718143e-05 2.399999802904164e-10
+ 2.9095106174968145e-05 2.3999998026488739e-10
+ 2.9107313206218144e-05 2.399999803948264e-10
+ 2.9119520237468146e-05 2.399999803901337e-10
+ 2.9131727268718145e-05 2.3999998030809217e-10
+ 2.9143934299968147e-05 2.3999998036169063e-10
+ 2.9156141331218145e-05 2.3999998033495331e-10
+ 2.9168348362468147e-05 2.3999998039429674e-10
+ 2.9180555393718146e-05 2.3999998043834603e-10
+ 2.9192762424968148e-05 2.3999998042747548e-10
+ 2.9204969456218147e-05 2.3999998033813589e-10
+ 2.9217176487468149e-05 2.3999998042749197e-10
+ 2.9229383518718147e-05 2.3999998045576412e-10
+ 2.9241590549968149e-05 2.3999998040668088e-10
+ 2.9253797581218148e-05 2.3999998041015307e-10
+ 2.926600461246815e-05 2.3999998038280188e-10
+ 2.9278211643718149e-05 2.399999804963409e-10
+ 2.9290418674968151e-05 2.3999998050724164e-10
+ 2.9302625706218149e-05 2.3999998043757132e-10
+ 2.9314832737468151e-05 2.3999998042873677e-10
+ 2.932703976871815e-05 2.3999998048062938e-10
+ 2.9339246799968152e-05 2.3999998046244087e-10
+ 2.9351453831218151e-05 2.3999998047367506e-10
+ 2.9363660862468153e-05 2.3999998045481209e-10
+ 2.9375867893718152e-05 2.3999998043752122e-10
+ 2.9388074924968154e-05 2.3999998042446345e-10
+ 2.9400281956218152e-05 2.3999998041722252e-10
+ 2.9412488987468154e-05 2.3999998041674074e-10
+ 2.9424696018718153e-05 2.3999998042357827e-10
+ 2.9436903049968155e-05 2.3999998043806778e-10
+ 2.9449110081218154e-05 2.3999998047660411e-10
+ 2.9461317112468156e-05 2.3999998051655456e-10
+ 2.9473524143718154e-05 2.3999998052591767e-10
+ 2.9485731174968156e-05 2.3999998048427911e-10
+ 2.9497938206218155e-05 2.3999998054712477e-10
+ 2.9510145237468157e-05 2.3999998057013456e-10
+ 2.9522352268718156e-05 2.3999998051176627e-10
+ 2.9534559299968158e-05 2.3999998057450993e-10
+ 2.9546766331218156e-05 2.3999998053652084e-10
+ 2.9558973362468158e-05 2.3999998056705243e-10
+ 2.9571180393718157e-05 2.399999805326457e-10
+ 2.9583387424968159e-05 2.399999805718764e-10
+ 2.9595594456218158e-05 2.3999998054921403e-10
+ 2.960780148746816e-05 2.3999998061819825e-10
+ 2.9620008518718159e-05 2.399999805688973e-10
+ 2.9632215549968161e-05 2.3999998054792621e-10
+ 2.9644422581218159e-05 2.39999980627754e-10
+ 2.9656629612468161e-05 2.3999998059474422e-10
+ 2.966883664371816e-05 2.399999805933057e-10
+ 2.9681043674968162e-05 2.3999998057922352e-10
+ 2.9693250706218161e-05 2.3999998056088616e-10
+ 2.9705457737468163e-05 2.3999998058786213e-10
+ 2.9717664768718161e-05 2.399999806005213e-10
+ 2.9729871799968163e-05 2.3999998060792622e-10
+ 2.9742078831218162e-05 2.3999998061547279e-10
+ 2.9754285862468164e-05 2.3999998062637359e-10
+ 2.9766492893718163e-05 2.3999998064254068e-10
+ 2.9778699924968165e-05 2.399999806651119e-10
+ 2.9790906956218163e-05 2.3999998065019003e-10
+ 2.9803113987468165e-05 2.3999998066078063e-10
+ 2.9815321018718164e-05 2.399999807158811e-10
+ 2.9827528049968166e-05 2.3999998065933043e-10
+ 2.9839735081218165e-05 2.3999998069949765e-10
+ 2.9851942112468167e-05 2.3999998071137632e-10
+ 2.9864149143718166e-05 2.3999998066492584e-10
+ 2.9876356174968168e-05 2.3999998067631891e-10
+ 2.9888563206218166e-05 2.3999998068067386e-10
+ 2.9900770237468168e-05 2.3999998072884115e-10
+ 2.9912977268718167e-05 2.3999998071703879e-10
+ 2.9925184299968169e-05 2.399999807620995e-10
+ 2.9937391331218168e-05 2.3999998071038665e-10
+ 2.994959836246817e-05 2.3999998068359319e-10
+ 2.9961805393718168e-05 2.3999998073934671e-10
+ 2.997401242496817e-05 2.3999998074833904e-10
+ 2.9986219456218169e-05 2.3999998072288318e-10
+ 2.9998426487468171e-05 2.3999998078919143e-10
+ 3.001063351871817e-05 2.3999998076965073e-10
+ 3.0022840549968172e-05 2.399999807468099e-10
+ 3.003504758121817e-05 2.3999998076982682e-10
+ 3.0047254612468172e-05 2.3999998077882701e-10
+ 3.0059461643718171e-05 2.3999998078272732e-10
+ 3.0071668674968173e-05 2.3999998077698307e-10
+ 3.0083875706218172e-05 2.3999998078844893e-10
+ 3.0096082737468174e-05 2.3999998080355428e-10
+ 3.0108289768718172e-05 2.3999998082407074e-10
+ 3.0120496799968175e-05 2.3999998085105249e-10
+ 3.0132703831218173e-05 2.3999998076975625e-10
+ 3.0144910862468175e-05 2.399999808033618e-10
+ 3.0157117893718174e-05 2.3999998080328762e-10
+ 3.0169324924968176e-05 2.3999998084082399e-10
+ 3.0181531956218175e-05 2.3999998077877215e-10
+ 3.0193738987468177e-05 2.3999998083679345e-10
+ 3.0205946018718175e-05 2.3999998087406507e-10
+ 3.0218153049968177e-05 2.3999998083776306e-10
+ 3.0230360081218176e-05 2.3999998086990843e-10
+ 3.0242567112468178e-05 2.3999998083702247e-10
+ 3.0254774143718177e-05 2.399999808776692e-10
+ 3.0266981174968179e-05 2.3999998085631119e-10
+ 3.0279188206218177e-05 2.3999998083949021e-10
+ 3.0291395237468179e-05 2.3999929577393646e-10
+ 3.0303602268718178e-05 2.3999721430085655e-10
+ 3.031580929996818e-05 2.3999541801853927e-10
+ 3.0328016331218179e-05 2.3999352441667849e-10
+ 3.0340223362468181e-05 2.3998998231508299e-10
+ 3.0352430393718179e-05 2.3998269751518182e-10
+ 3.0364637424968182e-05 2.3996731785187146e-10
+ 3.0370740940593181e-05 2.3994983464395233e-10
+ 3.037684445621818e-05 2.3990674100743305e-10
+ 3.0379896214030683e-05 2.3985615585153402e-10
+ 3.0382947971843183e-05 2.3973456609508262e-10
+ 3.0384473850749429e-05 2.3959023649420816e-10
+ 3.0385999729655683e-05 2.3924487360909957e-10
+ 3.0386991106889186e-05 2.3866252493064795e-10
+ 3.0387269733896242e-05 2.3836567845599657e-10
+ 3.0387548360903301e-05 2.3795958755937176e-10
+ 3.038809883562797e-05 2.3707317678626589e-10
+ 3.0390875273912436e-05 2.3289947932096134e-10
+ 3.0403082305162435e-05 2.1857108082062022e-10
+ 3.0415289336412437e-05 2.0744394567167327e-10
+ 3.0427496367662439e-05 1.9657101424192844e-10
+ 3.0439703398912437e-05 1.8444183633608339e-10
+ 3.0451910430162436e-05 1.7048236032410772e-10
+ 3.0464117461412438e-05 1.5473832156939622e-10
+ 3.047632449266244e-05 1.376643966131987e-10
+ 3.0488531523912439e-05 1.1997405552563603e-10
+ 3.0500738555162437e-05 1.0252468847149855e-10
+ 3.0512945586412439e-05 8.622433036431135e-11
+ 3.0525152617662442e-05 7.1953269034585456e-11
+ 3.053735964891244e-05 6.0497851486217764e-11
+ 3.0549566680162439e-05 5.2496010132610782e-11
+ 3.0561773711412438e-05 4.8395088933560857e-11
+ 3.0573980742662443e-05 4.8422873289603413e-11
+ 3.0586187773912442e-05 5.2572582289997926e-11
+ 3.059839480516244e-05 6.0602144636946106e-11
+ 3.0610601836412446e-05 7.2047475992215135e-11
+ 3.0622808867662444e-05 8.6248800170538565e-11
+ 3.0635015898912443e-05 1.0238838404643464e-10
+ 3.0647222930162442e-05 1.19537446121802e-10
+ 3.065942996141244e-05 1.367094991032434e-10
+ 3.0671636992662446e-05 1.5291703382970249e-10
+ 3.0683844023912444e-05 1.6722827017382802e-10
+ 3.0686895781724944e-05 1.7041028620342427e-10
+ 3.068704836961557e-05 1.7056469761267313e-10
+ 3.0687429839342132e-05 1.7094872387604414e-10
+ 3.0687467986314786e-05 1.7098696858623529e-10
+ 3.0687475615709319e-05 1.7099461407315297e-10
+ 3.0687490874498383e-05 1.7100990159048815e-10
+ 3.0687496978014005e-05 1.7101601530675094e-10
+ 3.0687499419420261e-05 1.7101846058671687e-10
+ 3.0687499604455787e-05 1.7101864591102341e-10
+ 3.068749997452684e-05 1.710190165576025e-10
+ 3.0687500714668945e-05 2.9362295535076986e-10
+ 3.0687501454811058e-05 6.7955376462053112e-10
+ 3.0687508856232148e-05 1.9019685483973129e-08
+ 3.0687516257653237e-05 6.3680162617685321e-08
+ 3.0687523659074327e-05 1.3464578979540883e-07
+ 3.0687531060495417e-05 2.3189729697639808e-07
+ 3.0687538461916507e-05 3.5541134357275011e-07
+ 3.068754751235569e-05 5.4209487018455778e-07
+ 3.0687556562794867e-05 7.6794744751962639e-07
+ 3.0687565613234051e-05 1.032901665904789e-06
+ 3.0687574663673228e-05 1.3368810846168448e-06
+ 3.0687583714112411e-05 1.6798002590529673e-06
+ 3.068759504453351e-05 2.1638522289015684e-06
+ 3.0687606374954608e-05 2.7085809274094572e-06
+ 3.0687617705375707e-05 3.3137595140903088e-06
+ 3.0687629035796805e-05 3.9791394372703589e-06
+ 3.068764321465336e-05 4.8961848891924115e-06
+ 3.0687657393509915e-05 5.9065041934527361e-06
+ 3.068767157236647e-05 7.0094688242501652e-06
+ 3.0687689032396934e-05 8.4939484121898285e-06
+ 3.0687706492427399e-05 1.011650368403691e-05
+ 3.0687723952457863e-05 1.187564441966631e-05
+ 3.0687746268477833e-05 1.4320324258348367e-05
+ 3.0687768584497803e-05 1.6981891243476683e-05
+ 3.0687790900517773e-05 1.9856448881756975e-05
+ 3.0687819090217242e-05 2.3785542948120637e-05
+ 3.0687847279916711e-05 2.8038794641957824e-05
+ 3.068787546961618e-05 3.2606525910010655e-05
+ 3.068790365931565e-05 3.7478440563006991e-05
+ 3.0687931849015119e-05 4.2643660624918842e-05
+ 3.0687960038714595e-05 4.809076449946518e-05
+ 3.0687988228414064e-05 5.3807826764352856e-05
+ 3.0688019414106473e-05 6.0432058501488789e-05
+ 3.0688050599798882e-05 6.7354141141263776e-05
+ 3.0688081785491297e-05 7.4556149339010216e-05
+ 3.0688112971183706e-05 8.2019674226669682e-05
+ 3.0688150418414339e-05 9.1300740447793598e-05
+ 3.0688187865644965e-05 0.00010089852928503813
+ 3.0688225312875597e-05 0.00011077933330704341
+ 3.0688270844195807e-05 0.00012312530862772575
+ 3.0688316375516024e-05 0.00013577798574481139
+ 3.0688361906836234e-05 0.00014867616552750304
+ 3.0688407438156444e-05 0.00016175929991125412
+ 3.0688441084028109e-05 0.00017151113091571656
+ 3.0688474729899775e-05 0.00018130797963939794
+ 3.068850837577144e-05 0.00019112690048319055
+ 3.0688542021643106e-05 0.000200945563836072
+ 3.0688575667514771e-05 0.0002107423308290232
+ 3.0688609313386437e-05 0.00022049632214156449
+ 3.0688642959258102e-05 0.00023018748061678874
+ 3.0688676605129767e-05 0.00023979662749408118
+ 3.0688710251001433e-05 0.0002493055121224335
+ 3.068873687066815e-05 0.00025674620625396695
+ 3.068876349033486e-05 0.00026410519322842072
+ 3.0688790110001569e-05 0.00027137476557784006
+ 3.0688816729668279e-05 0.00027854762813939171
+ 3.0688843349334989e-05 0.00028561690431054267
+ 3.0688869969001699e-05 0.0002925761407342706
+ 3.0688896588668409e-05 0.0002994193104460534
+ 3.0688923208335126e-05 0.00030614081452042582
+ 3.0688949828001836e-05 0.00031273548226053464
+ 3.0688976447668546e-05 0.00031919856997935221
+ 3.0689003067335255e-05 0.00032552575842600295
+ 3.0689029687001965e-05 0.00033171314891500655
+ 3.0689056306668675e-05 0.00033775725822013397
+ 3.0689082926335385e-05 0.00034365501229800138
+ 3.0689109546002095e-05 0.00034940373890948994
+ 3.0689136165668805e-05 0.00035500115920957621
+ 3.0689162785335522e-05 0.00036044537837818884
+ 3.0689189405002232e-05 0.00036573487536628151
+ 3.0689216024668941e-05 0.00037086849183281574
+ 3.0689239404935231e-05 0.00037524816041470616
+ 3.0689262785201514e-05 0.00037950661982143294
+ 3.0689286165467804e-05 0.00038364373347733212
+ 3.0689309545734094e-05 0.00038765955240256639
+ 3.0689332926000384e-05 0.00039155430797307712
+ 3.0689356306266667e-05 0.00039532840450424615
+ 3.0689379686532957e-05 0.00039898241168751826
+ 3.0689403066799247e-05 0.00040251705690861332
+ 3.0689426447065537e-05 0.00040593321747524688
+ 3.068944982733182e-05 0.0004092319127814815
+ 3.068947320759811e-05 0.00041241429643495774
+ 3.06894965878644e-05 0.00041548164837231091
+ 3.068951996813069e-05 0.00041843536698707185
+ 3.0689543348396973e-05 0.00042127696129328835
+ 3.0689566728663263e-05 0.00042400804314699181
+ 3.0689590108929553e-05 0.00042663031954648096
+ 3.0689613489195843e-05 0.00042914558503120656
+ 3.0689636869462126e-05 0.00043155571419782471
+ 3.0689660249728416e-05 0.00043386265435075173
+ 3.0689683629994706e-05 0.0004360684183033
+ 3.0689707010260995e-05 0.00043817507734421687
+ 3.0689735591237516e-05 0.00044061881915944171
+ 3.0689764172214043e-05 0.00044292160557832261
+ 3.0689792753190564e-05 0.00044508748731897325
+ 3.0689821334167091e-05 0.0004471205811035718
+ 3.0689849915143611e-05 0.00044902505354874717
+ 3.068988619980621e-05 0.00045126415767136695
+ 3.0689925453373383e-05 0.00045347065125915753
+ 3.0689946977215262e-05 0.00045458914938144757
+ 3.0689973696714698e-05 0.00045589098737442259
+ 3.0690000416214134e-05 0.00045710004038524538
+ 3.069002713571357e-05 0.00045821970861944291
+ 3.0690053855213006e-05 0.00045925335947318648
+ 3.0690080574712442e-05 0.00046020432082601948
+ 3.0690107294211878e-05 0.00046107587487371744
+ 3.0690134013711314e-05 0.00046187125249194449
+ 3.0690160733210751e-05 0.00046259362811953432
+ 3.0690187452710187e-05 0.00046324611514856153
+ 3.0690214172209623e-05 0.00046383176180687778
+ 3.0690240891709059e-05 0.00046435354751746608
+ 3.0690262548859612e-05 0.00046473161709406521
+ 3.0690284206010166e-05 0.00046507115570231151
+ 3.0690305863160719e-05 0.00046537364255429416
+ 3.0690327520311266e-05 0.00046564052306956875
+ 3.0690349177461819e-05 0.00046587320827894959
+ 3.0690370834612373e-05 0.00046607307433484731
+ 3.0690392491762919e-05 0.00046624146212347479
+ 3.0690414148913473e-05 0.00046637967697419719
+ 3.0690435806064026e-05 0.00046648898846127722
+ 3.069045746321458e-05 0.00046657063029325929
+ 3.0690479120365133e-05 0.0004666258002852115
+ 3.0690496765399601e-05 0.00046665198683365781
+ 3.0690514410434075e-05 0.00046666198405394353
+ 3.069053205546855e-05 0.00046665638716889121
+ 3.0690549700503025e-05 0.00046663577581361698
+ 3.0690567345537499e-05 0.00046660071413966874
+ 3.0690584990571974e-05 0.00046655175093608377
+ 3.0690602635606449e-05 0.00046648941976632619
+ 3.0690620280640916e-05 0.00046641423912008399
+ 3.0690637925675391e-05 0.00046632671257892689
+ 3.0690655570709866e-05 0.00046622732899484812
+ 3.069067321574434e-05 0.00046611656268073646
+ 3.0690690860778815e-05 0.00046599487361184948
+ 3.0690708505813289e-05 0.00046586270763738396
+ 3.0690726150847764e-05 0.00046572049670126538
+ 3.0690743795882239e-05 0.00046556865907130521
+ 3.0690761440916713e-05 0.00046540759957590188
+ 3.0690779085951181e-05 0.00046523770984748908
+ 3.0690796730985656e-05 0.00046505936857196291
+ 3.069081437602013e-05 0.00046487294174334804
+ 3.0690832021054605e-05 0.00046467878292299136
+ 3.069084966608908e-05 0.00046447723350260048
+ 3.0690867311123554e-05 0.00046426862297047311
+ 3.0690884956158029e-05 0.00046405326918029163
+ 3.0690902601192497e-05 0.00046383147862188659
+ 3.0690920246226971e-05 0.0004636035466933999
+ 3.0690937891261446e-05 0.00046336975797430831
+ 3.0690955536295921e-05 0.00046313038649879376
+ 3.0690973181330395e-05 0.00046288569602897633
+ 3.069099082636487e-05 0.00046263594032755121
+ 3.0691008471399344e-05 0.00046238136342939871
+ 3.0691026116433819e-05 0.00046212219991176166
+ 3.0691043761468294e-05 0.00046185867516261082
+ 3.0691061406502761e-05 0.00046159100564684353
+ 3.0691079051537236e-05 0.00046131939916998468
+ 3.0691096696571711e-05 0.00046104405513908457
+ 3.0691114341606185e-05 0.00046076516482052872
+ 3.069113198664066e-05 0.00046048291159450004
+ 3.0691149631675134e-05 0.00046019747120585279
+ 3.0691167276709609e-05 0.00045990901201118061
+ 3.0691184921744077e-05 0.00045961769522188066
+ 3.0691202566778552e-05 0.00045932367514303494
+ 3.0691220211813026e-05 0.00045902709940794936
+ 3.0691237856847501e-05 0.00045872810920820898
+ 3.0691255501881975e-05 0.00045842683951912496
+ 3.069127314691645e-05 0.00045812341932046545
+ 3.0691290791950925e-05 0.00045781797181237863
+ 3.0691308436985399e-05 0.00045751061462643097
+ 3.0691326082019874e-05 0.00045720146003169808
+ 3.0691343727054342e-05 0.00045689061513585962
+ 3.0691361372088816e-05 0.00045657818208126165
+ 3.0691379017123291e-05 0.00045626425823592343
+ 3.0691396662157766e-05 0.0004559489363794755
+ 3.069141430719224e-05 0.0004556323048840281
+ 3.0691431952226715e-05 0.00045531444788997848
+ 3.0691449597261189e-05 0.00045499544547677518
+ 3.0691467242295657e-05 0.00045467537382866608
+ 3.0691484887330132e-05 0.00045435430539546583
+ 3.0691502532364606e-05 0.00045403230904838535
+ 3.0691520177399081e-05 0.00045370945023097327
+ 3.0691537822433556e-05 0.00045338579110522598
+ 3.069155546746803e-05 0.00045306139069292836
+ 3.0691573112502505e-05 0.00045273630501229328
+ 3.069159075753698e-05 0.00045241058720997258
+ 3.0691608402571454e-05 0.00045208428768851668
+ 3.0691626047605922e-05 0.00045175745422936376
+ 3.0691643692640397e-05 0.00045143013211144381
+ 3.0691661337674871e-05 0.00045110236422548483
+ 3.0691682620107576e-05 0.00045070649383213837
+ 3.069170274528168e-05 0.00045033166770387813
+ 3.0691722870455783e-05 0.00044995642757493547
+ 3.0691742995629887e-05 0.00044958082330929242
+ 3.0691763120803983e-05 0.00044920490166811688
+ 3.0691783245978087e-05 0.00044882870648050557
+ 3.069180337115219e-05 0.00044845227880637947
+ 3.0691823496326294e-05 0.00044807565709178331
+ 3.0691843621500397e-05 0.00044769887731683952
+ 3.06918637466745e-05 0.00044732197313660687
+ 3.0691888110746126e-05 0.00044686556133260454
+ 3.0691912474817752e-05 0.00044640906499999366
+ 3.0691936838889385e-05 0.00044595253182312878
+ 3.069196120296101e-05 0.00044549600565976083
+ 3.0691985567032636e-05 0.00044503952681690417
+ 3.0692009931104262e-05 0.00044458313230938829
+ 3.0692034295175895e-05 0.00044412685610195336
+ 3.069205865924752e-05 0.00044367072933572632
+ 3.0692083023319146e-05 0.00044321478053989036
+ 3.0692107387390772e-05 0.00044275903582933563
+ 3.0692136719683572e-05 0.00044221066197735565
+ 3.0692166051976365e-05 0.00044166265618977781
+ 3.0692195384269158e-05 0.00044111505229614979
+ 3.0692224716561951e-05 0.000440567880571222
+ 3.0692254048854751e-05 0.0004400211680723513
+ 3.0692283381147544e-05 0.0004394749389480193
+ 3.0692312713440338e-05 0.0004389292147195882
+ 3.0692342045733131e-05 0.00043838401453830063
+ 3.0692377848029195e-05 0.00043771929099924211
+ 3.0692412335454629e-05 0.00043707976746529866
+ 3.0692446822880064e-05 0.00043644103787377733
+ 3.0692481310305498e-05 0.00043580312030283216
+ 3.0692515797730933e-05 0.00043516603032572377
+ 3.0692557828321211e-05 0.00043439073279079223
+ 3.0692599858911489e-05 0.00043361670459320404
+ 3.0692641889501767e-05 0.00043284396248195208
+ 3.0692683920092045e-05 0.00043207252012209858
+ 3.0692725950682323e-05 0.00043130238856505936
+ 3.0692777518503422e-05 0.00043035930871672526
+ 3.069282818666648e-05 0.00042943462880424378
+ 3.0692878854829539e-05 0.00042851188736760037
+ 3.0692929522992597e-05 0.00042759109050169295
+ 3.0692993215143461e-05 0.00042643637215815307
+ 3.0693056907294326e-05 0.0004252847370223043
+ 3.069312059944519e-05 0.00042413618616643506
+ 3.0693198945610717e-05 0.00042272760989246018
+ 3.0693278657649688e-05 0.00042129925771114857
+ 3.0693358369688667e-05 0.00041987571829712041
+ 3.0693461292370762e-05 0.00041804477075287836
+ 3.0693569508909818e-05 0.00041612824858809757
+ 3.0693701914804436e-05 0.00041379527174881443
+ 3.0693847065030185e-05 0.00041125276249577136
+ 3.0694034315235686e-05 0.00040799587225246868
+ 3.0694255865010427e-05 0.00040417569543334638
+ 3.0694554034092504e-05 0.00039909077578923559
+ 3.0694998769870886e-05 0.00039162496079868337
+ 3.0695805003988995e-05 0.00037844492463713218
+ 3.0696711764368316e-05 0.00036415075183872955
+ 3.0697737475686443e-05 0.00034863113834200367
+ 3.069880114340234e-05 0.00033323544260725887
+ 3.0699944764949547e-05 0.00031744009309453978
+ 3.0702231646278912e-05 0.00028806442739914481
+ 3.070418268121666e-05 0.00026516169925578173
+ 3.0706291228517248e-05 0.00024245284579639417
+ 3.0708581467436163e-05 0.00021998507757767748
+ 3.0710926666850021e-05 0.00019913410083615226
+ 3.0713271866263885e-05 0.00018025945489984468
+ 3.0715590537179629e-05 0.00016335772611693962
+ 3.0718474569484282e-05 0.00014452917890563918
+ 3.0721358601788929e-05 0.00012787080313841811
+ 3.0724242634093575e-05 0.00011313246567173927
+ 3.0727126666398228e-05 0.00010009286360866482
+ 3.0730010698702875e-05 8.8556201336288662e-05
+ 3.0732894731007528e-05 7.8349250567829904e-05
+ 3.0735778763312175e-05 6.9318749243295542e-05
+ 3.0739342797663592e-05 5.9583601550415324e-05
+ 3.0742906832015016e-05 5.12156620124964e-05
+ 3.0746470866366433e-05 4.4022919356413453e-05
+ 3.0750034900717857e-05 3.7840328450154061e-05
+ 3.0753598935069274e-05 3.2526023165760874e-05
+ 3.075789996112736e-05 2.7096692323683933e-05
+ 3.0762200987185453e-05 2.2573641128908005e-05
+ 3.0766502013243539e-05 1.8805590756409222e-05
+ 3.0770803039301626e-05 1.5666514280396347e-05
+ 3.0775104065359719e-05 1.3051421554109079e-05
+ 3.0780502505986983e-05 1.0377818664489998e-05
+ 3.0785900946614253e-05 8.251909089995107e-06
+ 3.0791299387241517e-05 6.5614966739560858e-06
+ 3.0796697827868781e-05 5.2173688876777125e-06
+ 3.0803468247657468e-05 3.9138135354349389e-06
+ 3.0810238667446156e-05 2.9359531577328348e-06
+ 3.0817009087234844e-05 2.2024124497970242e-06
+ 3.0825385304343956e-05 1.5432541258101081e-06
+ 3.0833761521453069e-05 1.081378721967762e-06
+ 3.0842137738562181e-05 7.5774041132707628e-07
+ 3.0853043385488654e-05 4.7689837631713853e-07
+ 3.0863949032415133e-05 3.0015113649486665e-07
+ 3.0876156063665131e-05 1.7876217937191045e-07
+ 3.088836309491513e-05 1.0647330757921957e-07
+ 3.0900570126165129e-05 6.3424252544034479e-08
+ 3.0912777157415134e-05 3.7787934734000867e-08
+ 3.0924984188665133e-05 2.2521155841269887e-08
+ 3.0937191219915131e-05 1.3429588576020001e-08
+ 3.0949398251165137e-05 8.015449872567151e-09
+ 3.0961605282415136e-05 4.7912734917149069e-09
+ 3.0973812313665134e-05 2.871251600636248e-09
+ 3.0986019344915133e-05 1.7278727196949598e-09
+ 3.0998226376165132e-05 1.0469960699243559e-09
+ 3.1010433407415137e-05 6.4154623608527275e-10
+ 3.1022640438665136e-05 4.0011708092908531e-10
+ 3.1034847469915134e-05 2.563646256420896e-10
+ 3.104705450116514e-05 1.7078006330613652e-10
+ 3.1059261532415138e-05 1.1983532309874618e-10
+ 3.1071468563665137e-05 8.9519095817165878e-11
+ 3.1083675594915136e-05 7.14874426319846e-11
+ 3.1095882626165134e-05 6.0771426293748156e-11
+ 3.110808965741514e-05 5.4411972164600532e-11
+ 3.1120296688665138e-05 5.0646908151112081e-11
+ 3.1132503719915137e-05 4.8426835103990855e-11
+ 3.1144710751165142e-05 4.7126820532761082e-11
+ 3.1156917782415141e-05 4.6374708016315066e-11
+ 3.116912481366514e-05 4.594887297816922e-11
+ 3.1181331844915138e-05 4.5717334758833713e-11
+ 3.1193538876165137e-05 4.5601496954841019e-11
+ 3.1205745907415143e-05 4.5554554261028926e-11
+ 3.1217952938665141e-05 4.5548633436145208e-11
+ 3.123015996991514e-05 4.5567135561437956e-11
+ 3.1242367001165145e-05 4.5600175741221697e-11
+ 3.1250000000000001e-05 4.5624752229059989e-11
+ 3.1262207031249999e-05 4.5669966819297461e-11
+ 3.1274414062499998e-05 4.5718898557805248e-11
+ 3.1286621093750003e-05 4.5770037749483043e-11
+ 3.1298828125000002e-05 4.5822485350610839e-11
+ 3.1311035156250001e-05 4.5875705969269391e-11
+ 3.1323242187499999e-05 4.5929380773488921e-11
+ 3.1335449218749998e-05 4.5983319895906806e-11
+ 3.1347656250000003e-05 4.6037410269464089e-11
+ 3.1359863281250002e-05 4.6091584562801975e-11
+ 3.1372070312500001e-05 4.6145802680837535e-11
+ 3.1384277343749999e-05 4.6200040748086769e-11
+ 3.1396484374999998e-05 4.6254284548072891e-11
+ 3.1408691406250004e-05 4.6308525616398256e-11
+ 3.1420898437500002e-05 4.6362758914111761e-11
+ 3.1433105468750001e-05 4.641698144216514e-11
+ 3.1445312499999999e-05 4.6471191416301583e-11
+ 3.1457519531249998e-05 4.6525387775689795e-11
+ 3.1469726562500004e-05 4.6579569890308451e-11
+ 3.1481933593750002e-05 4.663373738668933e-11
+ 3.1494140625000001e-05 4.6687890044144897e-11
+ 3.150634765625e-05 4.6742027732970226e-11
+ 3.1518554687499998e-05 4.6796150377641402e-11
+ 3.1530761718750004e-05 4.6850257934899579e-11
+ 3.1542968750000002e-05 4.690435038069982e-11
+ 3.1555175781250001e-05 4.695842770243876e-11
+ 3.15673828125e-05 4.7012489894326265e-11
+ 3.1579589843749998e-05 4.7066536954629075e-11
+ 3.1591796875000004e-05 4.7120568884029375e-11
+ 3.1604003906250002e-05 4.7174585684647293e-11
+ 3.1616210937500001e-05 4.7228587359458799e-11
+ 3.162841796875e-05 4.728257391194907e-11
+ 3.1640624999999998e-05 4.7336545345906017e-11
+ 3.1652832031250004e-05 4.7390501665297362e-11
+ 3.1665039062500002e-05 4.7444442874197415e-11
+ 3.1677246093750001e-05 4.7498368976743532e-11
+ 3.1689453125e-05 4.7552279977110043e-11
+ 3.1701660156249998e-05 4.7606175879492929e-11
+ 3.1713867187499997e-05 4.76600566881005e-11
+ 3.1726074218750002e-05 4.771392240714795e-11
+ 3.1738281250000001e-05 4.7767773040854128e-11
+ 3.175048828125e-05 4.7821608593439534e-11
+ 3.1762695312499998e-05 4.7875429069125182e-11
+ 3.1774902343749997e-05 4.7929234472131972e-11
+ 3.1787109375000002e-05 4.7983024806680162e-11
+ 3.1799316406250001e-05 4.8036800076989225e-11
+ 3.18115234375e-05 4.8090560287277661e-11
+ 3.1823730468749998e-05 4.81443054417629e-11
+ 3.1835937500000004e-05 4.8198035544661283e-11
+ 3.1848144531250003e-05 4.8251750600188019e-11
+ 3.1860351562500001e-05 4.8305450612557161e-11
+ 3.187255859375e-05 4.835913558598157e-11
+ 3.1884765624999999e-05 4.8412805524672993e-11
+ 3.1896972656250004e-05 4.846646043284194e-11
+ 3.1909179687500003e-05 4.8520100314697792e-11
+ 3.1921386718750001e-05 4.8573725174448732e-11
+ 3.193359375e-05 4.8627335016301782e-11
+ 3.1945800781249999e-05 4.8680929844462761e-11
+ 3.1958007812500004e-05 4.8734509663136332e-11
+ 3.1970214843750003e-05 4.8788074476525962e-11
+ 3.1982421875000001e-05 4.8841624288833967e-11
+ 3.199462890625e-05 4.8895159104261467e-11
+ 3.2006835937499999e-05 4.894867892700839e-11
+ 3.2019042968750004e-05 4.9002183761273549e-11
+ 3.2031250000000003e-05 4.905567361125451e-11
+ 3.2043457031250001e-05 4.9109148481147716e-11
+ 3.20556640625e-05 4.9162608375148381e-11
+ 3.2067871093749999e-05 4.9216053297450589e-11
+ 3.2080078125000004e-05 4.9269483252247235e-11
+ 3.2092285156250003e-05 4.932289824373005e-11
+ 3.2104492187500001e-05 4.9376298276089576e-11
+ 3.211669921875e-05 4.9429683353515166e-11
+ 3.2128906249999999e-05 4.9483053480195042e-11
+ 3.2141113281250004e-05 4.9536408660316226e-11
+ 3.2153320312500003e-05 4.9589748898064572e-11
+ 3.2165527343750001e-05 4.9643074197624777e-11
+ 3.2177734375e-05 4.9696384563180337e-11
+ 3.2189941406249999e-05 4.9749679998913594e-11
+ 3.2202148437500004e-05 4.980296050900572e-11
+ 3.2214355468750003e-05 4.9856226097636712e-11
+ 3.2226562500000002e-05 4.99094767689854e-11
+ 3.223876953125e-05 4.9962712527229435e-11
+ 3.2250976562499999e-05 5.0015933376545304e-11
+ 3.2263183593750004e-05 5.0069139321108297e-11
+ 3.2275390625000003e-05 5.0122330365092602e-11
+ 3.2287597656250002e-05 5.0175506512671175e-11
+ 3.22998046875e-05 5.0228667768015851e-11
+ 3.2312011718749999e-05 5.0281814135297241e-11
+ 3.2324218750000004e-05 5.0334945618684835e-11
+ 3.2336425781250003e-05 5.0388062222346936e-11
+ 3.2348632812500002e-05 5.0441163950450669e-11
+ 3.236083984375e-05 5.0494250807162017e-11
+ 3.2373046874999999e-05 5.0547322796645784e-11
+ 3.2385253906249998e-05 5.060037992306559e-11
+ 3.2397460937500003e-05 5.0653422190583924e-11
+ 3.2409667968750002e-05 5.0706449603362099e-11
+ 3.2421875e-05 5.0759462165560252e-11
+ 3.2434082031249999e-05 5.0812459881337356e-11
+ 3.2446289062499998e-05 5.086544275485121e-11
+ 3.2458496093750003e-05 5.0918410790258479e-11
+ 3.2470703125000002e-05 5.0971363991714641e-11
+ 3.248291015625e-05 5.1024302363374004e-11
+ 3.2495117187499999e-05 5.1077225909389738e-11
+ 3.2507324218749998e-05 5.1130134633913832e-11
+ 3.2519531249999996e-05 5.1183028541097097e-11
+ 3.2531738281250002e-05 5.123590763508922e-11
+ 3.25439453125e-05 5.1288771920038706e-11
+ 3.2556152343749999e-05 5.1341621400092889e-11
+ 3.2568359374999998e-05 5.1394456079397949e-11
+ 3.2580566406249996e-05 5.1447275962098919e-11
+ 3.2592773437500002e-05 5.1500081052339658e-11
+ 3.260498046875e-05 5.1552871354262853e-11
+ 3.2617187499999999e-05 5.1605646872010057e-11
+ 3.2629394531249998e-05 5.1658407609721638e-11
+ 3.2641601562499996e-05 5.171115357153682e-11
+ 3.2653808593750002e-05 5.1763884761593666e-11
+ 3.2666015625000001e-05 5.1816601184029079e-11
+ 3.2678222656249999e-05 5.1869302842978788e-11
+ 3.2690429687499998e-05 5.1921989742577379e-11
+ 3.2702636718749997e-05 5.1974661886958285e-11
+ 3.2714843750000002e-05 5.2027319280253771e-11
+ 3.2727050781250001e-05 5.2079961926594946e-11
+ 3.2739257812499999e-05 5.2132589830111786e-11
+ 3.2751464843749998e-05 5.2185202994933079e-11
+ 3.2763671874999997e-05 5.2237801425186463e-11
+ 3.2775878906249995e-05 5.2290385124998426e-11
+ 3.2788085937500001e-05 5.2342954098494298e-11
+ 3.2800292968749999e-05 5.2395508349798247e-11
+ 3.2812499999999998e-05 5.2448047883033309e-11
+ 3.2824707031249997e-05 5.2500572702321331e-11
+ 3.2836914062499995e-05 5.2553082811783024e-11
+ 3.2849121093750001e-05 5.260557821553798e-11
+ 3.2861328124999999e-05 5.265805891770455e-11
+ 3.2873535156249998e-05 5.2710524922400013e-11
+ 3.2885742187499997e-05 5.2762976233740464e-11
+ 3.2897949218749995e-05 5.281541285584085e-11
+ 3.2910156249999994e-05 5.2867834792814952e-11
+ 3.2922363281249999e-05 5.2920242048775429e-11
+ 3.2934570312499998e-05 5.297263462783375e-11
+ 3.2946777343749997e-05 5.3025012534100265e-11
+ 3.2958984374999995e-05 5.3077375771684144e-11
+ 3.2971191406249994e-05 5.3129724344693429e-11
+ 3.2983398437499999e-05 5.3182058257235008e-11
+ 3.2995605468749998e-05 5.3234377513414598e-11
+ 3.3007812499999997e-05 5.3286682117336819e-11
+ 3.3020019531249995e-05 5.3338972073105086e-11
+ 3.3032226562499994e-05 5.339124738482168e-11
+ 3.304443359375e-05 5.3443508056587737e-11
+ 3.3056640624999998e-05 5.349575409250326e-11
+ 3.3068847656249997e-05 5.3547985496667078e-11
+ 3.3081054687499996e-05 5.3600202273176877e-11
+ 3.3093261718749994e-05 5.3652404426129203e-11
+ 3.310546875e-05 5.3704591959619454e-11
+ 3.3117675781249998e-05 5.3756764877741888e-11
+ 3.3129882812499997e-05 5.3808923184589598e-11
+ 3.3142089843749996e-05 5.3861066884254534e-11
+ 3.3154296874999994e-05 5.3913195980827531e-11
+ 3.3166503906249993e-05 5.3965310478398236e-11
+ 3.3178710937499998e-05 5.4017410381055188e-11
+ 3.3190917968749997e-05 5.4069495692885746e-11
+ 3.3203124999999996e-05 5.4121566417976143e-11
+ 3.3215332031249994e-05 5.4173622560411455e-11
+ 3.3227539062499993e-05 5.4225664124275648e-11
+ 3.3239746093749998e-05 5.4277691113651499e-11
+ 3.3251953124999997e-05 5.4329703532620677e-11
+ 3.3264160156249996e-05 5.4381701385263697e-11
+ 3.3276367187499994e-05 5.4433684675659917e-11
+ 3.3288574218749993e-05 5.4485653407887576e-11
+ 3.3300781249999992e-05 5.4537607586023745e-11
+ 3.3312988281249997e-05 5.4589547214144361e-11
+ 3.3325195312499996e-05 5.4641472296324253e-11
+ 3.3337402343749994e-05 5.4693382836637059e-11
+ 3.3349609374999993e-05 5.4745278839155299e-11
+ 3.3361816406249992e-05 5.4797160307950356e-11
+ 3.3374023437499997e-05 5.4849027247092475e-11
+ 3.3386230468749996e-05 5.4900879660650734e-11
+ 3.3398437499999994e-05 5.4952717552693121e-11
+ 3.3410644531249993e-05 5.5004540927286431e-11
+ 3.3422851562499992e-05 5.5055228596414379e-11
+ 3.3435058593749997e-05 5.510627065877697e-11
+ 3.3447265624999996e-05 5.5158092921228189e-11
+ 3.3459472656249994e-05 5.5210849104087091e-11
+ 3.3471679687499993e-05 5.5264521350196526e-11
+ 3.3483886718749992e-05 5.5318219478297029e-11
+ 3.3489990234374991e-05 5.5343709041866146e-11
+ 3.3496093749999997e-05 5.5365175813779936e-11
+ 3.3499145507812497e-05 5.537183500008943e-11
+ 3.3502197265624997e-05 5.5371668509114686e-11
+ 3.3505249023437496e-05 5.5354771851498252e-11
+ 3.3506606790774088e-05 5.5334751403020664e-11
+ 3.3506998216660861e-05 5.5326313558461538e-11
+ 3.3507389642547634e-05 5.5316205768572161e-11
+ 3.3508368207264576e-05 5.5280832763072969e-11
+ 3.3509409502908187e-05 5.5216998316807767e-11
+ 3.3509970598735322e-05 5.5162661637241072e-11
+ 3.3510339629298368e-05 5.5114439869388932e-11
+ 3.3511110323815843e-05 5.4960015216721681e-11
+ 3.3511741481233846e-05 5.4732817211499076e-11
+ 3.3512113084009008e-05 5.4516300482441227e-11
+ 3.3512434193795786e-05 5.42419953316085e-11
+ 3.3512647097925408e-05 5.400886072195258e-11
+ 3.351286000205503e-05 5.3774257755821461e-11
+ 3.3514989043351245e-05 5.1549852354822979e-11
+ 3.3527196074601243e-05 4.2855387214314058e-11
+ 3.3539403105851242e-05 4.053247294954365e-11
+ 3.3551610137101247e-05 4.3931039996784842e-11
+ 3.3563817168351246e-05 5.2388572167819672e-11
+ 3.3576024199601245e-05 6.5140225940715896e-11
+ 3.3588231230851243e-05 8.1286621114128428e-11
+ 3.3600438262101242e-05 9.9800201152591339e-11
+ 3.3612645293351241e-05 1.1955731974057662e-10
+ 3.3624852324601246e-05 1.3938677731239894e-10
+ 3.3637059355851245e-05 1.581275910662053e-10
+ 3.3649266387101243e-05 1.7469004130247602e-10
+ 3.3661473418351242e-05 1.881149150311095e-10
+ 3.3673680449601241e-05 1.9762660690176225e-10
+ 3.3685887480851246e-05 2.026764694324815e-10
+ 3.3698094512101245e-05 2.0297359093770258e-10
+ 3.3710301543351243e-05 1.9850103705845601e-10
+ 3.3722508574601242e-05 1.8951650785639057e-10
+ 3.3734715605851241e-05 1.7653730627935789e-10
+ 3.3746922637101246e-05 1.6031044421422816e-10
+ 3.3759129668351245e-05 1.4176958358946107e-10
+ 3.3771336699601243e-05 1.2198127662112241e-10
+ 3.3783543730851242e-05 1.0208359001036545e-10
+ 3.3795750762101241e-05 8.3220638681385549e-11
+ 3.3807957793351246e-05 6.6476791169901555e-11
+ 3.3811009551163746e-05 6.2738216402259133e-11
+ 3.3811314726944991e-05 6.2375524734021021e-11
+ 3.3812077666398114e-05 6.1477937832984702e-11
+ 3.3812459136124683e-05 6.1034090082773124e-11
+ 3.3812482977982594e-05 6.1006459924724939e-11
+ 3.381248774635417e-05 6.1000935454857881e-11
+ 3.3812497283097337e-05 6.0989888077255491e-11
+ 3.3812498046036786e-05 6.0989004377034889e-11
+ 3.3812499571915696e-05 6.0987237016591268e-11
+ 3.3812499693986006e-05 6.0987095630059761e-11
+ 3.381249993812663e-05 6.0986812858020706e-11
+ 3.3812499957657882e-05 6.0986790236316644e-11
+ 3.3812499996720385e-05 6.098674499293473e-11
+ 3.3812500074845385e-05 6.2330481534674083e-11
+ 3.3812500152970385e-05 6.6608198187672893e-11
+ 3.3812500934220382e-05 2.7075208822833839e-10
+ 3.3812508051845976e-05 1.5641542586395462e-08
+ 3.381251516947157e-05 5.5354276368357439e-08
+ 3.3812522287097164e-05 1.1939590331347595e-07
+ 3.3812529404722765e-05 2.0774988808958391e-07
+ 3.381253652234836e-05 3.2039621340029153e-07
+ 3.3812543639973954e-05 4.5731138406416947e-07
+ 3.3812550757599555e-05 6.1846843192454422e-07
+ 3.3812557875225149e-05 8.0383692158836119e-07
+ 3.3812564992850743e-05 1.0133829569922963e-06
+ 3.3812572110476345e-05 1.2470691887940203e-06
+ 3.3812579228101939e-05 1.5048548225862434e-06
+ 3.3812587807568571e-05 1.8475543476526228e-06
+ 3.3812596387035203e-05 2.2251205386231599e-06
+ 3.3812604966501835e-05 2.637462112110794e-06
+ 3.3812613545968467e-05 3.0844806091734263e-06
+ 3.3812622125435099e-05 3.5660704276185103e-06
+ 3.3812630704901731e-05 4.0821188567621002e-06
+ 3.3812639284368363e-05 4.6325061146258863e-06
+ 3.3812647863834995e-05 5.2171053875545835e-06
+ 3.3812658180770249e-05 5.965211217502911e-06
+ 3.3812668497705509e-05 6.7623492313414161e-06
+ 3.3812678814640763e-05 7.6082590651614992e-06
+ 3.3812689131576017e-05 8.5026660760363497e-06
+ 3.381269944851127e-05 9.4452814742207388e-06
+ 3.3812709765446524e-05 1.0435802462230257e-05
+ 3.3812720082381784e-05 1.147391238070454e-05
+ 3.3812730399317038e-05 1.25592808609545e-05
+ 3.3812742902012261e-05 1.393744004677843e-05
+ 3.3812755404707476e-05 1.538385928477854e-05
+ 3.3812767907402699e-05 1.6897871760843825e-05
+ 3.3812780410097914e-05 1.8478782715895571e-05
+ 3.3812792912793137e-05 2.0125869935940648e-05
+ 3.3812805415488353e-05 2.1838384260846487e-05
+ 3.3812817918183575e-05 2.3615550111329756e-05
+ 3.3812830420878797e-05 2.5456566033633845e-05
+ 3.3812845592253872e-05 2.7775100207116592e-05
+ 3.3812860763628954e-05 3.0184906039223483e-05
+ 3.3812875935004035e-05 3.2684405463249104e-05
+ 3.381289110637911e-05 3.5271969973378807e-05
+ 3.3812906277754191e-05 3.7945922288216153e-05
+ 3.3812921449129273e-05 4.0704538058428326e-05
+ 3.3812936620504354e-05 4.3546047616054653e-05
+ 3.3812954860519559e-05 4.7069469432613542e-05
+ 3.381297310053477e-05 5.0706855826657106e-05
+ 3.3812991340549974e-05 5.4454893918205257e-05
+ 3.3813009580565179e-05 5.8310193146384224e-05
+ 3.381302782058039e-05 6.2269290123695639e-05
+ 3.3813046060595594e-05 6.6328653564053143e-05
+ 3.3813068199865842e-05 7.1385338233594827e-05
+ 3.3813090339136098e-05 7.6577901326810804e-05
+ 3.3813112478406346e-05 8.189969012601315e-05
+ 3.3813134617676594e-05 8.7343953274172687e-05
+ 3.3813161293011319e-05 9.4056657818521804e-05
+ 3.3813187873095807e-05 0.00010090035482762358
+ 3.3813214453180294e-05 0.00010788664307091889
+ 3.3813248688484339e-05 0.00011707548567577072
+ 3.3813282923788384e-05 0.00012645461865043843
+ 3.3813315356127045e-05 0.00013549167951766453
+ 3.3813347788465714e-05 0.00014465398332574899
+ 3.3813380220804375e-05 0.00015391958689944246
+ 3.3813412653143037e-05 0.00016326679416820027
+ 3.3813445085481705e-05 0.00017267423453976973
+ 3.3813477517820366e-05 0.00018212093762926101
+ 3.3813509950159028e-05 0.00019158640400330904
+ 3.3813542382497689e-05 0.00020105067163597072
+ 3.3813569584998148e-05 0.00020897371829601134
+ 3.38135967874986e-05 0.00021687121736840308
+ 3.3813623989999051e-05 0.0002247324443841368
+ 3.381365119249951e-05 0.00023254704172942061
+ 3.3813678394999962e-05 0.00024030503688061725
+ 3.3813705597500414e-05 0.00024799685880477063
+ 3.3813732800000866e-05 0.00025561335251051022
+ 3.3813760002501317e-05 0.00026314579174345146
+ 3.3813787205001776e-05 0.00027058588982929906
+ 3.3813814407502228e-05 0.00027792580867665878
+ 3.381384161000268e-05 0.0002851581659600263
+ 3.3813868812503138e-05 0.00029227604051150784
+ 3.381389601500359e-05 0.00029927297595749906
+ 3.3813923217504042e-05 0.00030614298264376868
+ 3.3813950420004494e-05 0.00031288053789913813
+ 3.3813977622504946e-05 0.00031948058469418605
+ 3.3814004825005404e-05 0.00032593852875712024
+ 3.3814032027505856e-05 0.00033225023421413059
+ 3.3814059230006308e-05 0.00033841201782615327
+ 3.3814086432506767e-05 0.0003444206418985982
+ 3.3814115300883497e-05 0.00035062659892727544
+ 3.3814144169260235e-05 0.0003566540934654631
+ 3.3814173037636965e-05 0.00036250083298786399
+ 3.3814201906013703e-05 0.00036816503744223664
+ 3.381423077439044e-05 0.00037364542226806104
+ 3.3814259642767171e-05 0.00037894118026981165
+ 3.3814288511143909e-05 0.00038405196247931109
+ 3.3814317379520639e-05 0.000388977858140999
+ 3.3814346247897377e-05 0.00039371937395252178
+ 3.3814381135166679e-05 0.0003992047348763101
+ 3.3814416022435988e-05 0.00040442447430172904
+ 3.3814449985506049e-05 0.00040925368585940502
+ 3.3814483948576111e-05 0.00041383750344981278
+ 3.3814517911646178e-05 0.00041817993390062743
+ 3.381455187471624e-05 0.00042228549548244641
+ 3.3814585837786301e-05 0.00042615916749456922
+ 3.381462738108282e-05 0.0004305900119691504
+ 3.3814668924379333e-05 0.00043469258490726371
+ 3.3814710467675846e-05 0.0004384781612780042
+ 3.3814752010972365e-05 0.00044195857402361564
+ 3.3814802322523101e-05 0.00044578261210212054
+ 3.3814853125173633e-05 0.00044923093231022854
+ 3.3814903927824171e-05 0.00045228765276156626
+ 3.3814971607266246e-05 0.00045579239535176001
+ 3.3815039286708321e-05 0.00045870005395461338
+ 3.3815091919396567e-05 0.00046058369469111949
+ 3.3815144552084814e-05 0.00046216451732223918
+ 3.3815197184773054e-05 0.00046346681282214352
+ 3.3815249817461301e-05 0.00046451393123718372
+ 3.3815297809929102e-05 0.00046526519657479943
+ 3.3815345802396904e-05 0.00046583893527304737
+ 3.3815393794864705e-05 0.00046625041073407677
+ 3.3815441787332514e-05 0.00046651403875466578
+ 3.3815489779800315e-05 0.0004666433740508164
+ 3.3815537261554866e-05 0.00046665162291553914
+ 3.3815584743309411e-05 0.000466552308242554
+ 3.3815632225063962e-05 0.00046635608374731292
+ 3.3815679706818513e-05 0.00046607281339991539
+ 3.3815727188573057e-05 0.00046571159614456351
+ 3.3815774670327608e-05 0.00046528079492301239
+ 3.3815824358583363e-05 0.00046476378468933915
+ 3.3815874046839124e-05 0.00046418694952370777
+ 3.3815923735094879e-05 0.00046355752837163748
+ 3.3815973423350634e-05 0.00046288205221083837
+ 3.3816023111606395e-05 0.00046216639229460844
+ 3.381607279986215e-05 0.00046141580830294233
+ 3.3816127951386075e-05 0.00046054748419045071
+ 3.381618310291e-05 0.00045964758393211987
+ 3.3816238254433926e-05 0.00045872107390199996
+ 3.3816293405957851e-05 0.00045777228079549998
+ 3.3816348557481776e-05 0.00045680495887963081
+ 3.3816411640520542e-05 0.000455679953428722
+ 3.3816474723559301e-05 0.00045453907391423655
+ 3.3816537806598059e-05 0.0004533857886546739
+ 3.3816600889636818e-05 0.00045222299034028662
+ 3.3816674140146426e-05 0.00045086399130210022
+ 3.3816747390656033e-05 0.00044949844535668453
+ 3.3816820641165648e-05 0.00044812878579885432
+ 3.3816905619421586e-05 0.00044653719761490697
+ 3.3816990597677524e-05 0.0004449449586312652
+ 3.3817093836844787e-05 0.00044301214871122791
+ 3.3817198171769411e-05 0.00044106269601017851
+ 3.3817302506694043e-05 0.00043911870626636078
+ 3.3817426664469162e-05 0.00043681393387383496
+ 3.3817550822244287e-05 0.00043451951813961668
+ 3.3817705800806531e-05 0.00043167106196547318
+ 3.3817884937131784e-05 0.00042840086834201771
+ 3.3818098556602387e-05 0.00042453293757745131
+ 3.3818364485722956e-05 0.00041976628303681877
+ 3.3818717982712204e-05 0.00041351261779238365
+ 3.3819242097564146e-05 0.00040441158298440465
+ 3.3820136340120473e-05 0.00038934346113524376
+ 3.3822132807185038e-05 0.00035769765454050228
+ 3.3823988816858016e-05 0.00033058981538904275
+ 3.382642166844308e-05 0.00029814348467284587
+ 3.3828854520028144e-05 0.00026888165874455468
+ 3.3831287371613209e-05 0.00024249178888257299
+ 3.3833720223198273e-05 0.00021869200206866874
+ 3.3836153074783331e-05 0.00019722808975099272
+ 3.3838585926368395e-05 0.00017787079297825666
+ 3.3841018777953459e-05 0.00016041335425741158
+ 3.3843451629538523e-05 0.0001446693086575522
+ 3.3845767705239778e-05 0.00013111903917235234
+ 3.3848819440406716e-05 0.00011518312547724692
+ 3.3851871175573654e-05 0.00010118403045864018
+ 3.3854922910740599e-05 8.8886357108097517e-05
+ 3.3857974645907538e-05 7.8083318131395906e-05
+ 3.3861026381074476e-05 6.8593258842393536e-05
+ 3.3864078116241414e-05 6.025660181923537e-05
+ 3.3867773618773601e-05 5.1505809187250614e-05
+ 3.3871134288610906e-05 4.4656271026532631e-05
+ 3.3874494958448218e-05 3.8717628008379948e-05
+ 3.3878620731690281e-05 3.2495702272495222e-05
+ 3.3882746504932338e-05 2.7273646663031209e-05
+ 3.3886872278174394e-05 2.2890780980831938e-05
+ 3.3890998051416458e-05 1.9212246512347876e-05
+ 3.3895123824658514e-05 1.6124856494297113e-05
+ 3.3900251138437097e-05 1.2970141364146993e-05
+ 3.390537845221568e-05 1.0432633172092827e-05
+ 3.3910505765994263e-05 8.3915781182774641e-06
+ 3.3915633079772846e-05 6.7498471833962207e-06
+ 3.3921995979825153e-05 5.1518189724579756e-06
+ 3.392835887987746e-05 3.9321378049054371e-06
+ 3.3934721779929767e-05 3.0012267671564931e-06
+ 3.3942497256254511e-05 2.15737185496337e-06
+ 3.3950272732579249e-05 1.5508026051292012e-06
+ 3.3958048208903994e-05 1.1147960586695601e-06
+ 3.396798344193607e-05 7.3118840550782522e-07
+ 3.3977918674968139e-05 4.7961075194826108e-07
+ 3.3990125706218145e-05 2.8571159964289929e-07
+ 3.4002332737468143e-05 1.7024209705967684e-07
+ 3.4014539768718142e-05 1.0147848625806179e-07
+ 3.4026746799968141e-05 6.0528851952355526e-08
+ 3.4038953831218139e-05 3.6142806128821739e-08
+ 3.4051160862468145e-05 2.1620593980565466e-08
+ 3.4063367893718143e-05 1.2972424953734794e-08
+ 3.4075574924968142e-05 7.8223266739669589e-09
+ 3.4087781956218141e-05 4.7553755500354248e-09
+ 3.4099988987468139e-05 2.9289656540459339e-09
+ 3.4112196018718145e-05 1.8413143839828223e-09
+ 3.4124403049968144e-05 1.1936037658401295e-09
+ 3.4136610081218142e-05 8.078836241498485e-10
+ 3.4148817112468141e-05 5.7818218790680653e-10
+ 3.416102414371814e-05 4.4139192644487092e-10
+ 3.4173231174968138e-05 3.5993152647751398e-10
+ 3.4185438206218144e-05 3.1142080027758294e-10
+ 3.4197645237468142e-05 2.8253202431124535e-10
+ 3.4209852268718141e-05 2.653283707170538e-10
+ 3.422205929996814e-05 2.5508336753526945e-10
+ 3.4234266331218138e-05 2.4898233649178344e-10
+ 3.4246473362468144e-05 2.4534909287155193e-10
+ 3.4258680393718142e-05 2.4318544696123555e-10
+ 3.4270887424968141e-05 2.4189696683490067e-10
+ 3.428309445621814e-05 2.411296605642883e-10
+ 3.4295301487468138e-05 2.406727199550333e-10
+ 3.4307508518718137e-05 2.4040060549918595e-10
+ 3.4319715549968142e-05 2.4023855751768804e-10
+ 3.4331922581218141e-05 2.4014205601586099e-10
+ 3.434412961246814e-05 2.4008458822552009e-10
+ 3.4356336643718138e-05 2.4005036536744095e-10
+ 3.4368543674968137e-05 2.4002998505548136e-10
+ 3.4380750706218142e-05 2.4001784836154639e-10
+ 3.4392957737468141e-05 2.4001062082534474e-10
+ 3.440516476871814e-05 2.4000631674323626e-10
+ 3.4417371799968138e-05 2.4000375361391963e-10
+ 3.4429578831218137e-05 2.4000222718017004e-10
+ 3.4441785862468142e-05 2.4000131819356677e-10
+ 3.4453992893718141e-05 2.4000077702242996e-10
+ 3.446619992496814e-05 2.4000045459933931e-10
+ 3.4478406956218138e-05 2.4000026257884156e-10
+ 3.4490613987468137e-05 2.4000014832025053e-10
+ 3.4502821018718143e-05 2.4000008023582484e-10
+ 3.4515028049968141e-05 2.4000003966625581e-10
+ 3.452723508121814e-05 2.400000155533385e-10
+ 3.4539442112468138e-05 2.4000000121814107e-10
+ 3.4551649143718137e-05 2.3999999261673205e-10
+ 3.4563856174968136e-05 2.3999998758456908e-10
+ 3.4576063206218141e-05 2.3999998453222656e-10
+ 3.458827023746814e-05 2.3999998265390494e-10
+ 3.4600477268718139e-05 2.3999998161732485e-10
+ 3.4612684299968137e-05 2.3999998104358188e-10
+ 3.4624891331218136e-05 2.3999998057389865e-10
+ 3.4637098362468141e-05 2.3999998026292464e-10
+ 3.464930539371814e-05 2.3999998019001177e-10
+ 3.4661512424968139e-05 2.3999998019899801e-10
+ 3.4673719456218137e-05 2.3999998020597388e-10
+ 3.4685926487468136e-05 2.3999998012855701e-10
+ 3.4698133518718135e-05 2.3999998005534517e-10
+ 3.471034054996814e-05 2.3999998008389102e-10
+ 3.4722547581218139e-05 2.3999998009224399e-10
+ 3.4734754612468137e-05 2.3999998012219294e-10
+ 3.4746961643718136e-05 2.3999998013282356e-10
+ 3.4759168674968135e-05 2.3999998009115475e-10
+ 3.477137570621814e-05 2.3999998009706464e-10
+ 3.4783582737468139e-05 2.3999998010363494e-10
+ 3.4795789768718137e-05 2.3999998011314167e-10
+ 3.4807996799968136e-05 2.3999998013616955e-10
+ 3.4820203831218135e-05 2.3999998011363462e-10
+ 3.483241086246814e-05 2.3999998009274014e-10
+ 3.4844617893718139e-05 2.399999801011231e-10
+ 3.4856824924968137e-05 2.399999800977465e-10
+ 3.4869031956218136e-05 2.3999998010717031e-10
+ 3.4881238987468135e-05 2.3999998026497155e-10
+ 3.489344601871814e-05 2.3999998018940695e-10
+ 3.4905653049968139e-05 2.399999801489314e-10
+ 3.4917860081218137e-05 2.3999998016252337e-10
+ 3.4930067112468136e-05 2.3999998017736873e-10
+ 3.4942274143718135e-05 2.3999998008841631e-10
+ 3.4954481174968133e-05 2.399999801406156e-10
+ 3.4966688206218139e-05 2.3999998027111368e-10
+ 3.4978895237468138e-05 2.399999803096209e-10
+ 3.4991102268718136e-05 2.399999801745041e-10
+ 3.5003309299968135e-05 2.3999998014351678e-10
+ 3.5015516331218133e-05 2.399999802735929e-10
+ 3.5027723362468139e-05 2.3999998026179471e-10
+ 3.5039930393718138e-05 2.3999998016976751e-10
+ 3.5052137424968136e-05 2.3999998022820648e-10
+ 3.5064344456218135e-05 2.3999998018386391e-10
+ 3.5076551487468134e-05 2.3999998024457121e-10
+ 3.5088758518718139e-05 2.399999802712344e-10
+ 3.5100965549968138e-05 2.3999998016906244e-10
+ 3.5113172581218136e-05 2.399999802251944e-10
+ 3.5125379612468135e-05 2.3999998029674961e-10
+ 3.513758664371814e-05 2.3999998024490881e-10
+ 3.5149793674968139e-05 2.3999998022841694e-10
+ 3.5162000706218138e-05 2.3999998027402318e-10
+ 3.5174207737468136e-05 2.3999998031284179e-10
+ 3.5186414768718142e-05 2.3999998024592236e-10
+ 3.519862179996814e-05 2.3999998028900653e-10
+ 3.5210828831218139e-05 2.3999998029018118e-10
+ 3.5223035862468138e-05 2.3999998020407995e-10
+ 3.5235242893718143e-05 2.3999998030027903e-10
+ 3.5247449924968142e-05 2.3999998034659856e-10
+ 3.525965695621814e-05 2.3999998035710371e-10
+ 3.5271863987468139e-05 2.3999998035781327e-10
+ 3.5284071018718145e-05 2.3999998028429372e-10
+ 3.5296278049968143e-05 2.3999998026462584e-10
+ 3.5308485081218142e-05 2.3999998034401652e-10
+ 3.5320692112468141e-05 2.3999998040748526e-10
+ 3.5332899143718146e-05 2.399999802904164e-10
+ 3.5345106174968145e-05 2.3999998026488739e-10
+ 3.5357313206218143e-05 2.399999803948264e-10
+ 3.5369520237468142e-05 2.399999803901337e-10
+ 3.5381727268718147e-05 2.3999998030809217e-10
+ 3.5393934299968146e-05 2.3999998036169063e-10
+ 3.5406141331218145e-05 2.3999998033495331e-10
+ 3.5418348362468143e-05 2.3999998039429674e-10
+ 3.5430555393718149e-05 2.3999998043834603e-10
+ 3.5442762424968147e-05 2.3999998042747548e-10
+ 3.5454969456218146e-05 2.3999998033813589e-10
+ 3.5467176487468145e-05 2.3999998042749197e-10
+ 3.547938351871815e-05 2.3999998045576412e-10
+ 3.5491590549968149e-05 2.3999998040668088e-10
+ 3.5503797581218147e-05 2.3999998041015307e-10
+ 3.5516004612468146e-05 2.3999998038280188e-10
+ 3.5528211643718152e-05 2.399999804963409e-10
+ 3.554041867496815e-05 2.3999998050724164e-10
+ 3.5552625706218149e-05 2.3999998043757132e-10
+ 3.5564832737468148e-05 2.3999998042873677e-10
+ 3.5577039768718153e-05 2.3999998048062938e-10
+ 3.5589246799968152e-05 2.3999998046244087e-10
+ 3.560145383121815e-05 2.3999998047367506e-10
+ 3.5613660862468149e-05 2.3999998045481209e-10
+ 3.5625867893718154e-05 2.3999998043752122e-10
+ 3.5638074924968153e-05 2.3999998042446345e-10
+ 3.5650281956218152e-05 2.3999998041722252e-10
+ 3.566248898746815e-05 2.3999998041674074e-10
+ 3.5674696018718156e-05 2.3999998042357827e-10
+ 3.5686903049968154e-05 2.3999998043806778e-10
+ 3.5699110081218153e-05 2.3999998047660411e-10
+ 3.5711317112468152e-05 2.3999998051655456e-10
+ 3.5723524143718157e-05 2.3999998052591767e-10
+ 3.5735731174968156e-05 2.3999998048427911e-10
+ 3.5747938206218154e-05 2.3999998054712477e-10
+ 3.5760145237468153e-05 2.3999998057013456e-10
+ 3.5772352268718159e-05 2.3999998051176627e-10
+ 3.5784559299968157e-05 2.3999998057450993e-10
+ 3.5796766331218156e-05 2.3999998053652084e-10
+ 3.5808973362468155e-05 2.3999998056705243e-10
+ 3.582118039371816e-05 2.399999805326457e-10
+ 3.5833387424968159e-05 2.399999805718764e-10
+ 3.5845594456218157e-05 2.3999998054921403e-10
+ 3.5857801487468156e-05 2.3999998061819825e-10
+ 3.5870008518718161e-05 2.399999805688973e-10
+ 3.588221554996816e-05 2.3999998054792621e-10
+ 3.5894422581218159e-05 2.39999980627754e-10
+ 3.5906629612468157e-05 2.3999998059474422e-10
+ 3.5918836643718163e-05 2.399999805933057e-10
+ 3.5931043674968161e-05 2.3999998057922352e-10
+ 3.594325070621816e-05 2.3999998056088616e-10
+ 3.5955457737468159e-05 2.3999998058786213e-10
+ 3.5967664768718164e-05 2.399999806005213e-10
+ 3.5979871799968163e-05 2.3999998060792622e-10
+ 3.5992078831218161e-05 2.3999998061547279e-10
+ 3.600428586246816e-05 2.3999998062637359e-10
+ 3.6016492893718166e-05 2.3999998064254068e-10
+ 3.6028699924968164e-05 2.399999806651119e-10
+ 3.6040906956218163e-05 2.3999998065019003e-10
+ 3.6053113987468162e-05 2.3999998066078063e-10
+ 3.6065321018718167e-05 2.399999807158811e-10
+ 3.6077528049968166e-05 2.3999998065933043e-10
+ 3.6089735081218164e-05 2.3999998069949765e-10
+ 3.6101942112468163e-05 2.3999998071137632e-10
+ 3.6114149143718168e-05 2.3999998066492584e-10
+ 3.6126356174968167e-05 2.3999998067631891e-10
+ 3.6138563206218166e-05 2.3999998068067386e-10
+ 3.6150770237468164e-05 2.3999998072884115e-10
+ 3.616297726871817e-05 2.3999998071703879e-10
+ 3.6175184299968168e-05 2.399999807620995e-10
+ 3.6187391331218167e-05 2.3999998071038665e-10
+ 3.6199598362468166e-05 2.3999998068359319e-10
+ 3.6211805393718171e-05 2.3999998073934671e-10
+ 3.622401242496817e-05 2.3999998074833904e-10
+ 3.6236219456218168e-05 2.3999998072288318e-10
+ 3.6248426487468167e-05 2.3999998078919143e-10
+ 3.6260633518718173e-05 2.3999998076965073e-10
+ 3.6272840549968171e-05 2.399999807468099e-10
+ 3.628504758121817e-05 2.3999998076982682e-10
+ 3.6297254612468169e-05 2.3999998077882701e-10
+ 3.6309461643718174e-05 2.3999998078272732e-10
+ 3.6321668674968173e-05 2.3999998077698307e-10
+ 3.6333875706218171e-05 2.3999998078844893e-10
+ 3.634608273746817e-05 2.3999998080355428e-10
+ 3.6358289768718175e-05 2.3999998082407074e-10
+ 3.6370496799968174e-05 2.3999998085105249e-10
+ 3.6382703831218173e-05 2.3999998076975625e-10
+ 3.6394910862468171e-05 2.399999808033618e-10
+ 3.6407117893718177e-05 2.3999998080328762e-10
+ 3.6419324924968175e-05 2.3999998084082399e-10
+ 3.6431531956218174e-05 2.3999998077877215e-10
+ 3.6443738987468173e-05 2.3999998083679345e-10
+ 3.6455946018718178e-05 2.3999998087406507e-10
+ 3.6468153049968177e-05 2.3999998083776306e-10
+ 3.6480360081218175e-05 2.3999998086990843e-10
+ 3.6492567112468174e-05 2.3999998083702247e-10
+ 3.650477414371818e-05 2.399999808776692e-10
+ 3.6516981174968178e-05 2.3999998085631119e-10
+ 3.6529188206218177e-05 2.3999998083949021e-10
+ 3.6541395237468176e-05 2.3999929577393646e-10
+ 3.6553602268718181e-05 2.3999721430085655e-10
+ 3.656580929996818e-05 2.3999541801853927e-10
+ 3.6578016331218178e-05 2.3999352441667849e-10
+ 3.6590223362468177e-05 2.3998998231508299e-10
+ 3.6602430393718182e-05 2.3998269751518182e-10
+ 3.6614637424968181e-05 2.3996731785187146e-10
+ 3.662074094059318e-05 2.3994983464395233e-10
+ 3.662684445621818e-05 2.3990674100743305e-10
+ 3.6629896214030679e-05 2.3985615585153402e-10
+ 3.6632947971843179e-05 2.3973456609508262e-10
+ 3.6634473850749432e-05 2.3959023649420816e-10
+ 3.6635999729655679e-05 2.3924487360909957e-10
+ 3.6636991106889185e-05 2.3866252493064795e-10
+ 3.6637269733896245e-05 2.3836567845599657e-10
+ 3.6637548360903298e-05 2.3795958755937176e-10
+ 3.6638098835627972e-05 2.3707317678626589e-10
+ 3.6640875273912432e-05 2.3289947932096134e-10
+ 3.6653082305162437e-05 2.1857108082062022e-10
+ 3.6665289336412436e-05 2.0744394567167327e-10
+ 3.6677496367662435e-05 1.9657101424192844e-10
+ 3.668970339891244e-05 1.8444183633608339e-10
+ 3.6701910430162439e-05 1.7048236032410772e-10
+ 3.6714117461412438e-05 1.5473832156939622e-10
+ 3.6726324492662436e-05 1.376643966131987e-10
+ 3.6738531523912435e-05 1.1997405552563603e-10
+ 3.675073855516244e-05 1.0252468847149855e-10
+ 3.6762945586412439e-05 8.622433036431135e-11
+ 3.6775152617662438e-05 7.1953269034585456e-11
+ 3.6787359648912443e-05 6.0497851486217764e-11
+ 3.6799566680162442e-05 5.2496010132610782e-11
+ 3.681177371141244e-05 4.8395088933560857e-11
+ 3.6823980742662439e-05 4.8422873289603413e-11
+ 3.6836187773912438e-05 5.2572582289997926e-11
+ 3.6848394805162443e-05 6.0602144636946106e-11
+ 3.6860601836412442e-05 7.2047475992215135e-11
+ 3.687280886766244e-05 8.6248800170538565e-11
+ 3.6885015898912446e-05 1.0238838404643464e-10
+ 3.6897222930162444e-05 1.19537446121802e-10
+ 3.6909429961412443e-05 1.367094991032434e-10
+ 3.6921636992662442e-05 1.5291703382970249e-10
+ 3.693384402391244e-05 1.6722827017382802e-10
+ 3.6936895781724947e-05 1.7041028620342427e-10
+ 3.6937048369615566e-05 1.7056469761267313e-10
+ 3.6937429839342128e-05 1.7094872387604414e-10
+ 3.6937467986314789e-05 1.7098696858623529e-10
+ 3.6937475615709322e-05 1.7099461407315297e-10
+ 3.6937490874498379e-05 1.7100990159048815e-10
+ 3.6937496978014008e-05 1.7101601530675094e-10
+ 3.6937499419420257e-05 1.7101846058671687e-10
+ 3.6937499604455783e-05 1.7101864591102341e-10
+ 3.6937499974526843e-05 1.710190165576025e-10
+ 3.6937500714668948e-05 2.9362295535076986e-10
+ 3.6937501454811054e-05 6.7955376462053112e-10
+ 3.693750885623215e-05 1.9019685483973129e-08
+ 3.6937516257653233e-05 6.3680162617685321e-08
+ 3.693752365907433e-05 1.3464578979540883e-07
+ 3.6937531060495413e-05 2.3189729697639808e-07
+ 3.693753846191651e-05 3.5541134357275011e-07
+ 3.6937547512355686e-05 5.4209487018455778e-07
+ 3.693755656279487e-05 7.6794744751962639e-07
+ 3.6937565613234047e-05 1.032901665904789e-06
+ 3.6937574663673231e-05 1.3368810846168448e-06
+ 3.6937583714112414e-05 1.6798002590529673e-06
+ 3.6937595044533513e-05 2.1638522289015684e-06
+ 3.6937606374954611e-05 2.7085809274094572e-06
+ 3.6937617705375709e-05 3.3137595140903088e-06
+ 3.6937629035796808e-05 3.9791394372703589e-06
+ 3.6937643214653363e-05 4.8961848891924115e-06
+ 3.6937657393509918e-05 5.9065041934527361e-06
+ 3.6937671572366472e-05 7.0094688242501652e-06
+ 3.6937689032396937e-05 8.4939484121898285e-06
+ 3.6937706492427402e-05 1.011650368403691e-05
+ 3.6937723952457859e-05 1.187564441966631e-05
+ 3.6937746268477829e-05 1.4320324258348367e-05
+ 3.6937768584497799e-05 1.6981891243476683e-05
+ 3.6937790900517769e-05 1.9856448881756975e-05
+ 3.6937819090217238e-05 2.3785542948120637e-05
+ 3.6937847279916707e-05 2.8038794641957824e-05
+ 3.6937875469616183e-05 3.2606525910010655e-05
+ 3.6937903659315653e-05 3.7478440563006991e-05
+ 3.6937931849015122e-05 4.2643660624918842e-05
+ 3.6937960038714591e-05 4.809076449946518e-05
+ 3.6937988228414061e-05 5.3807826764352856e-05
+ 3.6938019414106476e-05 6.0432058501488789e-05
+ 3.6938050599798885e-05 6.7354141141263776e-05
+ 3.6938081785491293e-05 7.4556149339010216e-05
+ 3.6938112971183709e-05 8.2019674226669682e-05
+ 3.6938150418414335e-05 9.1300740447793598e-05
+ 3.6938187865644967e-05 0.00010089852928503813
+ 3.6938225312875593e-05 0.00011077933330704341
+ 3.693827084419581e-05 0.00012312530862772575
+ 3.693831637551602e-05 0.00013577798574481139
+ 3.6938361906836237e-05 0.00014867616552750304
+ 3.6938407438156446e-05 0.00016175929991125412
+ 3.6938441084028112e-05 0.00017151113091571656
+ 3.6938474729899777e-05 0.00018130797963939794
+ 3.6938508375771443e-05 0.00019112690048319055
+ 3.6938542021643108e-05 0.000200945563836072
+ 3.6938575667514774e-05 0.0002107423308290232
+ 3.6938609313386439e-05 0.00022049632214156449
+ 3.6938642959258105e-05 0.00023018748061678874
+ 3.693867660512977e-05 0.00023979662749408118
+ 3.6938710251001436e-05 0.0002493055121224335
+ 3.6938736870668146e-05 0.00025674620625396695
+ 3.6938763490334856e-05 0.00026410519322842072
+ 3.6938790110001566e-05 0.00027137476557784006
+ 3.6938816729668275e-05 0.00027854762813939171
+ 3.6938843349334992e-05 0.00028561690431054267
+ 3.6938869969001702e-05 0.0002925761407342706
+ 3.6938896588668412e-05 0.0002994193104460534
+ 3.6938923208335122e-05 0.00030614081452042582
+ 3.6938949828001832e-05 0.00031273548226053464
+ 3.6938976447668542e-05 0.00031919856997935221
+ 3.6939003067335252e-05 0.00032552575842600295
+ 3.6939029687001968e-05 0.00033171314891500655
+ 3.6939056306668678e-05 0.00033775725822013397
+ 3.6939082926335388e-05 0.00034365501229800138
+ 3.6939109546002098e-05 0.00034940373890948994
+ 3.6939136165668808e-05 0.00035500115920957621
+ 3.6939162785335518e-05 0.00036044537837818884
+ 3.6939189405002228e-05 0.00036573487536628151
+ 3.6939216024668937e-05 0.00037086849183281574
+ 3.6939239404935227e-05 0.00037524816041470616
+ 3.6939262785201517e-05 0.00037950661982143294
+ 3.6939286165467807e-05 0.00038364373347733212
+ 3.693930954573409e-05 0.00038765955240256639
+ 3.693933292600038e-05 0.00039155430797307712
+ 3.693935630626667e-05 0.00039532840450424615
+ 3.693937968653296e-05 0.00039898241168751826
+ 3.6939403066799243e-05 0.00040251705690861332
+ 3.6939426447065533e-05 0.00040593321747524688
+ 3.6939449827331823e-05 0.0004092319127814815
+ 3.6939473207598113e-05 0.00041241429643495774
+ 3.6939496587864396e-05 0.00041548164837231091
+ 3.6939519968130686e-05 0.00041843536698707185
+ 3.6939543348396976e-05 0.00042127696129328835
+ 3.6939566728663266e-05 0.00042400804314699181
+ 3.6939590108929549e-05 0.00042663031954648096
+ 3.6939613489195839e-05 0.00042914558503120656
+ 3.6939636869462129e-05 0.00043155571419782471
+ 3.6939660249728419e-05 0.00043386265435075173
+ 3.6939683629994702e-05 0.0004360684183033
+ 3.6939707010260992e-05 0.00043817507734421687
+ 3.6939735591237519e-05 0.00044061881915944171
+ 3.6939764172214039e-05 0.00044292160557832261
+ 3.6939792753190567e-05 0.00044508748731897325
+ 3.6939821334167087e-05 0.0004471205811035718
+ 3.6939849915143614e-05 0.00044902505354874717
+ 3.6939886199806212e-05 0.00045126415767136695
+ 3.6939925453373379e-05 0.00045347065125915753
+ 3.6939946977215265e-05 0.00045458914938144757
+ 3.6939973696714701e-05 0.00045589098737442259
+ 3.6940000416214137e-05 0.00045710004038524538
+ 3.6940027135713573e-05 0.00045821970861944291
+ 3.6940053855213009e-05 0.00045925335947318648
+ 3.6940080574712445e-05 0.00046020432082601948
+ 3.6940107294211881e-05 0.00046107587487371744
+ 3.6940134013711317e-05 0.00046187125249194449
+ 3.6940160733210753e-05 0.00046259362811953432
+ 3.6940187452710189e-05 0.00046324611514856153
+ 3.6940214172209626e-05 0.00046383176180687778
+ 3.6940240891709062e-05 0.00046435354751746608
+ 3.6940262548859615e-05 0.00046473161709406521
+ 3.6940284206010162e-05 0.00046507115570231151
+ 3.6940305863160715e-05 0.00046537364255429416
+ 3.6940327520311269e-05 0.00046564052306956875
+ 3.6940349177461815e-05 0.00046587320827894959
+ 3.6940370834612369e-05 0.00046607307433484731
+ 3.6940392491762922e-05 0.00046624146212347479
+ 3.6940414148913476e-05 0.00046637967697419719
+ 3.6940435806064029e-05 0.00046648898846127722
+ 3.6940457463214576e-05 0.00046657063029325929
+ 3.6940479120365129e-05 0.0004666258002852115
+ 3.6940496765399604e-05 0.00046665198683365781
+ 3.6940514410434078e-05 0.00046666198405394353
+ 3.6940532055468553e-05 0.00046665638716889121
+ 3.6940549700503021e-05 0.00046663577581361698
+ 3.6940567345537495e-05 0.00046660071413966874
+ 3.694058499057197e-05 0.00046655175093608377
+ 3.6940602635606445e-05 0.00046648941976632619
+ 3.6940620280640919e-05 0.00046641423912008399
+ 3.6940637925675394e-05 0.00046632671257892689
+ 3.6940655570709868e-05 0.00046622732899484812
+ 3.6940673215744343e-05 0.00046611656268073646
+ 3.6940690860778818e-05 0.00046599487361184948
+ 3.6940708505813286e-05 0.00046586270763738396
+ 3.694072615084776e-05 0.00046572049670126538
+ 3.6940743795882235e-05 0.00046556865907130521
+ 3.6940761440916709e-05 0.00046540759957590188
+ 3.6940779085951184e-05 0.00046523770984748908
+ 3.6940796730985659e-05 0.00046505936857196291
+ 3.6940814376020133e-05 0.00046487294174334804
+ 3.6940832021054601e-05 0.00046467878292299136
+ 3.6940849666089076e-05 0.00046447723350260048
+ 3.694086731112355e-05 0.00046426862297047311
+ 3.6940884956158025e-05 0.00046405326918029163
+ 3.6940902601192499e-05 0.00046383147862188659
+ 3.6940920246226974e-05 0.0004636035466933999
+ 3.6940937891261449e-05 0.00046336975797430831
+ 3.6940955536295923e-05 0.00046313038649879376
+ 3.6940973181330398e-05 0.00046288569602897633
+ 3.6940990826364866e-05 0.00046263594032755121
+ 3.694100847139934e-05 0.00046238136342939871
+ 3.6941026116433815e-05 0.00046212219991176166
+ 3.694104376146829e-05 0.00046185867516261082
+ 3.6941061406502764e-05 0.00046159100564684353
+ 3.6941079051537239e-05 0.00046131939916998468
+ 3.6941096696571713e-05 0.00046104405513908457
+ 3.6941114341606181e-05 0.00046076516482052872
+ 3.6941131986640656e-05 0.00046048291159450004
+ 3.6941149631675131e-05 0.00046019747120585279
+ 3.6941167276709605e-05 0.00045990901201118061
+ 3.694118492174408e-05 0.00045961769522188066
+ 3.6941202566778554e-05 0.00045932367514303494
+ 3.6941220211813029e-05 0.00045902709940794936
+ 3.6941237856847504e-05 0.00045872810920820898
+ 3.6941255501881978e-05 0.00045842683951912496
+ 3.6941273146916446e-05 0.00045812341932046545
+ 3.6941290791950921e-05 0.00045781797181237863
+ 3.6941308436985395e-05 0.00045751061462643097
+ 3.694132608201987e-05 0.00045720146003169808
+ 3.6941343727054345e-05 0.00045689061513585962
+ 3.6941361372088819e-05 0.00045657818208126165
+ 3.6941379017123294e-05 0.00045626425823592343
+ 3.6941396662157762e-05 0.0004559489363794755
+ 3.6941414307192236e-05 0.0004556323048840281
+ 3.6941431952226711e-05 0.00045531444788997848
+ 3.6941449597261185e-05 0.00045499544547677518
+ 3.694146724229566e-05 0.00045467537382866608
+ 3.6941484887330135e-05 0.00045435430539546583
+ 3.6941502532364609e-05 0.00045403230904838535
+ 3.6941520177399084e-05 0.00045370945023097327
+ 3.6941537822433559e-05 0.00045338579110522598
+ 3.6941555467468026e-05 0.00045306139069292836
+ 3.6941573112502501e-05 0.00045273630501229328
+ 3.6941590757536976e-05 0.00045241058720997258
+ 3.694160840257145e-05 0.00045208428768851668
+ 3.6941626047605925e-05 0.00045175745422936376
+ 3.6941643692640399e-05 0.00045143013211144381
+ 3.6941661337674874e-05 0.00045110236422548483
+ 3.6941682620107572e-05 0.00045070649383213837
+ 3.6941702745281676e-05 0.00045033166770387813
+ 3.6941722870455779e-05 0.00044995642757493547
+ 3.6941742995629883e-05 0.00044958082330929242
+ 3.6941763120803986e-05 0.00044920490166811688
+ 3.6941783245978089e-05 0.00044882870648050557
+ 3.6941803371152193e-05 0.00044845227880637947
+ 3.6941823496326296e-05 0.00044807565709178331
+ 3.69418436215004e-05 0.00044769887731683952
+ 3.6941863746674496e-05 0.00044732197313660687
+ 3.6941888110746129e-05 0.00044686556133260454
+ 3.6941912474817755e-05 0.00044640906499999366
+ 3.6941936838889381e-05 0.00044595253182312878
+ 3.6941961202961007e-05 0.00044549600565976083
+ 3.6941985567032639e-05 0.00044503952681690417
+ 3.6942009931104265e-05 0.00044458313230938829
+ 3.6942034295175891e-05 0.00044412685610195336
+ 3.6942058659247517e-05 0.00044367072933572632
+ 3.6942083023319149e-05 0.00044321478053989036
+ 3.6942107387390775e-05 0.00044275903582933563
+ 3.6942136719683568e-05 0.00044221066197735565
+ 3.6942166051976361e-05 0.00044166265618977781
+ 3.6942195384269161e-05 0.00044111505229614979
+ 3.6942224716561954e-05 0.000440567880571222
+ 3.6942254048854747e-05 0.0004400211680723513
+ 3.6942283381147541e-05 0.0004394749389480193
+ 3.694231271344034e-05 0.0004389292147195882
+ 3.6942342045733134e-05 0.00043838401453830063
+ 3.6942377848029198e-05 0.00043771929099924211
+ 3.6942412335454626e-05 0.00043707976746529866
+ 3.694244682288006e-05 0.00043644103787377733
+ 3.6942481310305494e-05 0.00043580312030283216
+ 3.6942515797730929e-05 0.00043516603032572377
+ 3.6942557828321207e-05 0.00043439073279079223
+ 3.6942599858911485e-05 0.00043361670459320404
+ 3.694264188950177e-05 0.00043284396248195208
+ 3.6942683920092048e-05 0.00043207252012209858
+ 3.6942725950682326e-05 0.00043130238856505936
+ 3.6942777518503424e-05 0.00043035930871672526
+ 3.6942828186666483e-05 0.00042943462880424378
+ 3.6942878854829541e-05 0.00042851188736760037
+ 3.6942929522992593e-05 0.00042759109050169295
+ 3.6942993215143458e-05 0.00042643637215815307
+ 3.6943056907294322e-05 0.0004252847370223043
+ 3.6943120599445186e-05 0.00042413618616643506
+ 3.6943198945610713e-05 0.00042272760989246018
+ 3.6943278657649691e-05 0.00042129925771114857
+ 3.6943358369688669e-05 0.00041987571829712041
+ 3.6943461292370765e-05 0.00041804477075287836
+ 3.6943569508909821e-05 0.00041612824858809757
+ 3.6943701914804439e-05 0.00041379527174881443
+ 3.6943847065030181e-05 0.00041125276249577136
+ 3.6944034315235682e-05 0.00040799587225246868
+ 3.6944255865010424e-05 0.00040417569543334638
+ 3.6944554034092506e-05 0.00039909077578923559
+ 3.6944998769870889e-05 0.00039162496079868337
+ 3.6945805003988991e-05 0.00037844492463713218
+ 3.6946711764368318e-05 0.00036415075183872955
+ 3.6947737475686439e-05 0.00034863113834200367
+ 3.6948801143402343e-05 0.00033323544260725887
+ 3.6949944764949543e-05 0.00031744009309453978
+ 3.6952231646278908e-05 0.00028806442739914481
+ 3.6954182681216656e-05 0.00026516169925578173
+ 3.695629122851725e-05 0.00024245284579639417
+ 3.6958581467436159e-05 0.00021998507757767748
+ 3.6960926666850023e-05 0.00019913410083615226
+ 3.6963271866263888e-05 0.00018025945489984468
+ 3.6965590537179632e-05 0.00016335772611693962
+ 3.6968474569484278e-05 0.00014452917890563918
+ 3.6971358601788931e-05 0.00012787080313841811
+ 3.6974242634093578e-05 0.00011313246567173927
+ 3.6977126666398224e-05 0.00010009286360866482
+ 3.6980010698702878e-05 8.8556201336288662e-05
+ 3.6982894731007524e-05 7.8349250567829904e-05
+ 3.6985778763312178e-05 6.9318749243295542e-05
+ 3.6989342797663595e-05 5.9583601550415324e-05
+ 3.6992906832015012e-05 5.12156620124964e-05
+ 3.6996470866366436e-05 4.4022919356413453e-05
+ 3.7000034900717853e-05 3.7840328450154061e-05
+ 3.700359893506927e-05 3.2526023165760874e-05
+ 3.7007899961127363e-05 2.7096692323683933e-05
+ 3.7012200987185449e-05 2.2573641128908005e-05
+ 3.7016502013243542e-05 1.8805590756409222e-05
+ 3.7020803039301629e-05 1.5666514280396347e-05
+ 3.7025104065359715e-05 1.3051421554109079e-05
+ 3.7030502505986986e-05 1.0377818664489998e-05
+ 3.7035900946614249e-05 8.251909089995107e-06
+ 3.7041299387241513e-05 6.5614966739560858e-06
+ 3.7046697827868783e-05 5.2173688876777125e-06
+ 3.7053468247657471e-05 3.9138135354349389e-06
+ 3.7060238667446159e-05 2.9359531577328348e-06
+ 3.7067009087234846e-05 2.2024124497970242e-06
+ 3.7075385304343959e-05 1.5432541258101081e-06
+ 3.7083761521453071e-05 1.081378721967762e-06
+ 3.7092137738562184e-05 7.5774041132707628e-07
+ 3.7103043385488656e-05 4.7689837631713853e-07
+ 3.7113949032415129e-05 3.0015113649486665e-07
+ 3.7126156063665134e-05 1.7876217937191045e-07
+ 3.7138363094915133e-05 1.0647330757921957e-07
+ 3.7150570126165132e-05 6.3424252544034479e-08
+ 3.716277715741513e-05 3.7787934734000867e-08
+ 3.7174984188665129e-05 2.2521155841269887e-08
+ 3.7187191219915134e-05 1.3429588576020001e-08
+ 3.7199398251165133e-05 8.015449872567151e-09
+ 3.7211605282415132e-05 4.7912734917149069e-09
+ 3.7223812313665137e-05 2.871251600636248e-09
+ 3.7236019344915136e-05 1.7278727196949598e-09
+ 3.7248226376165134e-05 1.0469960699243559e-09
+ 3.7260433407415133e-05 6.4154623608527275e-10
+ 3.7272640438665132e-05 4.0011708092908531e-10
+ 3.7284847469915137e-05 2.563646256420896e-10
+ 3.7297054501165136e-05 1.7078006330613652e-10
+ 3.7309261532415134e-05 1.1983532309874618e-10
+ 3.732146856366514e-05 8.9519095817165878e-11
+ 3.7333675594915139e-05 7.14874426319846e-11
+ 3.7345882626165137e-05 6.0771426293748156e-11
+ 3.7358089657415136e-05 5.4411972164600532e-11
+ 3.7370296688665134e-05 5.0646908151112081e-11
+ 3.738250371991514e-05 4.8426835103990855e-11
+ 3.7394710751165139e-05 4.7126820532761082e-11
+ 3.7406917782415137e-05 4.6374708016315066e-11
+ 3.7419124813665143e-05 4.594887297816922e-11
+ 3.7431331844915141e-05 4.5717334758833713e-11
+ 3.744353887616514e-05 4.5601496954841019e-11
+ 3.7455745907415139e-05 4.5554554261028926e-11
+ 3.7467952938665137e-05 4.5548633436145208e-11
+ 3.7480159969915143e-05 4.5567135561437956e-11
+ 3.7492367001165141e-05 4.5600175741221697e-11
+ 3.7500000000000003e-05 4.5624752229059989e-11
+ 3.7512207031250002e-05 4.5669966819297461e-11
+ 3.7524414062500001e-05 4.5718898557805248e-11
+ 3.7536621093750006e-05 4.5770037749483043e-11
+ 3.7548828125000005e-05 4.5822485350610839e-11
+ 3.7561035156250004e-05 4.5875705969269391e-11
+ 3.7573242187500002e-05 4.5929380773488921e-11
+ 3.7585449218750001e-05 4.5983319895906806e-11
+ 3.7597656250000006e-05 4.6037410269464089e-11
+ 3.7609863281250005e-05 4.6091584562801975e-11
+ 3.7622070312500004e-05 4.6145802680837535e-11
+ 3.7634277343750002e-05 4.6200040748086769e-11
+ 3.7646484375000001e-05 4.6254284548072891e-11
+ 3.7658691406250006e-05 4.6308525616398256e-11
+ 3.7670898437500005e-05 4.6362758914111761e-11
+ 3.7683105468750004e-05 4.641698144216514e-11
+ 3.7695312500000002e-05 4.6471191416301583e-11
+ 3.7707519531250001e-05 4.6525387775689795e-11
+ 3.7719726562500006e-05 4.6579569890308451e-11
+ 3.7731933593750005e-05 4.663373738668933e-11
+ 3.7744140625000004e-05 4.6687890044144897e-11
+ 3.7756347656250002e-05 4.6742027732970226e-11
+ 3.7768554687500001e-05 4.6796150377641402e-11
+ 3.7780761718750006e-05 4.6850257934899579e-11
+ 3.7792968750000005e-05 4.690435038069982e-11
+ 3.7805175781250004e-05 4.695842770243876e-11
+ 3.7817382812500002e-05 4.7012489894326265e-11
+ 3.7829589843750001e-05 4.7066536954629075e-11
+ 3.7841796875000007e-05 4.7120568884029375e-11
+ 3.7854003906250005e-05 4.7174585684647293e-11
+ 3.7866210937500004e-05 4.7228587359458799e-11
+ 3.7878417968750002e-05 4.728257391194907e-11
+ 3.7890625000000001e-05 4.7336545345906017e-11
+ 3.7902832031250007e-05 4.7390501665297362e-11
+ 3.7915039062500005e-05 4.7444442874197415e-11
+ 3.7927246093750004e-05 4.7498368976743532e-11
+ 3.7939453125000003e-05 4.7552279977110043e-11
+ 3.7951660156250001e-05 4.7606175879492929e-11
+ 3.79638671875e-05 4.76600566881005e-11
+ 3.7976074218750005e-05 4.771392240714795e-11
+ 3.7988281250000004e-05 4.7767773040854128e-11
+ 3.8000488281250003e-05 4.7821608593439534e-11
+ 3.8012695312500001e-05 4.7875429069125182e-11
+ 3.802490234375e-05 4.7929234472131972e-11
+ 3.8037109375000005e-05 4.7983024806680162e-11
+ 3.8049316406250004e-05 4.8036800076989225e-11
+ 3.8061523437500003e-05 4.8090560287277661e-11
+ 3.8073730468750001e-05 4.81443054417629e-11
+ 3.8085937500000007e-05 4.8198035544661283e-11
+ 3.8098144531250005e-05 4.8251750600188019e-11
+ 3.8110351562500004e-05 4.8305450612557161e-11
+ 3.8122558593750003e-05 4.835913558598157e-11
+ 3.8134765625000001e-05 4.8412805524672993e-11
+ 3.8146972656250007e-05 4.846646043284194e-11
+ 3.8159179687500005e-05 4.8520100314697792e-11
+ 3.8171386718750004e-05 4.8573725174448732e-11
+ 3.8183593750000003e-05 4.8627335016301782e-11
+ 3.8195800781250001e-05 4.8680929844462761e-11
+ 3.8208007812500007e-05 4.8734509663136332e-11
+ 3.8220214843750005e-05 4.8788074476525962e-11
+ 3.8232421875000004e-05 4.8841624288833967e-11
+ 3.8244628906250003e-05 4.8895159104261467e-11
+ 3.8256835937500001e-05 4.894867892700839e-11
+ 3.8269042968750007e-05 4.9002183761273549e-11
+ 3.8281250000000006e-05 4.905567361125451e-11
+ 3.8293457031250004e-05 4.9109148481147716e-11
+ 3.8305664062500003e-05 4.9162608375148381e-11
+ 3.8317871093750002e-05 4.9216053297450589e-11
+ 3.8330078125000007e-05 4.9269483252247235e-11
+ 3.8342285156250006e-05 4.932289824373005e-11
+ 3.8354492187500004e-05 4.9376298276089576e-11
+ 3.8366699218750003e-05 4.9429683353515166e-11
+ 3.8378906250000002e-05 4.9483053480195042e-11
+ 3.8391113281250007e-05 4.9536408660316226e-11
+ 3.8403320312500006e-05 4.9589748898064572e-11
+ 3.8415527343750004e-05 4.9643074197624777e-11
+ 3.8427734375000003e-05 4.9696384563180337e-11
+ 3.8439941406250002e-05 4.9749679998913594e-11
+ 3.8452148437500007e-05 4.980296050900572e-11
+ 3.8464355468750006e-05 4.9856226097636712e-11
+ 3.8476562500000004e-05 4.99094767689854e-11
+ 3.8488769531250003e-05 4.9962712527229435e-11
+ 3.8500976562500002e-05 5.0015933376545304e-11
+ 3.8513183593750007e-05 5.0069139321108297e-11
+ 3.8525390625000006e-05 5.0122330365092602e-11
+ 3.8537597656250004e-05 5.0175506512671175e-11
+ 3.8549804687500003e-05 5.0228667768015851e-11
+ 3.8562011718750002e-05 5.0281814135297241e-11
+ 3.8574218750000007e-05 5.0334945618684835e-11
+ 3.8586425781250006e-05 5.0388062222346936e-11
+ 3.8598632812500004e-05 5.0441163950450669e-11
+ 3.8610839843750003e-05 5.0494250807162017e-11
+ 3.8623046875000002e-05 5.0547322796645784e-11
+ 3.863525390625e-05 5.060037992306559e-11
+ 3.8647460937500006e-05 5.0653422190583924e-11
+ 3.8659667968750005e-05 5.0706449603362099e-11
+ 3.8671875000000003e-05 5.0759462165560252e-11
+ 3.8684082031250002e-05 5.0812459881337356e-11
+ 3.86962890625e-05 5.086544275485121e-11
+ 3.8708496093750006e-05 5.0918410790258479e-11
+ 3.8720703125000005e-05 5.0971363991714641e-11
+ 3.8732910156250003e-05 5.1024302363374004e-11
+ 3.8745117187500002e-05 5.1077225909389738e-11
+ 3.8757324218750001e-05 5.1130134633913832e-11
+ 3.8769531249999999e-05 5.1183028541097097e-11
+ 3.8781738281250005e-05 5.123590763508922e-11
+ 3.8793945312500003e-05 5.1288771920038706e-11
+ 3.8806152343750002e-05 5.1341621400092889e-11
+ 3.8818359375000001e-05 5.1394456079397949e-11
+ 3.8830566406249999e-05 5.1447275962098919e-11
+ 3.8842773437500005e-05 5.1500081052339658e-11
+ 3.8854980468750003e-05 5.1552871354262853e-11
+ 3.8867187500000002e-05 5.1605646872010057e-11
+ 3.8879394531250001e-05 5.1658407609721638e-11
+ 3.8891601562499999e-05 5.171115357153682e-11
+ 3.8903808593750005e-05 5.1763884761593666e-11
+ 3.8916015625000003e-05 5.1816601184029079e-11
+ 3.8928222656250002e-05 5.1869302842978788e-11
+ 3.8940429687500001e-05 5.1921989742577379e-11
+ 3.8952636718749999e-05 5.1974661886958285e-11
+ 3.8964843750000005e-05 5.2027319280253771e-11
+ 3.8977050781250003e-05 5.2079961926594946e-11
+ 3.8989257812500002e-05 5.2132589830111786e-11
+ 3.9001464843750001e-05 5.2185202994933079e-11
+ 3.9013671874999999e-05 5.2237801425186463e-11
+ 3.9025878906249998e-05 5.2290385124998426e-11
+ 3.9038085937500004e-05 5.2342954098494298e-11
+ 3.9050292968750002e-05 5.2395508349798247e-11
+ 3.9062500000000001e-05 5.2448047883033309e-11
+ 3.9074707031249999e-05 5.2500572702321331e-11
+ 3.9086914062499998e-05 5.2553082811783024e-11
+ 3.9099121093750004e-05 5.260557821553798e-11
+ 3.9111328125000002e-05 5.265805891770455e-11
+ 3.9123535156250001e-05 5.2710524922400013e-11
+ 3.91357421875e-05 5.2762976233740464e-11
+ 3.9147949218749998e-05 5.281541285584085e-11
+ 3.9160156249999997e-05 5.2867834792814952e-11
+ 3.9172363281250002e-05 5.2920242048775429e-11
+ 3.9184570312500001e-05 5.297263462783375e-11
+ 3.919677734375e-05 5.3025012534100265e-11
+ 3.9208984374999998e-05 5.3077375771684144e-11
+ 3.9221191406249997e-05 5.3129724344693429e-11
+ 3.9233398437500002e-05 5.3182058257235008e-11
+ 3.9245605468750001e-05 5.3234377513414598e-11
+ 3.92578125e-05 5.3286682117336819e-11
+ 3.9270019531249998e-05 5.3338972073105086e-11
+ 3.9282226562499997e-05 5.339124738482168e-11
+ 3.9294433593750002e-05 5.3443508056587737e-11
+ 3.9306640625000001e-05 5.349575409250326e-11
+ 3.931884765625e-05 5.3547985496667078e-11
+ 3.9331054687499998e-05 5.3600202273176877e-11
+ 3.9343261718749997e-05 5.3652404426129203e-11
+ 3.9355468750000002e-05 5.3704591959619454e-11
+ 3.9367675781250001e-05 5.3756764877741888e-11
+ 3.93798828125e-05 5.3808923184589598e-11
+ 3.9392089843749998e-05 5.3861066884254534e-11
+ 3.9404296874999997e-05 5.3913195980827531e-11
+ 3.9416503906249996e-05 5.3965310478398236e-11
+ 3.9428710937500001e-05 5.4017410381055188e-11
+ 3.944091796875e-05 5.4069495692885746e-11
+ 3.9453124999999998e-05 5.4121566417976143e-11
+ 3.9465332031249997e-05 5.4173622560411455e-11
+ 3.9477539062499996e-05 5.4225664124275648e-11
+ 3.9489746093750001e-05 5.4277691113651499e-11
+ 3.9501953125e-05 5.4329703532620677e-11
+ 3.9514160156249999e-05 5.4381701385263697e-11
+ 3.9526367187499997e-05 5.4433684675659917e-11
+ 3.9538574218749996e-05 5.4485653407887576e-11
+ 3.9550781249999994e-05 5.4537607586023745e-11
+ 3.956298828125e-05 5.4589547214144361e-11
+ 3.9575195312499999e-05 5.4641472296324253e-11
+ 3.9587402343749997e-05 5.4693382836637059e-11
+ 3.9599609374999996e-05 5.4745278839155299e-11
+ 3.9611816406249995e-05 5.4797160307950356e-11
+ 3.96240234375e-05 5.4849027247092475e-11
+ 3.9636230468749999e-05 5.4900879660650734e-11
+ 3.9648437499999997e-05 5.4952717552693121e-11
+ 3.9660644531249996e-05 5.5004540927286431e-11
+ 3.9672851562499995e-05 5.5055228596414379e-11
+ 3.968505859375e-05 5.510627065877697e-11
+ 3.9697265624999999e-05 5.5158092921228189e-11
+ 3.9709472656249997e-05 5.5210849104087091e-11
+ 3.9721679687499996e-05 5.5264521350196526e-11
+ 3.9733886718749995e-05 5.5318219478297029e-11
+ 3.9739990234374994e-05 5.5343709041866146e-11
+ 3.974609375e-05 5.5365175813779936e-11
+ 3.97491455078125e-05 5.537183500008943e-11
+ 3.9752197265624999e-05 5.5371668509114686e-11
+ 3.9755249023437499e-05 5.5354771851498252e-11
+ 3.9756606790774091e-05 5.5334751403020664e-11
+ 3.9756998216660864e-05 5.5326313558461538e-11
+ 3.9757389642547637e-05 5.5316205768572161e-11
+ 3.9758368207264579e-05 5.5280832763072969e-11
+ 3.975940950290819e-05 5.5216998316807767e-11
+ 3.9759970598735325e-05 5.5162661637241072e-11
+ 3.9760339629298371e-05 5.5114439869388932e-11
+ 3.9761110323815846e-05 5.4960015216721681e-11
+ 3.9761741481233849e-05 5.4732817211499076e-11
+ 3.9762113084009011e-05 5.4516300482441227e-11
+ 3.9762434193795789e-05 5.42419953316085e-11
+ 3.9762647097925411e-05 5.400886072195258e-11
+ 3.9762860002055033e-05 5.3774257755821461e-11
+ 3.9764989043351247e-05 5.1549852354822979e-11
+ 3.9777196074601246e-05 4.2855387214314058e-11
+ 3.9789403105851245e-05 4.053247294954365e-11
+ 3.980161013710125e-05 4.3931039996784842e-11
+ 3.9813817168351249e-05 5.2388572167819672e-11
+ 3.9826024199601247e-05 6.5140225940715896e-11
+ 3.9838231230851246e-05 8.1286621114128428e-11
+ 3.9850438262101245e-05 9.9800201152591339e-11
+ 3.9862645293351243e-05 1.1955731974057662e-10
+ 3.9874852324601249e-05 1.3938677731239894e-10
+ 3.9887059355851247e-05 1.581275910662053e-10
+ 3.9899266387101246e-05 1.7469004130247602e-10
+ 3.9911473418351245e-05 1.881149150311095e-10
+ 3.9923680449601243e-05 1.9762660690176225e-10
+ 3.9935887480851249e-05 2.026764694324815e-10
+ 3.9948094512101248e-05 2.0297359093770258e-10
+ 3.9960301543351246e-05 1.9850103705845601e-10
+ 3.9972508574601245e-05 1.8951650785639057e-10
+ 3.9984715605851244e-05 1.7653730627935789e-10
+ 3.9996922637101249e-05 1.6031044421422816e-10
+ 4.0009129668351248e-05 1.4176958358946107e-10
+ 4.0021336699601246e-05 1.2198127662112241e-10
+ 4.0033543730851245e-05 1.0208359001036545e-10
+ 4.0045750762101244e-05 8.3220638681385549e-11
+ 4.0057957793351249e-05 6.6476791169901555e-11
+ 4.0061009551163749e-05 6.2738216402259133e-11
+ 4.0061314726944994e-05 6.2375524734021021e-11
+ 4.0062077666398117e-05 6.1477937832984702e-11
+ 4.0062459136124685e-05 6.1034090082773124e-11
+ 4.0062482977982596e-05 6.1006459924724939e-11
+ 4.0062487746354173e-05 6.1000935454857881e-11
+ 4.006249728309734e-05 6.0989888077255491e-11
+ 4.0062498046036789e-05 6.0989004377034889e-11
+ 4.0062499571915699e-05 6.0987237016591268e-11
+ 4.0062499693986008e-05 6.0987095630059761e-11
+ 4.0062499938126633e-05 6.0986812858020706e-11
+ 4.0062499957657885e-05 6.0986790236316644e-11
+ 4.0062499996720388e-05 6.098674499293473e-11
+ 4.0062500074845388e-05 6.2330481534674083e-11
+ 4.0062500152970387e-05 6.6608198187672893e-11
+ 4.0062500934220384e-05 2.7075208822833839e-10
+ 4.0062508051845979e-05 1.5641542586395462e-08
+ 4.0062515169471573e-05 5.5354276368357439e-08
+ 4.0062522287097167e-05 1.1939590331347595e-07
+ 4.0062529404722768e-05 2.0774988808958391e-07
+ 4.0062536522348362e-05 3.2039621340029153e-07
+ 4.0062543639973957e-05 4.5731138406416947e-07
+ 4.0062550757599558e-05 6.1846843192454422e-07
+ 4.0062557875225152e-05 8.0383692158836119e-07
+ 4.0062564992850746e-05 1.0133829569922963e-06
+ 4.0062572110476347e-05 1.2470691887940203e-06
+ 4.0062579228101942e-05 1.5048548225862434e-06
+ 4.0062587807568574e-05 1.8475543476526228e-06
+ 4.0062596387035206e-05 2.2251205386231599e-06
+ 4.0062604966501838e-05 2.637462112110794e-06
+ 4.006261354596847e-05 3.0844806091734263e-06
+ 4.0062622125435102e-05 3.5660704276185103e-06
+ 4.0062630704901734e-05 4.0821188567621002e-06
+ 4.0062639284368366e-05 4.6325061146258863e-06
+ 4.0062647863834998e-05 5.2171053875545835e-06
+ 4.0062658180770252e-05 5.965211217502911e-06
+ 4.0062668497705512e-05 6.7623492313414161e-06
+ 4.0062678814640766e-05 7.6082590651614992e-06
+ 4.0062689131576019e-05 8.5026660760363497e-06
+ 4.0062699448511273e-05 9.4452814742207388e-06
+ 4.0062709765446527e-05 1.0435802462230257e-05
+ 4.0062720082381787e-05 1.147391238070454e-05
+ 4.0062730399317041e-05 1.25592808609545e-05
+ 4.0062742902012263e-05 1.393744004677843e-05
+ 4.0062755404707479e-05 1.538385928477854e-05
+ 4.0062767907402702e-05 1.6897871760843825e-05
+ 4.0062780410097917e-05 1.8478782715895571e-05
+ 4.006279291279314e-05 2.0125869935940648e-05
+ 4.0062805415488355e-05 2.1838384260846487e-05
+ 4.0062817918183578e-05 2.3615550111329756e-05
+ 4.00628304208788e-05 2.5456566033633845e-05
+ 4.0062845592253875e-05 2.7775100207116592e-05
+ 4.0062860763628957e-05 3.0184906039223483e-05
+ 4.0062875935004038e-05 3.2684405463249104e-05
+ 4.0062891106379113e-05 3.5271969973378807e-05
+ 4.0062906277754194e-05 3.7945922288216153e-05
+ 4.0062921449129276e-05 4.0704538058428326e-05
+ 4.0062936620504357e-05 4.3546047616054653e-05
+ 4.0062954860519562e-05 4.7069469432613542e-05
+ 4.0062973100534773e-05 5.0706855826657106e-05
+ 4.0062991340549977e-05 5.4454893918205257e-05
+ 4.0063009580565181e-05 5.8310193146384224e-05
+ 4.0063027820580393e-05 6.2269290123695639e-05
+ 4.0063046060595597e-05 6.6328653564053143e-05
+ 4.0063068199865845e-05 7.1385338233594827e-05
+ 4.00630903391361e-05 7.6577901326810804e-05
+ 4.0063112478406349e-05 8.189969012601315e-05
+ 4.0063134617676597e-05 8.7343953274172687e-05
+ 4.0063161293011322e-05 9.4056657818521804e-05
+ 4.006318787309581e-05 0.00010090035482762358
+ 4.0063214453180297e-05 0.00010788664307091889
+ 4.0063248688484342e-05 0.00011707548567577072
+ 4.0063282923788387e-05 0.00012645461865043843
+ 4.0063315356127048e-05 0.00013549167951766453
+ 4.0063347788465716e-05 0.00014465398332574899
+ 4.0063380220804378e-05 0.00015391958689944246
+ 4.0063412653143039e-05 0.00016326679416820027
+ 4.0063445085481708e-05 0.00017267423453976973
+ 4.0063477517820369e-05 0.00018212093762926101
+ 4.0063509950159031e-05 0.00019158640400330904
+ 4.0063542382497692e-05 0.00020105067163597072
+ 4.0063569584998151e-05 0.00020897371829601134
+ 4.0063596787498602e-05 0.00021687121736840308
+ 4.0063623989999054e-05 0.0002247324443841368
+ 4.0063651192499513e-05 0.00023254704172942061
+ 4.0063678394999965e-05 0.00024030503688061725
+ 4.0063705597500417e-05 0.00024799685880477063
+ 4.0063732800000868e-05 0.00025561335251051022
+ 4.006376000250132e-05 0.00026314579174345146
+ 4.0063787205001779e-05 0.00027058588982929906
+ 4.0063814407502231e-05 0.00027792580867665878
+ 4.0063841610002683e-05 0.0002851581659600263
+ 4.0063868812503141e-05 0.00029227604051150784
+ 4.0063896015003593e-05 0.00029927297595749906
+ 4.0063923217504045e-05 0.00030614298264376868
+ 4.0063950420004497e-05 0.00031288053789913813
+ 4.0063977622504948e-05 0.00031948058469418605
+ 4.0064004825005407e-05 0.00032593852875712024
+ 4.0064032027505859e-05 0.00033225023421413059
+ 4.0064059230006311e-05 0.00033841201782615327
+ 4.0064086432506769e-05 0.0003444206418985982
+ 4.00641153008835e-05 0.00035062659892727544
+ 4.0064144169260238e-05 0.0003566540934654631
+ 4.0064173037636968e-05 0.00036250083298786399
+ 4.0064201906013706e-05 0.00036816503744223664
+ 4.0064230774390443e-05 0.00037364542226806104
+ 4.0064259642767174e-05 0.00037894118026981165
+ 4.0064288511143912e-05 0.00038405196247931109
+ 4.0064317379520642e-05 0.000388977858140999
+ 4.006434624789738e-05 0.00039371937395252178
+ 4.0064381135166682e-05 0.0003992047348763101
+ 4.0064416022435991e-05 0.00040442447430172904
+ 4.0064449985506052e-05 0.00040925368585940502
+ 4.0064483948576113e-05 0.00041383750344981278
+ 4.0064517911646181e-05 0.00041817993390062743
+ 4.0064551874716242e-05 0.00042228549548244641
+ 4.0064585837786303e-05 0.00042615916749456922
+ 4.0064627381082823e-05 0.0004305900119691504
+ 4.0064668924379336e-05 0.00043469258490726371
+ 4.0064710467675849e-05 0.0004384781612780042
+ 4.0064752010972368e-05 0.00044195857402361564
+ 4.0064802322523104e-05 0.00044578261210212054
+ 4.0064853125173636e-05 0.00044923093231022854
+ 4.0064903927824174e-05 0.00045228765276156626
+ 4.0064971607266249e-05 0.00045579239535176001
+ 4.0065039286708323e-05 0.00045870005395461338
+ 4.006509191939657e-05 0.00046058369469111949
+ 4.0065144552084817e-05 0.00046216451732223918
+ 4.0065197184773057e-05 0.00046346681282214352
+ 4.0065249817461304e-05 0.00046451393123718372
+ 4.0065297809929105e-05 0.00046526519657479943
+ 4.0065345802396907e-05 0.00046583893527304737
+ 4.0065393794864708e-05 0.00046625041073407677
+ 4.0065441787332517e-05 0.00046651403875466578
+ 4.0065489779800318e-05 0.0004666433740508164
+ 4.0065537261554869e-05 0.00046665162291553914
+ 4.0065584743309413e-05 0.000466552308242554
+ 4.0065632225063965e-05 0.00046635608374731292
+ 4.0065679706818516e-05 0.00046607281339991539
+ 4.006572718857306e-05 0.00046571159614456351
+ 4.0065774670327611e-05 0.00046528079492301239
+ 4.0065824358583366e-05 0.00046476378468933915
+ 4.0065874046839127e-05 0.00046418694952370777
+ 4.0065923735094882e-05 0.00046355752837163748
+ 4.0065973423350637e-05 0.00046288205221083837
+ 4.0066023111606398e-05 0.00046216639229460844
+ 4.0066072799862153e-05 0.00046141580830294233
+ 4.0066127951386078e-05 0.00046054748419045071
+ 4.0066183102910003e-05 0.00045964758393211987
+ 4.0066238254433928e-05 0.00045872107390199996
+ 4.0066293405957854e-05 0.00045777228079549998
+ 4.0066348557481779e-05 0.00045680495887963081
+ 4.0066411640520545e-05 0.000455679953428722
+ 4.0066474723559303e-05 0.00045453907391423655
+ 4.0066537806598062e-05 0.0004533857886546739
+ 4.0066600889636821e-05 0.00045222299034028662
+ 4.0066674140146429e-05 0.00045086399130210022
+ 4.0066747390656036e-05 0.00044949844535668453
+ 4.006682064116565e-05 0.00044812878579885432
+ 4.0066905619421589e-05 0.00044653719761490697
+ 4.0066990597677527e-05 0.0004449449586312652
+ 4.006709383684479e-05 0.00044301214871122791
+ 4.0067198171769414e-05 0.00044106269601017851
+ 4.0067302506694046e-05 0.00043911870626636078
+ 4.0067426664469164e-05 0.00043681393387383496
+ 4.006755082224429e-05 0.00043451951813961668
+ 4.0067705800806534e-05 0.00043167106196547318
+ 4.0067884937131787e-05 0.00042840086834201771
+ 4.006809855660239e-05 0.00042453293757745131
+ 4.0068364485722958e-05 0.00041976628303681877
+ 4.0068717982712207e-05 0.00041351261779238365
+ 4.0069242097564149e-05 0.00040441158298440465
+ 4.0070136340120476e-05 0.00038934346113524376
+ 4.0072132807185041e-05 0.00035769765454050228
+ 4.0073988816858019e-05 0.00033058981538904275
+ 4.0076421668443083e-05 0.00029814348467284587
+ 4.0078854520028147e-05 0.00026888165874455468
+ 4.0081287371613212e-05 0.00024249178888257299
+ 4.0083720223198276e-05 0.00021869200206866874
+ 4.0086153074783333e-05 0.00019722808975099272
+ 4.0088585926368398e-05 0.00017787079297825666
+ 4.0091018777953462e-05 0.00016041335425741158
+ 4.0093451629538526e-05 0.0001446693086575522
+ 4.0095767705239781e-05 0.00013111903917235234
+ 4.0098819440406719e-05 0.00011518312547724692
+ 4.0101871175573657e-05 0.00010118403045864018
+ 4.0104922910740602e-05 8.8886357108097517e-05
+ 4.0107974645907541e-05 7.8083318131395906e-05
+ 4.0111026381074479e-05 6.8593258842393536e-05
+ 4.0114078116241417e-05 6.025660181923537e-05
+ 4.0117773618773604e-05 5.1505809187250614e-05
+ 4.0121134288610909e-05 4.4656271026532631e-05
+ 4.0124494958448221e-05 3.8717628008379948e-05
+ 4.0128620731690284e-05 3.2495702272495222e-05
+ 4.0132746504932341e-05 2.7273646663031209e-05
+ 4.0136872278174397e-05 2.2890780980831938e-05
+ 4.014099805141646e-05 1.9212246512347876e-05
+ 4.0145123824658517e-05 1.6124856494297113e-05
+ 4.01502511384371e-05 1.2970141364146993e-05
+ 4.0155378452215683e-05 1.0432633172092827e-05
+ 4.0160505765994266e-05 8.3915781182774641e-06
+ 4.0165633079772849e-05 6.7498471833962207e-06
+ 4.0171995979825156e-05 5.1518189724579756e-06
+ 4.0178358879877463e-05 3.9321378049054371e-06
+ 4.018472177992977e-05 3.0012267671564931e-06
+ 4.0192497256254514e-05 2.15737185496337e-06
+ 4.0200272732579252e-05 1.5508026051292012e-06
+ 4.0208048208903997e-05 1.1147960586695601e-06
+ 4.0217983441936073e-05 7.3118840550782522e-07
+ 4.0227918674968142e-05 4.7961075194826108e-07
+ 4.0240125706218148e-05 2.8571159964289929e-07
+ 4.0252332737468146e-05 1.7024209705967684e-07
+ 4.0264539768718145e-05 1.0147848625806179e-07
+ 4.0276746799968144e-05 6.0528851952355526e-08
+ 4.0288953831218142e-05 3.6142806128821739e-08
+ 4.0301160862468148e-05 2.1620593980565466e-08
+ 4.0313367893718146e-05 1.2972424953734794e-08
+ 4.0325574924968145e-05 7.8223266739669589e-09
+ 4.0337781956218144e-05 4.7553755500354248e-09
+ 4.0349988987468142e-05 2.9289656540459339e-09
+ 4.0362196018718148e-05 1.8413143839828223e-09
+ 4.0374403049968146e-05 1.1936037658401295e-09
+ 4.0386610081218145e-05 8.078836241498485e-10
+ 4.0398817112468144e-05 5.7818218790680653e-10
+ 4.0411024143718142e-05 4.4139192644487092e-10
+ 4.0423231174968141e-05 3.5993152647751398e-10
+ 4.0435438206218146e-05 3.1142080027758294e-10
+ 4.0447645237468145e-05 2.8253202431124535e-10
+ 4.0459852268718144e-05 2.653283707170538e-10
+ 4.0472059299968142e-05 2.5508336753526945e-10
+ 4.0484266331218141e-05 2.4898233649178344e-10
+ 4.0496473362468146e-05 2.4534909287155193e-10
+ 4.0508680393718145e-05 2.4318544696123555e-10
+ 4.0520887424968144e-05 2.4189696683490067e-10
+ 4.0533094456218142e-05 2.411296605642883e-10
+ 4.0545301487468141e-05 2.406727199550333e-10
+ 4.055750851871814e-05 2.4040060549918595e-10
+ 4.0569715549968145e-05 2.4023855751768804e-10
+ 4.0581922581218144e-05 2.4014205601586099e-10
+ 4.0594129612468143e-05 2.4008458822552009e-10
+ 4.0606336643718141e-05 2.4005036536744095e-10
+ 4.061854367496814e-05 2.4002998505548136e-10
+ 4.0630750706218145e-05 2.4001784836154639e-10
+ 4.0642957737468144e-05 2.4001062082534474e-10
+ 4.0655164768718143e-05 2.4000631674323626e-10
+ 4.0667371799968141e-05 2.4000375361391963e-10
+ 4.067957883121814e-05 2.4000222718017004e-10
+ 4.0691785862468145e-05 2.4000131819356677e-10
+ 4.0703992893718144e-05 2.4000077702242996e-10
+ 4.0716199924968143e-05 2.4000045459933931e-10
+ 4.0728406956218141e-05 2.4000026257884156e-10
+ 4.074061398746814e-05 2.4000014832025053e-10
+ 4.0752821018718145e-05 2.4000008023582484e-10
+ 4.0765028049968144e-05 2.4000003966625581e-10
+ 4.0777235081218143e-05 2.400000155533385e-10
+ 4.0789442112468141e-05 2.4000000121814107e-10
+ 4.080164914371814e-05 2.3999999261673205e-10
+ 4.0813856174968139e-05 2.3999998758456908e-10
+ 4.0826063206218144e-05 2.3999998453222656e-10
+ 4.0838270237468143e-05 2.3999998265390494e-10
+ 4.0850477268718141e-05 2.3999998161732485e-10
+ 4.086268429996814e-05 2.3999998104358188e-10
+ 4.0874891331218139e-05 2.3999998057389865e-10
+ 4.0887098362468144e-05 2.3999998026292464e-10
+ 4.0899305393718143e-05 2.3999998019001177e-10
+ 4.0911512424968141e-05 2.3999998019899801e-10
+ 4.092371945621814e-05 2.3999998020597388e-10
+ 4.0935926487468139e-05 2.3999998012855701e-10
+ 4.0948133518718137e-05 2.3999998005534517e-10
+ 4.0960340549968143e-05 2.3999998008389102e-10
+ 4.0972547581218141e-05 2.3999998009224399e-10
+ 4.098475461246814e-05 2.3999998012219294e-10
+ 4.0996961643718139e-05 2.3999998013282356e-10
+ 4.1009168674968137e-05 2.3999998009115475e-10
+ 4.1021375706218143e-05 2.3999998009706464e-10
+ 4.1033582737468142e-05 2.3999998010363494e-10
+ 4.104578976871814e-05 2.3999998011314167e-10
+ 4.1057996799968139e-05 2.3999998013616955e-10
+ 4.1070203831218138e-05 2.3999998011363462e-10
+ 4.1082410862468143e-05 2.3999998009274014e-10
+ 4.1094617893718142e-05 2.399999801011231e-10
+ 4.110682492496814e-05 2.399999800977465e-10
+ 4.1119031956218139e-05 2.3999998010717031e-10
+ 4.1131238987468138e-05 2.3999998026497155e-10
+ 4.1143446018718143e-05 2.3999998018940695e-10
+ 4.1155653049968142e-05 2.399999801489314e-10
+ 4.116786008121814e-05 2.3999998016252337e-10
+ 4.1180067112468139e-05 2.3999998017736873e-10
+ 4.1192274143718138e-05 2.3999998008841631e-10
+ 4.1204481174968136e-05 2.399999801406156e-10
+ 4.1216688206218142e-05 2.3999998027111368e-10
+ 4.122889523746814e-05 2.399999803096209e-10
+ 4.1241102268718139e-05 2.399999801745041e-10
+ 4.1253309299968138e-05 2.3999998014351678e-10
+ 4.1265516331218136e-05 2.399999802735929e-10
+ 4.1277723362468142e-05 2.3999998026179471e-10
+ 4.128993039371814e-05 2.3999998016976751e-10
+ 4.1302137424968139e-05 2.3999998022820648e-10
+ 4.1314344456218138e-05 2.3999998018386391e-10
+ 4.1326551487468136e-05 2.3999998024457121e-10
+ 4.1338758518718142e-05 2.399999802712344e-10
+ 4.135096554996814e-05 2.3999998016906244e-10
+ 4.1363172581218139e-05 2.399999802251944e-10
+ 4.1375379612468138e-05 2.3999998029674961e-10
+ 4.1387586643718143e-05 2.3999998024490881e-10
+ 4.1399793674968142e-05 2.3999998022841694e-10
+ 4.1412000706218141e-05 2.3999998027402318e-10
+ 4.1424207737468139e-05 2.3999998031284179e-10
+ 4.1436414768718145e-05 2.3999998024592236e-10
+ 4.1448621799968143e-05 2.3999998028900653e-10
+ 4.1460828831218142e-05 2.3999998029018118e-10
+ 4.1473035862468141e-05 2.3999998020407995e-10
+ 4.1485242893718146e-05 2.3999998030027903e-10
+ 4.1497449924968145e-05 2.3999998034659856e-10
+ 4.1509656956218143e-05 2.3999998035710371e-10
+ 4.1521863987468142e-05 2.3999998035781327e-10
+ 4.1534071018718147e-05 2.3999998028429372e-10
+ 4.1546278049968146e-05 2.3999998026462584e-10
+ 4.1558485081218145e-05 2.3999998034401652e-10
+ 4.1570692112468143e-05 2.3999998040748526e-10
+ 4.1582899143718149e-05 2.399999802904164e-10
+ 4.1595106174968147e-05 2.3999998026488739e-10
+ 4.1607313206218146e-05 2.399999803948264e-10
+ 4.1619520237468145e-05 2.399999803901337e-10
+ 4.163172726871815e-05 2.3999998030809217e-10
+ 4.1643934299968149e-05 2.3999998036169063e-10
+ 4.1656141331218148e-05 2.3999998033495331e-10
+ 4.1668348362468146e-05 2.3999998039429674e-10
+ 4.1680555393718152e-05 2.3999998043834603e-10
+ 4.169276242496815e-05 2.3999998042747548e-10
+ 4.1704969456218149e-05 2.3999998033813589e-10
+ 4.1717176487468148e-05 2.3999998042749197e-10
+ 4.1729383518718153e-05 2.3999998045576412e-10
+ 4.1741590549968152e-05 2.3999998040668088e-10
+ 4.175379758121815e-05 2.3999998041015307e-10
+ 4.1766004612468149e-05 2.3999998038280188e-10
+ 4.1778211643718154e-05 2.399999804963409e-10
+ 4.1790418674968153e-05 2.3999998050724164e-10
+ 4.1802625706218152e-05 2.3999998043757132e-10
+ 4.181483273746815e-05 2.3999998042873677e-10
+ 4.1827039768718156e-05 2.3999998048062938e-10
+ 4.1839246799968154e-05 2.3999998046244087e-10
+ 4.1851453831218153e-05 2.3999998047367506e-10
+ 4.1863660862468152e-05 2.3999998045481209e-10
+ 4.1875867893718157e-05 2.3999998043752122e-10
+ 4.1888074924968156e-05 2.3999998042446345e-10
+ 4.1900281956218155e-05 2.3999998041722252e-10
+ 4.1912488987468153e-05 2.3999998041674074e-10
+ 4.1924696018718159e-05 2.3999998042357827e-10
+ 4.1936903049968157e-05 2.3999998043806778e-10
+ 4.1949110081218156e-05 2.3999998047660411e-10
+ 4.1961317112468155e-05 2.3999998051655456e-10
+ 4.197352414371816e-05 2.3999998052591767e-10
+ 4.1985731174968159e-05 2.3999998048427911e-10
+ 4.1997938206218157e-05 2.3999998054712477e-10
+ 4.2010145237468156e-05 2.3999998057013456e-10
+ 4.2022352268718161e-05 2.3999998051176627e-10
+ 4.203455929996816e-05 2.3999998057450993e-10
+ 4.2046766331218159e-05 2.3999998053652084e-10
+ 4.2058973362468157e-05 2.3999998056705243e-10
+ 4.2071180393718163e-05 2.399999805326457e-10
+ 4.2083387424968161e-05 2.399999805718764e-10
+ 4.209559445621816e-05 2.3999998054921403e-10
+ 4.2107801487468159e-05 2.3999998061819825e-10
+ 4.2120008518718164e-05 2.399999805688973e-10
+ 4.2132215549968163e-05 2.3999998054792621e-10
+ 4.2144422581218162e-05 2.39999980627754e-10
+ 4.215662961246816e-05 2.3999998059474422e-10
+ 4.2168836643718166e-05 2.399999805933057e-10
+ 4.2181043674968164e-05 2.3999998057922352e-10
+ 4.2193250706218163e-05 2.3999998056088616e-10
+ 4.2205457737468162e-05 2.3999998058786213e-10
+ 4.2217664768718167e-05 2.399999806005213e-10
+ 4.2229871799968166e-05 2.3999998060792622e-10
+ 4.2242078831218164e-05 2.3999998061547279e-10
+ 4.2254285862468163e-05 2.3999998062637359e-10
+ 4.2266492893718168e-05 2.3999998064254068e-10
+ 4.2278699924968167e-05 2.399999806651119e-10
+ 4.2290906956218166e-05 2.3999998065019003e-10
+ 4.2303113987468164e-05 2.3999998066078063e-10
+ 4.231532101871817e-05 2.399999807158811e-10
+ 4.2327528049968168e-05 2.3999998065933043e-10
+ 4.2339735081218167e-05 2.3999998069949765e-10
+ 4.2351942112468166e-05 2.3999998071137632e-10
+ 4.2364149143718171e-05 2.3999998066492584e-10
+ 4.237635617496817e-05 2.3999998067631891e-10
+ 4.2388563206218168e-05 2.3999998068067386e-10
+ 4.2400770237468167e-05 2.3999998072884115e-10
+ 4.2412977268718173e-05 2.3999998071703879e-10
+ 4.2425184299968171e-05 2.399999807620995e-10
+ 4.243739133121817e-05 2.3999998071038665e-10
+ 4.2449598362468169e-05 2.3999998068359319e-10
+ 4.2461805393718174e-05 2.3999998073934671e-10
+ 4.2474012424968173e-05 2.3999998074833904e-10
+ 4.2486219456218171e-05 2.3999998072288318e-10
+ 4.249842648746817e-05 2.3999998078919143e-10
+ 4.2510633518718175e-05 2.3999998076965073e-10
+ 4.2522840549968174e-05 2.399999807468099e-10
+ 4.2535047581218173e-05 2.3999998076982682e-10
+ 4.2547254612468171e-05 2.3999998077882701e-10
+ 4.2559461643718177e-05 2.3999998078272732e-10
+ 4.2571668674968175e-05 2.3999998077698307e-10
+ 4.2583875706218174e-05 2.3999998078844893e-10
+ 4.2596082737468173e-05 2.3999998080355428e-10
+ 4.2608289768718178e-05 2.3999998082407074e-10
+ 4.2620496799968177e-05 2.3999998085105249e-10
+ 4.2632703831218175e-05 2.3999998076975625e-10
+ 4.2644910862468174e-05 2.399999808033618e-10
+ 4.265711789371818e-05 2.3999998080328762e-10
+ 4.2669324924968178e-05 2.3999998084082399e-10
+ 4.2681531956218177e-05 2.3999998077877215e-10
+ 4.2693738987468176e-05 2.3999998083679345e-10
+ 4.2705946018718181e-05 2.3999998087406507e-10
+ 4.271815304996818e-05 2.3999998083776306e-10
+ 4.2730360081218178e-05 2.3999998086990843e-10
+ 4.2742567112468177e-05 2.3999998083702247e-10
+ 4.2754774143718182e-05 2.399999808776692e-10
+ 4.2766981174968181e-05 2.3999998085631119e-10
+ 4.277918820621818e-05 2.3999998083949021e-10
+ 4.2791395237468178e-05 2.3999929577393646e-10
+ 4.2803602268718184e-05 2.3999721430085655e-10
+ 4.2815809299968182e-05 2.3999541801853927e-10
+ 4.2828016331218181e-05 2.3999352441667849e-10
+ 4.284022336246818e-05 2.3998998231508299e-10
+ 4.2852430393718185e-05 2.3998269751518182e-10
+ 4.2864637424968184e-05 2.3996731785187146e-10
+ 4.2870740940593183e-05 2.3994983464395233e-10
+ 4.2876844456218182e-05 2.3990674100743305e-10
+ 4.2879896214030682e-05 2.3985615585153402e-10
+ 4.2882947971843182e-05 2.3973456609508262e-10
+ 4.2884473850749435e-05 2.3959023649420816e-10
+ 4.2885999729655681e-05 2.3924487360909957e-10
+ 4.2886991106889188e-05 2.3866252493064795e-10
+ 4.2887269733896248e-05 2.3836567845599657e-10
+ 4.28875483609033e-05 2.3795958755937176e-10
+ 4.2888098835627975e-05 2.3707317678626589e-10
+ 4.2890875273912435e-05 2.3289947932096134e-10
+ 4.290308230516244e-05 2.1857108082062022e-10
+ 4.2915289336412439e-05 2.0744394567167327e-10
+ 4.2927496367662438e-05 1.9657101424192844e-10
+ 4.2939703398912443e-05 1.8444183633608339e-10
+ 4.2951910430162442e-05 1.7048236032410772e-10
+ 4.296411746141244e-05 1.5473832156939622e-10
+ 4.2976324492662439e-05 1.376643966131987e-10
+ 4.2988531523912438e-05 1.1997405552563603e-10
+ 4.3000738555162443e-05 1.0252468847149855e-10
+ 4.3012945586412442e-05 8.622433036431135e-11
+ 4.302515261766244e-05 7.1953269034585456e-11
+ 4.3037359648912446e-05 6.0497851486217764e-11
+ 4.3049566680162445e-05 5.2496010132610782e-11
+ 4.3061773711412443e-05 4.8395088933560857e-11
+ 4.3073980742662442e-05 4.8422873289603413e-11
+ 4.3086187773912441e-05 5.2572582289997926e-11
+ 4.3098394805162446e-05 6.0602144636946106e-11
+ 4.3110601836412445e-05 7.2047475992215135e-11
+ 4.3122808867662443e-05 8.6248800170538565e-11
+ 4.3135015898912449e-05 1.0238838404643464e-10
+ 4.3147222930162447e-05 1.19537446121802e-10
+ 4.3159429961412446e-05 1.367094991032434e-10
+ 4.3171636992662445e-05 1.5291703382970249e-10
+ 4.3183844023912443e-05 1.6722827017382802e-10
+ 4.318689578172495e-05 1.7041028620342427e-10
+ 4.3187048369615569e-05 1.7056469761267313e-10
+ 4.3187429839342131e-05 1.7094872387604414e-10
+ 4.3187467986314792e-05 1.7098696858623529e-10
+ 4.3187475615709324e-05 1.7099461407315297e-10
+ 4.3187490874498382e-05 1.7100990159048815e-10
+ 4.3187496978014011e-05 1.7101601530675094e-10
+ 4.318749941942026e-05 1.7101846058671687e-10
+ 4.3187499604455786e-05 1.7101864591102341e-10
+ 4.3187499974526846e-05 1.710190165576025e-10
+ 4.3187500714668951e-05 2.9362295535076986e-10
+ 4.3187501454811057e-05 6.7955376462053112e-10
+ 4.3187508856232153e-05 1.9019685483973129e-08
+ 4.3187516257653236e-05 6.3680162617685321e-08
+ 4.3187523659074333e-05 1.3464578979540883e-07
+ 4.3187531060495416e-05 2.3189729697639808e-07
+ 4.3187538461916512e-05 3.5541134357275011e-07
+ 4.3187547512355689e-05 5.4209487018455778e-07
+ 4.3187556562794873e-05 7.6794744751962639e-07
+ 4.318756561323405e-05 1.032901665904789e-06
+ 4.3187574663673233e-05 1.3368810846168448e-06
+ 4.3187583714112417e-05 1.6798002590529673e-06
+ 4.3187595044533515e-05 2.1638522289015684e-06
+ 4.3187606374954614e-05 2.7085809274094572e-06
+ 4.3187617705375712e-05 3.3137595140903088e-06
+ 4.3187629035796811e-05 3.9791394372703589e-06
+ 4.3187643214653366e-05 4.8961848891924115e-06
+ 4.318765739350992e-05 5.9065041934527361e-06
+ 4.3187671572366475e-05 7.0094688242501652e-06
+ 4.318768903239694e-05 8.4939484121898285e-06
+ 4.3187706492427404e-05 1.011650368403691e-05
+ 4.3187723952457862e-05 1.187564441966631e-05
+ 4.3187746268477832e-05 1.4320324258348367e-05
+ 4.3187768584497802e-05 1.6981891243476683e-05
+ 4.3187790900517771e-05 1.9856448881756975e-05
+ 4.3187819090217241e-05 2.3785542948120637e-05
+ 4.318784727991671e-05 2.8038794641957824e-05
+ 4.3187875469616186e-05 3.2606525910010655e-05
+ 4.3187903659315655e-05 3.7478440563006991e-05
+ 4.3187931849015125e-05 4.2643660624918842e-05
+ 4.3187960038714594e-05 4.809076449946518e-05
+ 4.3187988228414063e-05 5.3807826764352856e-05
+ 4.3188019414106479e-05 6.0432058501488789e-05
+ 4.3188050599798888e-05 6.7354141141263776e-05
+ 4.3188081785491296e-05 7.4556149339010216e-05
+ 4.3188112971183712e-05 8.2019674226669682e-05
+ 4.3188150418414338e-05 9.1300740447793598e-05
+ 4.318818786564497e-05 0.00010089852928503813
+ 4.3188225312875596e-05 0.00011077933330704341
+ 4.3188270844195813e-05 0.00012312530862772575
+ 4.3188316375516023e-05 0.00013577798574481139
+ 4.3188361906836239e-05 0.00014867616552750304
+ 4.3188407438156449e-05 0.00016175929991125412
+ 4.3188441084028115e-05 0.00017151113091571656
+ 4.318847472989978e-05 0.00018130797963939794
+ 4.3188508375771446e-05 0.00019112690048319055
+ 4.3188542021643111e-05 0.000200945563836072
+ 4.3188575667514777e-05 0.0002107423308290232
+ 4.3188609313386442e-05 0.00022049632214156449
+ 4.3188642959258108e-05 0.00023018748061678874
+ 4.3188676605129773e-05 0.00023979662749408118
+ 4.3188710251001439e-05 0.0002493055121224335
+ 4.3188736870668149e-05 0.00025674620625396695
+ 4.3188763490334858e-05 0.00026410519322842072
+ 4.3188790110001568e-05 0.00027137476557784006
+ 4.3188816729668278e-05 0.00027854762813939171
+ 4.3188843349334995e-05 0.00028561690431054267
+ 4.3188869969001705e-05 0.0002925761407342706
+ 4.3188896588668415e-05 0.0002994193104460534
+ 4.3188923208335125e-05 0.00030614081452042582
+ 4.3188949828001835e-05 0.00031273548226053464
+ 4.3188976447668544e-05 0.00031919856997935221
+ 4.3189003067335254e-05 0.00032552575842600295
+ 4.3189029687001971e-05 0.00033171314891500655
+ 4.3189056306668681e-05 0.00033775725822013397
+ 4.3189082926335391e-05 0.00034365501229800138
+ 4.3189109546002101e-05 0.00034940373890948994
+ 4.3189136165668811e-05 0.00035500115920957621
+ 4.3189162785335521e-05 0.00036044537837818884
+ 4.318918940500223e-05 0.00036573487536628151
+ 4.318921602466894e-05 0.00037086849183281574
+ 4.318923940493523e-05 0.00037524816041470616
+ 4.318926278520152e-05 0.00037950661982143294
+ 4.318928616546781e-05 0.00038364373347733212
+ 4.3189309545734093e-05 0.00038765955240256639
+ 4.3189332926000383e-05 0.00039155430797307712
+ 4.3189356306266673e-05 0.00039532840450424615
+ 4.3189379686532963e-05 0.00039898241168751826
+ 4.3189403066799246e-05 0.00040251705690861332
+ 4.3189426447065536e-05 0.00040593321747524688
+ 4.3189449827331826e-05 0.0004092319127814815
+ 4.3189473207598116e-05 0.00041241429643495774
+ 4.3189496587864399e-05 0.00041548164837231091
+ 4.3189519968130689e-05 0.00041843536698707185
+ 4.3189543348396979e-05 0.00042127696129328835
+ 4.3189566728663269e-05 0.00042400804314699181
+ 4.3189590108929552e-05 0.00042663031954648096
+ 4.3189613489195842e-05 0.00042914558503120656
+ 4.3189636869462131e-05 0.00043155571419782471
+ 4.3189660249728421e-05 0.00043386265435075173
+ 4.3189683629994704e-05 0.0004360684183033
+ 4.3189707010260994e-05 0.00043817507734421687
+ 4.3189735591237522e-05 0.00044061881915944171
+ 4.3189764172214042e-05 0.00044292160557832261
+ 4.3189792753190569e-05 0.00044508748731897325
+ 4.318982133416709e-05 0.0004471205811035718
+ 4.3189849915143617e-05 0.00044902505354874717
+ 4.3189886199806215e-05 0.00045126415767136695
+ 4.3189925453373382e-05 0.00045347065125915753
+ 4.3189946977215268e-05 0.00045458914938144757
+ 4.3189973696714704e-05 0.00045589098737442259
+ 4.319000041621414e-05 0.00045710004038524538
+ 4.3190027135713576e-05 0.00045821970861944291
+ 4.3190053855213012e-05 0.00045925335947318648
+ 4.3190080574712448e-05 0.00046020432082601948
+ 4.3190107294211884e-05 0.00046107587487371744
+ 4.319013401371132e-05 0.00046187125249194449
+ 4.3190160733210756e-05 0.00046259362811953432
+ 4.3190187452710192e-05 0.00046324611514856153
+ 4.3190214172209628e-05 0.00046383176180687778
+ 4.3190240891709064e-05 0.00046435354751746608
+ 4.3190262548859618e-05 0.00046473161709406521
+ 4.3190284206010165e-05 0.00046507115570231151
+ 4.3190305863160718e-05 0.00046537364255429416
+ 4.3190327520311271e-05 0.00046564052306956875
+ 4.3190349177461818e-05 0.00046587320827894959
+ 4.3190370834612372e-05 0.00046607307433484731
+ 4.3190392491762925e-05 0.00046624146212347479
+ 4.3190414148913478e-05 0.00046637967697419719
+ 4.3190435806064032e-05 0.00046648898846127722
+ 4.3190457463214578e-05 0.00046657063029325929
+ 4.3190479120365132e-05 0.0004666258002852115
+ 4.3190496765399607e-05 0.00046665198683365781
+ 4.3190514410434081e-05 0.00046666198405394353
+ 4.3190532055468556e-05 0.00046665638716889121
+ 4.3190549700503024e-05 0.00046663577581361698
+ 4.3190567345537498e-05 0.00046660071413966874
+ 4.3190584990571973e-05 0.00046655175093608377
+ 4.3190602635606447e-05 0.00046648941976632619
+ 4.3190620280640922e-05 0.00046641423912008399
+ 4.3190637925675397e-05 0.00046632671257892689
+ 4.3190655570709871e-05 0.00046622732899484812
+ 4.3190673215744346e-05 0.00046611656268073646
+ 4.3190690860778821e-05 0.00046599487361184948
+ 4.3190708505813288e-05 0.00046586270763738396
+ 4.3190726150847763e-05 0.00046572049670126538
+ 4.3190743795882238e-05 0.00046556865907130521
+ 4.3190761440916712e-05 0.00046540759957590188
+ 4.3190779085951187e-05 0.00046523770984748908
+ 4.3190796730985661e-05 0.00046505936857196291
+ 4.3190814376020136e-05 0.00046487294174334804
+ 4.3190832021054604e-05 0.00046467878292299136
+ 4.3190849666089078e-05 0.00046447723350260048
+ 4.3190867311123553e-05 0.00046426862297047311
+ 4.3190884956158028e-05 0.00046405326918029163
+ 4.3190902601192502e-05 0.00046383147862188659
+ 4.3190920246226977e-05 0.0004636035466933999
+ 4.3190937891261452e-05 0.00046336975797430831
+ 4.3190955536295926e-05 0.00046313038649879376
+ 4.3190973181330401e-05 0.00046288569602897633
+ 4.3190990826364869e-05 0.00046263594032755121
+ 4.3191008471399343e-05 0.00046238136342939871
+ 4.3191026116433818e-05 0.00046212219991176166
+ 4.3191043761468292e-05 0.00046185867516261082
+ 4.3191061406502767e-05 0.00046159100564684353
+ 4.3191079051537242e-05 0.00046131939916998468
+ 4.3191096696571716e-05 0.00046104405513908457
+ 4.3191114341606184e-05 0.00046076516482052872
+ 4.3191131986640659e-05 0.00046048291159450004
+ 4.3191149631675133e-05 0.00046019747120585279
+ 4.3191167276709608e-05 0.00045990901201118061
+ 4.3191184921744083e-05 0.00045961769522188066
+ 4.3191202566778557e-05 0.00045932367514303494
+ 4.3191220211813032e-05 0.00045902709940794936
+ 4.3191237856847506e-05 0.00045872810920820898
+ 4.3191255501881981e-05 0.00045842683951912496
+ 4.3191273146916449e-05 0.00045812341932046545
+ 4.3191290791950924e-05 0.00045781797181237863
+ 4.3191308436985398e-05 0.00045751061462643097
+ 4.3191326082019873e-05 0.00045720146003169808
+ 4.3191343727054347e-05 0.00045689061513585962
+ 4.3191361372088822e-05 0.00045657818208126165
+ 4.3191379017123297e-05 0.00045626425823592343
+ 4.3191396662157764e-05 0.0004559489363794755
+ 4.3191414307192239e-05 0.0004556323048840281
+ 4.3191431952226714e-05 0.00045531444788997848
+ 4.3191449597261188e-05 0.00045499544547677518
+ 4.3191467242295663e-05 0.00045467537382866608
+ 4.3191484887330138e-05 0.00045435430539546583
+ 4.3191502532364612e-05 0.00045403230904838535
+ 4.3191520177399087e-05 0.00045370945023097327
+ 4.3191537822433561e-05 0.00045338579110522598
+ 4.3191555467468029e-05 0.00045306139069292836
+ 4.3191573112502504e-05 0.00045273630501229328
+ 4.3191590757536978e-05 0.00045241058720997258
+ 4.3191608402571453e-05 0.00045208428768851668
+ 4.3191626047605928e-05 0.00045175745422936376
+ 4.3191643692640402e-05 0.00045143013211144381
+ 4.3191661337674877e-05 0.00045110236422548483
+ 4.3191682620107575e-05 0.00045070649383213837
+ 4.3191702745281679e-05 0.00045033166770387813
+ 4.3191722870455782e-05 0.00044995642757493547
+ 4.3191742995629885e-05 0.00044958082330929242
+ 4.3191763120803989e-05 0.00044920490166811688
+ 4.3191783245978092e-05 0.00044882870648050557
+ 4.3191803371152196e-05 0.00044845227880637947
+ 4.3191823496326299e-05 0.00044807565709178331
+ 4.3191843621500403e-05 0.00044769887731683952
+ 4.3191863746674499e-05 0.00044732197313660687
+ 4.3191888110746132e-05 0.00044686556133260454
+ 4.3191912474817758e-05 0.00044640906499999366
+ 4.3191936838889384e-05 0.00044595253182312878
+ 4.3191961202961009e-05 0.00044549600565976083
+ 4.3191985567032642e-05 0.00044503952681690417
+ 4.3192009931104268e-05 0.00044458313230938829
+ 4.3192034295175894e-05 0.00044412685610195336
+ 4.3192058659247519e-05 0.00044367072933572632
+ 4.3192083023319152e-05 0.00044321478053989036
+ 4.3192107387390778e-05 0.00044275903582933563
+ 4.3192136719683571e-05 0.00044221066197735565
+ 4.3192166051976364e-05 0.00044166265618977781
+ 4.3192195384269164e-05 0.00044111505229614979
+ 4.3192224716561957e-05 0.000440567880571222
+ 4.319225404885475e-05 0.0004400211680723513
+ 4.3192283381147543e-05 0.0004394749389480193
+ 4.3192312713440343e-05 0.0004389292147195882
+ 4.3192342045733136e-05 0.00043838401453830063
+ 4.3192377848029201e-05 0.00043771929099924211
+ 4.3192412335454628e-05 0.00043707976746529866
+ 4.3192446822880063e-05 0.00043644103787377733
+ 4.3192481310305497e-05 0.00043580312030283216
+ 4.3192515797730932e-05 0.00043516603032572377
+ 4.319255782832121e-05 0.00043439073279079223
+ 4.3192599858911488e-05 0.00043361670459320404
+ 4.3192641889501772e-05 0.00043284396248195208
+ 4.319268392009205e-05 0.00043207252012209858
+ 4.3192725950682328e-05 0.00043130238856505936
+ 4.3192777518503427e-05 0.00043035930871672526
+ 4.3192828186666486e-05 0.00042943462880424378
+ 4.3192878854829544e-05 0.00042851188736760037
+ 4.3192929522992596e-05 0.00042759109050169295
+ 4.319299321514346e-05 0.00042643637215815307
+ 4.3193056907294325e-05 0.0004252847370223043
+ 4.3193120599445189e-05 0.00042413618616643506
+ 4.3193198945610716e-05 0.00042272760989246018
+ 4.3193278657649694e-05 0.00042129925771114857
+ 4.3193358369688672e-05 0.00041987571829712041
+ 4.3193461292370768e-05 0.00041804477075287836
+ 4.3193569508909824e-05 0.00041612824858809757
+ 4.3193701914804442e-05 0.00041379527174881443
+ 4.3193847065030184e-05 0.00041125276249577136
+ 4.3194034315235685e-05 0.00040799587225246868
+ 4.3194255865010426e-05 0.00040417569543334638
+ 4.3194554034092509e-05 0.00039909077578923559
+ 4.3194998769870892e-05 0.00039162496079868337
+ 4.3195805003988994e-05 0.00037844492463713218
+ 4.3196711764368321e-05 0.00036415075183872955
+ 4.3197737475686442e-05 0.00034863113834200367
+ 4.3198801143402346e-05 0.00033323544260725887
+ 4.3199944764949546e-05 0.00031744009309453978
+ 4.3202231646278911e-05 0.00028806442739914481
+ 4.3204182681216659e-05 0.00026516169925578173
+ 4.3206291228517253e-05 0.00024245284579639417
+ 4.3208581467436162e-05 0.00021998507757767748
+ 4.3210926666850026e-05 0.00019913410083615226
+ 4.3213271866263891e-05 0.00018025945489984468
+ 4.3215590537179634e-05 0.00016335772611693962
+ 4.3218474569484281e-05 0.00014452917890563918
+ 4.3221358601788934e-05 0.00012787080313841811
+ 4.3224242634093581e-05 0.00011313246567173927
+ 4.3227126666398227e-05 0.00010009286360866482
+ 4.3230010698702881e-05 8.8556201336288662e-05
+ 4.3232894731007527e-05 7.8349250567829904e-05
+ 4.323577876331218e-05 6.9318749243295542e-05
+ 4.3239342797663597e-05 5.9583601550415324e-05
+ 4.3242906832015015e-05 5.12156620124964e-05
+ 4.3246470866366438e-05 4.4022919356413453e-05
+ 4.3250034900717855e-05 3.7840328450154061e-05
+ 4.3253598935069272e-05 3.2526023165760874e-05
+ 4.3257899961127366e-05 2.7096692323683933e-05
+ 4.3262200987185452e-05 2.2573641128908005e-05
+ 4.3266502013243545e-05 1.8805590756409222e-05
+ 4.3270803039301631e-05 1.5666514280396347e-05
+ 4.3275104065359718e-05 1.3051421554109079e-05
+ 4.3280502505986988e-05 1.0377818664489998e-05
+ 4.3285900946614252e-05 8.251909089995107e-06
+ 4.3291299387241516e-05 6.5614966739560858e-06
+ 4.3296697827868786e-05 5.2173688876777125e-06
+ 4.3303468247657474e-05 3.9138135354349389e-06
+ 4.3310238667446162e-05 2.9359531577328348e-06
+ 4.3317009087234849e-05 2.2024124497970242e-06
+ 4.3325385304343962e-05 1.5432541258101081e-06
+ 4.3333761521453074e-05 1.081378721967762e-06
+ 4.3342137738562187e-05 7.5774041132707628e-07
+ 4.3353043385488659e-05 4.7689837631713853e-07
+ 4.3363949032415132e-05 3.0015113649486665e-07
+ 4.3376156063665137e-05 1.7876217937191045e-07
+ 4.3388363094915136e-05 1.0647330757921957e-07
+ 4.3400570126165134e-05 6.3424252544034479e-08
+ 4.3412777157415133e-05 3.7787934734000867e-08
+ 4.3424984188665132e-05 2.2521155841269887e-08
+ 4.3437191219915137e-05 1.3429588576020001e-08
+ 4.3449398251165136e-05 8.015449872567151e-09
+ 4.3461605282415134e-05 4.7912734917149069e-09
+ 4.347381231366514e-05 2.871251600636248e-09
+ 4.3486019344915139e-05 1.7278727196949598e-09
+ 4.3498226376165137e-05 1.0469960699243559e-09
+ 4.3510433407415136e-05 6.4154623608527275e-10
+ 4.3522640438665135e-05 4.0011708092908531e-10
+ 4.353484746991514e-05 2.563646256420896e-10
+ 4.3547054501165139e-05 1.7078006330613652e-10
+ 4.3559261532415137e-05 1.1983532309874618e-10
+ 4.3571468563665143e-05 8.9519095817165878e-11
+ 4.3583675594915141e-05 7.14874426319846e-11
+ 4.359588262616514e-05 6.0771426293748156e-11
+ 4.3608089657415139e-05 5.4411972164600532e-11
+ 4.3620296688665137e-05 5.0646908151112081e-11
+ 4.3632503719915143e-05 4.8426835103990855e-11
+ 4.3644710751165141e-05 4.7126820532761082e-11
+ 4.365691778241514e-05 4.6374708016315066e-11
+ 4.3669124813665145e-05 4.594887297816922e-11
+ 4.3681331844915144e-05 4.5717334758833713e-11
+ 4.3693538876165143e-05 4.5601496954841019e-11
+ 4.3705745907415141e-05 4.5554554261028926e-11
+ 4.371795293866514e-05 4.5548633436145208e-11
+ 4.3730159969915146e-05 4.5567135561437956e-11
+ 4.3742367001165144e-05 4.5600175741221697e-11
+ 4.375e-05 4.5624752229059989e-11
+ 4.3762207031249998e-05 4.5669966819297461e-11
+ 4.3774414062499997e-05 4.5718898557805248e-11
+ 4.3786621093750002e-05 4.5770037749483043e-11
+ 4.3798828125000001e-05 4.5822485350610839e-11
+ 4.381103515625e-05 4.5875705969269391e-11
+ 4.3823242187499998e-05 4.5929380773488921e-11
+ 4.3835449218749997e-05 4.5983319895906806e-11
+ 4.3847656250000002e-05 4.6037410269464089e-11
+ 4.3859863281250001e-05 4.6091584562801975e-11
+ 4.38720703125e-05 4.6145802680837535e-11
+ 4.3884277343749998e-05 4.6200040748086769e-11
+ 4.3896484374999997e-05 4.6254284548072891e-11
+ 4.3908691406250002e-05 4.6308525616398256e-11
+ 4.3920898437500001e-05 4.6362758914111761e-11
+ 4.393310546875e-05 4.641698144216514e-11
+ 4.3945312499999998e-05 4.6471191416301583e-11
+ 4.3957519531249997e-05 4.6525387775689795e-11
+ 4.3969726562500002e-05 4.6579569890308451e-11
+ 4.3981933593750001e-05 4.663373738668933e-11
+ 4.3994140625e-05 4.6687890044144897e-11
+ 4.4006347656249998e-05 4.6742027732970226e-11
+ 4.4018554687499997e-05 4.6796150377641402e-11
+ 4.4030761718750003e-05 4.6850257934899579e-11
+ 4.4042968750000001e-05 4.690435038069982e-11
+ 4.405517578125e-05 4.695842770243876e-11
+ 4.4067382812499998e-05 4.7012489894326265e-11
+ 4.4079589843749997e-05 4.7066536954629075e-11
+ 4.4091796875000003e-05 4.7120568884029375e-11
+ 4.4104003906250001e-05 4.7174585684647293e-11
+ 4.41162109375e-05 4.7228587359458799e-11
+ 4.4128417968749999e-05 4.728257391194907e-11
+ 4.4140624999999997e-05 4.7336545345906017e-11
+ 4.4152832031250003e-05 4.7390501665297362e-11
+ 4.4165039062500001e-05 4.7444442874197415e-11
+ 4.417724609375e-05 4.7498368976743532e-11
+ 4.4189453124999999e-05 4.7552279977110043e-11
+ 4.4201660156249997e-05 4.7606175879492929e-11
+ 4.4213867187499996e-05 4.76600566881005e-11
+ 4.4226074218750001e-05 4.771392240714795e-11
+ 4.423828125e-05 4.7767773040854128e-11
+ 4.4250488281249999e-05 4.7821608593439534e-11
+ 4.4262695312499997e-05 4.7875429069125182e-11
+ 4.4274902343750003e-05 4.7929234472131972e-11
+ 4.4287109375000001e-05 4.7983024806680162e-11
+ 4.429931640625e-05 4.8036800076989225e-11
+ 4.4311523437499999e-05 4.8090560287277661e-11
+ 4.4323730468749997e-05 4.81443054417629e-11
+ 4.4335937500000003e-05 4.8198035544661283e-11
+ 4.4348144531250001e-05 4.8251750600188019e-11
+ 4.43603515625e-05 4.8305450612557161e-11
+ 4.4372558593749999e-05 4.835913558598157e-11
+ 4.4384765624999997e-05 4.8412805524672993e-11
+ 4.4396972656250003e-05 4.846646043284194e-11
+ 4.4409179687500001e-05 4.8520100314697792e-11
+ 4.442138671875e-05 4.8573725174448732e-11
+ 4.4433593749999999e-05 4.8627335016301782e-11
+ 4.4445800781249997e-05 4.8680929844462761e-11
+ 4.4458007812500003e-05 4.8734509663136332e-11
+ 4.4470214843750002e-05 4.8788074476525962e-11
+ 4.4482421875e-05 4.8841624288833967e-11
+ 4.4494628906249999e-05 4.8895159104261467e-11
+ 4.4506835937499998e-05 4.894867892700839e-11
+ 4.4519042968750003e-05 4.9002183761273549e-11
+ 4.4531250000000002e-05 4.905567361125451e-11
+ 4.454345703125e-05 4.9109148481147716e-11
+ 4.4555664062499999e-05 4.9162608375148381e-11
+ 4.4567871093749998e-05 4.9216053297450589e-11
+ 4.4580078125000003e-05 4.9269483252247235e-11
+ 4.4592285156250002e-05 4.932289824373005e-11
+ 4.46044921875e-05 4.9376298276089576e-11
+ 4.4616699218749999e-05 4.9429683353515166e-11
+ 4.4628906249999998e-05 4.9483053480195042e-11
+ 4.4641113281250003e-05 4.9536408660316226e-11
+ 4.4653320312500002e-05 4.9589748898064572e-11
+ 4.466552734375e-05 4.9643074197624777e-11
+ 4.4677734374999999e-05 4.9696384563180337e-11
+ 4.4689941406249998e-05 4.9749679998913594e-11
+ 4.4702148437500003e-05 4.980296050900572e-11
+ 4.4714355468750002e-05 4.9856226097636712e-11
+ 4.47265625e-05 4.99094767689854e-11
+ 4.4738769531249999e-05 4.9962712527229435e-11
+ 4.4750976562499998e-05 5.0015933376545304e-11
+ 4.4763183593750003e-05 5.0069139321108297e-11
+ 4.4775390625000002e-05 5.0122330365092602e-11
+ 4.478759765625e-05 5.0175506512671175e-11
+ 4.4799804687499999e-05 5.0228667768015851e-11
+ 4.4812011718749998e-05 5.0281814135297241e-11
+ 4.4824218749999996e-05 5.0334945618684835e-11
+ 4.4836425781250002e-05 5.0388062222346936e-11
+ 4.4848632812500001e-05 5.0441163950450669e-11
+ 4.4860839843749999e-05 5.0494250807162017e-11
+ 4.4873046874999998e-05 5.0547322796645784e-11
+ 4.4885253906249996e-05 5.060037992306559e-11
+ 4.4897460937500002e-05 5.0653422190583924e-11
+ 4.4909667968750001e-05 5.0706449603362099e-11
+ 4.4921874999999999e-05 5.0759462165560252e-11
+ 4.4934082031249998e-05 5.0812459881337356e-11
+ 4.4946289062499997e-05 5.086544275485121e-11
+ 4.4958496093750002e-05 5.0918410790258479e-11
+ 4.4970703125000001e-05 5.0971363991714641e-11
+ 4.4982910156249999e-05 5.1024302363374004e-11
+ 4.4995117187499998e-05 5.1077225909389738e-11
+ 4.5007324218749997e-05 5.1130134633913832e-11
+ 4.5019531250000002e-05 5.1183028541097097e-11
+ 4.5031738281250001e-05 5.123590763508922e-11
+ 4.5043945312499999e-05 5.1288771920038706e-11
+ 4.5056152343749998e-05 5.1341621400092889e-11
+ 4.5068359374999997e-05 5.1394456079397949e-11
+ 4.5080566406249995e-05 5.1447275962098919e-11
+ 4.5092773437500001e-05 5.1500081052339658e-11
+ 4.5104980468749999e-05 5.1552871354262853e-11
+ 4.5117187499999998e-05 5.1605646872010057e-11
+ 4.5129394531249997e-05 5.1658407609721638e-11
+ 4.5141601562499995e-05 5.171115357153682e-11
+ 4.5153808593750001e-05 5.1763884761593666e-11
+ 4.5166015624999999e-05 5.1816601184029079e-11
+ 4.5178222656249998e-05 5.1869302842978788e-11
+ 4.5190429687499997e-05 5.1921989742577379e-11
+ 4.5202636718749995e-05 5.1974661886958285e-11
+ 4.5214843749999994e-05 5.2027319280253771e-11
+ 4.522705078125e-05 5.2079961926594946e-11
+ 4.5239257812499998e-05 5.2132589830111786e-11
+ 4.5251464843749997e-05 5.2185202994933079e-11
+ 4.5263671874999995e-05 5.2237801425186463e-11
+ 4.5275878906249994e-05 5.2290385124998426e-11
+ 4.52880859375e-05 5.2342954098494298e-11
+ 4.5300292968749998e-05 5.2395508349798247e-11
+ 4.5312499999999997e-05 5.2448047883033309e-11
+ 4.5324707031249996e-05 5.2500572702321331e-11
+ 4.5336914062499994e-05 5.2553082811783024e-11
+ 4.534912109375e-05 5.260557821553798e-11
+ 4.5361328124999998e-05 5.265805891770455e-11
+ 4.5373535156249997e-05 5.2710524922400013e-11
+ 4.5385742187499996e-05 5.2762976233740464e-11
+ 4.5397949218749994e-05 5.281541285584085e-11
+ 4.541015625e-05 5.2867834792814952e-11
+ 4.5422363281249998e-05 5.2920242048775429e-11
+ 4.5434570312499997e-05 5.297263462783375e-11
+ 4.5446777343749996e-05 5.3025012534100265e-11
+ 4.5458984374999994e-05 5.3077375771684144e-11
+ 4.5471191406249993e-05 5.3129724344693429e-11
+ 4.5483398437499998e-05 5.3182058257235008e-11
+ 4.5495605468749997e-05 5.3234377513414598e-11
+ 4.5507812499999996e-05 5.3286682117336819e-11
+ 4.5520019531249994e-05 5.3338972073105086e-11
+ 4.5532226562499993e-05 5.339124738482168e-11
+ 4.5544433593749998e-05 5.3443508056587737e-11
+ 4.5556640624999997e-05 5.349575409250326e-11
+ 4.5568847656249996e-05 5.3547985496667078e-11
+ 4.5581054687499994e-05 5.3600202273176877e-11
+ 4.5593261718749993e-05 5.3652404426129203e-11
+ 4.5605468749999992e-05 5.3704591959619454e-11
+ 4.5617675781249997e-05 5.3756764877741888e-11
+ 4.5629882812499996e-05 5.3808923184589598e-11
+ 4.5642089843749994e-05 5.3861066884254534e-11
+ 4.5654296874999993e-05 5.3913195980827531e-11
+ 4.5666503906249992e-05 5.3965310478398236e-11
+ 4.5678710937499997e-05 5.4017410381055188e-11
+ 4.5690917968749996e-05 5.4069495692885746e-11
+ 4.5703124999999995e-05 5.4121566417976143e-11
+ 4.5715332031249993e-05 5.4173622560411455e-11
+ 4.5727539062499992e-05 5.4225664124275648e-11
+ 4.5739746093749997e-05 5.4277691113651499e-11
+ 4.5751953124999996e-05 5.4329703532620677e-11
+ 4.5764160156249995e-05 5.4381701385263697e-11
+ 4.5776367187499993e-05 5.4433684675659917e-11
+ 4.5788574218749992e-05 5.4485653407887576e-11
+ 4.5800781249999997e-05 5.4537607586023745e-11
+ 4.5812988281249996e-05 5.4589547214144361e-11
+ 4.5825195312499995e-05 5.4641472296324253e-11
+ 4.5837402343749993e-05 5.4693382836637059e-11
+ 4.5849609374999992e-05 5.4745278839155299e-11
+ 4.5861816406249991e-05 5.4797160307950356e-11
+ 4.5874023437499996e-05 5.4849027247092475e-11
+ 4.5886230468749995e-05 5.4900879660650734e-11
+ 4.5898437499999993e-05 5.4952717552693121e-11
+ 4.5910644531249992e-05 5.5004540927286431e-11
+ 4.5922851562499991e-05 5.5055228596414379e-11
+ 4.5935058593749996e-05 5.510627065877697e-11
+ 4.5947265624999995e-05 5.5158092921228189e-11
+ 4.5959472656249993e-05 5.5210849104087091e-11
+ 4.5971679687499992e-05 5.5264521350196526e-11
+ 4.5983886718749991e-05 5.5318219478297029e-11
+ 4.598999023437499e-05 5.5343709041866146e-11
+ 4.5996093749999989e-05 5.5365175813779936e-11
+ 4.5999145507812496e-05 5.537183500008943e-11
+ 4.6002197265624995e-05 5.5371668509114686e-11
+ 4.6005249023437495e-05 5.5354771851498252e-11
+ 4.6006606790774087e-05 5.5334751403020664e-11
+ 4.600699821666086e-05 5.5326313558461538e-11
+ 4.6007389642547633e-05 5.5316205768572161e-11
+ 4.6008368207264575e-05 5.5280832763072969e-11
+ 4.6009409502908186e-05 5.5216998316807767e-11
+ 4.6009970598735321e-05 5.5162661637241072e-11
+ 4.6010339629298367e-05 5.5114439869388932e-11
+ 4.6011110323815842e-05 5.4960015216721681e-11
+ 4.6011741481233845e-05 5.4732817211499076e-11
+ 4.6012113084009007e-05 5.4516300482441227e-11
+ 4.6012434193795792e-05 5.42419953316085e-11
+ 4.6012647097925407e-05 5.400886072195258e-11
+ 4.6012860002055029e-05 5.3774257755821461e-11
+ 4.6014989043351243e-05 5.1549852354822979e-11
+ 4.6027196074601242e-05 4.2855387214314058e-11
+ 4.6039403105851241e-05 4.053247294954365e-11
+ 4.6051610137101246e-05 4.3931039996784842e-11
+ 4.6063817168351245e-05 5.2388572167819672e-11
+ 4.6076024199601244e-05 6.5140225940715896e-11
+ 4.6088231230851242e-05 8.1286621114128428e-11
+ 4.6100438262101241e-05 9.9800201152591339e-11
+ 4.6112645293351246e-05 1.1955731974057662e-10
+ 4.6124852324601245e-05 1.3938677731239894e-10
+ 4.6137059355851244e-05 1.581275910662053e-10
+ 4.6149266387101242e-05 1.7469004130247602e-10
+ 4.6161473418351241e-05 1.881149150311095e-10
+ 4.617368044960124e-05 1.9762660690176225e-10
+ 4.6185887480851245e-05 2.026764694324815e-10
+ 4.6198094512101244e-05 2.0297359093770258e-10
+ 4.6210301543351242e-05 1.9850103705845601e-10
+ 4.6222508574601241e-05 1.8951650785639057e-10
+ 4.623471560585124e-05 1.7653730627935789e-10
+ 4.6246922637101245e-05 1.6031044421422816e-10
+ 4.6259129668351244e-05 1.4176958358946107e-10
+ 4.6271336699601242e-05 1.2198127662112241e-10
+ 4.6283543730851241e-05 1.0208359001036545e-10
+ 4.629575076210124e-05 8.3220638681385549e-11
+ 4.6307957793351238e-05 6.6476791169901555e-11
+ 4.6311009551163745e-05 6.2738216402259133e-11
+ 4.631131472694499e-05 6.2375524734021021e-11
+ 4.631207766639812e-05 6.1477937832984702e-11
+ 4.6312459136124682e-05 6.1034090082773124e-11
+ 4.6312482977982586e-05 6.1006459924724939e-11
+ 4.6312487746354169e-05 6.1000935454857881e-11
+ 4.6312497283097336e-05 6.0989888077255491e-11
+ 4.6312498046036785e-05 6.0989004377034889e-11
+ 4.6312499571915695e-05 6.0987237016591268e-11
+ 4.6312499693986004e-05 6.0987095630059761e-11
+ 4.6312499938126629e-05 6.0986812858020706e-11
+ 4.6312499957657881e-05 6.0986790236316644e-11
+ 4.6312499996720384e-05 6.098674499293473e-11
+ 4.6312500074845384e-05 6.2330481534674083e-11
+ 4.6312500152970384e-05 6.6608198187672893e-11
+ 4.631250093422038e-05 2.7075208822833839e-10
+ 4.6312508051845975e-05 1.5641542586395462e-08
+ 4.6312515169471569e-05 5.5354276368357439e-08
+ 4.631252228709717e-05 1.1939590331347595e-07
+ 4.6312529404722764e-05 2.0774988808958391e-07
+ 4.6312536522348359e-05 3.2039621340029153e-07
+ 4.6312543639973953e-05 4.5731138406416947e-07
+ 4.6312550757599554e-05 6.1846843192454422e-07
+ 4.6312557875225148e-05 8.0383692158836119e-07
+ 4.6312564992850742e-05 1.0133829569922963e-06
+ 4.6312572110476343e-05 1.2470691887940203e-06
+ 4.6312579228101938e-05 1.5048548225862434e-06
+ 4.631258780756857e-05 1.8475543476526228e-06
+ 4.6312596387035202e-05 2.2251205386231599e-06
+ 4.6312604966501834e-05 2.637462112110794e-06
+ 4.6312613545968466e-05 3.0844806091734263e-06
+ 4.6312622125435098e-05 3.5660704276185103e-06
+ 4.631263070490173e-05 4.0821188567621002e-06
+ 4.6312639284368362e-05 4.6325061146258863e-06
+ 4.6312647863834994e-05 5.2171053875545835e-06
+ 4.6312658180770248e-05 5.965211217502911e-06
+ 4.6312668497705501e-05 6.7623492313414161e-06
+ 4.6312678814640762e-05 7.6082590651614992e-06
+ 4.6312689131576016e-05 8.5026660760363497e-06
+ 4.6312699448511269e-05 9.4452814742207388e-06
+ 4.631270976544653e-05 1.0435802462230257e-05
+ 4.6312720082381783e-05 1.147391238070454e-05
+ 4.6312730399317037e-05 1.25592808609545e-05
+ 4.631274290201226e-05 1.393744004677843e-05
+ 4.6312755404707475e-05 1.538385928477854e-05
+ 4.6312767907402698e-05 1.6897871760843825e-05
+ 4.6312780410097913e-05 1.8478782715895571e-05
+ 4.6312792912793136e-05 2.0125869935940648e-05
+ 4.6312805415488351e-05 2.1838384260846487e-05
+ 4.6312817918183574e-05 2.3615550111329756e-05
+ 4.631283042087879e-05 2.5456566033633845e-05
+ 4.6312845592253871e-05 2.7775100207116592e-05
+ 4.6312860763628953e-05 3.0184906039223483e-05
+ 4.6312875935004034e-05 3.2684405463249104e-05
+ 4.6312891106379116e-05 3.5271969973378807e-05
+ 4.631290627775419e-05 3.7945922288216153e-05
+ 4.6312921449129272e-05 4.0704538058428326e-05
+ 4.6312936620504353e-05 4.3546047616054653e-05
+ 4.6312954860519558e-05 4.7069469432613542e-05
+ 4.6312973100534769e-05 5.0706855826657106e-05
+ 4.6312991340549973e-05 5.4454893918205257e-05
+ 4.6313009580565184e-05 5.8310193146384224e-05
+ 4.6313027820580389e-05 6.2269290123695639e-05
+ 4.6313046060595593e-05 6.6328653564053143e-05
+ 4.6313068199865841e-05 7.1385338233594827e-05
+ 4.631309033913609e-05 7.6577901326810804e-05
+ 4.6313112478406345e-05 8.189969012601315e-05
+ 4.6313134617676593e-05 8.7343953274172687e-05
+ 4.6313161293011318e-05 9.4056657818521804e-05
+ 4.6313187873095806e-05 0.00010090035482762358
+ 4.6313214453180293e-05 0.00010788664307091889
+ 4.6313248688484338e-05 0.00011707548567577072
+ 4.6313282923788383e-05 0.00012645461865043843
+ 4.6313315356127044e-05 0.00013549167951766453
+ 4.6313347788465712e-05 0.00014465398332574899
+ 4.6313380220804374e-05 0.00015391958689944246
+ 4.6313412653143035e-05 0.00016326679416820027
+ 4.6313445085481704e-05 0.00017267423453976973
+ 4.6313477517820365e-05 0.00018212093762926101
+ 4.6313509950159027e-05 0.00019158640400330904
+ 4.6313542382497695e-05 0.00020105067163597072
+ 4.6313569584998147e-05 0.00020897371829601134
+ 4.6313596787498599e-05 0.00021687121736840308
+ 4.631362398999905e-05 0.0002247324443841368
+ 4.6313651192499502e-05 0.00023254704172942061
+ 4.6313678394999961e-05 0.00024030503688061725
+ 4.6313705597500413e-05 0.00024799685880477063
+ 4.6313732800000864e-05 0.00025561335251051022
+ 4.6313760002501323e-05 0.00026314579174345146
+ 4.6313787205001775e-05 0.00027058588982929906
+ 4.6313814407502227e-05 0.00027792580867665878
+ 4.6313841610002679e-05 0.0002851581659600263
+ 4.631386881250313e-05 0.00029227604051150784
+ 4.6313896015003589e-05 0.00029927297595749906
+ 4.6313923217504041e-05 0.00030614298264376868
+ 4.6313950420004493e-05 0.00031288053789913813
+ 4.6313977622504951e-05 0.00031948058469418605
+ 4.6314004825005403e-05 0.00032593852875712024
+ 4.6314032027505855e-05 0.00033225023421413059
+ 4.6314059230006307e-05 0.00033841201782615327
+ 4.6314086432506759e-05 0.0003444206418985982
+ 4.6314115300883496e-05 0.00035062659892727544
+ 4.6314144169260234e-05 0.0003566540934654631
+ 4.6314173037636964e-05 0.00036250083298786399
+ 4.6314201906013702e-05 0.00036816503744223664
+ 4.6314230774390439e-05 0.00037364542226806104
+ 4.631425964276717e-05 0.00037894118026981165
+ 4.6314288511143908e-05 0.00038405196247931109
+ 4.6314317379520645e-05 0.000388977858140999
+ 4.6314346247897376e-05 0.00039371937395252178
+ 4.6314381135166685e-05 0.0003992047348763101
+ 4.6314416022435987e-05 0.00040442447430172904
+ 4.6314449985506048e-05 0.00040925368585940502
+ 4.6314483948576109e-05 0.00041383750344981278
+ 4.6314517911646177e-05 0.00041817993390062743
+ 4.6314551874716238e-05 0.00042228549548244641
+ 4.63145858377863e-05 0.00042615916749456922
+ 4.6314627381082819e-05 0.0004305900119691504
+ 4.6314668924379332e-05 0.00043469258490726371
+ 4.6314710467675845e-05 0.0004384781612780042
+ 4.6314752010972364e-05 0.00044195857402361564
+ 4.63148023225231e-05 0.00044578261210212054
+ 4.6314853125173632e-05 0.00044923093231022854
+ 4.631490392782417e-05 0.00045228765276156626
+ 4.6314971607266245e-05 0.00045579239535176001
+ 4.6315039286708319e-05 0.00045870005395461338
+ 4.6315091919396566e-05 0.00046058369469111949
+ 4.6315144552084813e-05 0.00046216451732223918
+ 4.6315197184773053e-05 0.00046346681282214352
+ 4.63152498174613e-05 0.00046451393123718372
+ 4.6315297809929101e-05 0.00046526519657479943
+ 4.6315345802396903e-05 0.00046583893527304737
+ 4.6315393794864711e-05 0.00046625041073407677
+ 4.6315441787332513e-05 0.00046651403875466578
+ 4.6315489779800314e-05 0.0004666433740508164
+ 4.6315537261554865e-05 0.00046665162291553914
+ 4.631558474330941e-05 0.000466552308242554
+ 4.6315632225063961e-05 0.00046635608374731292
+ 4.6315679706818512e-05 0.00046607281339991539
+ 4.6315727188573056e-05 0.00046571159614456351
+ 4.6315774670327607e-05 0.00046528079492301239
+ 4.6315824358583362e-05 0.00046476378468933915
+ 4.6315874046839123e-05 0.00046418694952370777
+ 4.6315923735094878e-05 0.00046355752837163748
+ 4.6315973423350633e-05 0.00046288205221083837
+ 4.6316023111606394e-05 0.00046216639229460844
+ 4.6316072799862149e-05 0.00046141580830294233
+ 4.6316127951386074e-05 0.00046054748419045071
+ 4.6316183102909999e-05 0.00045964758393211987
+ 4.6316238254433925e-05 0.00045872107390199996
+ 4.631629340595785e-05 0.00045777228079549998
+ 4.6316348557481782e-05 0.00045680495887963081
+ 4.6316411640520541e-05 0.000455679953428722
+ 4.6316474723559299e-05 0.00045453907391423655
+ 4.6316537806598058e-05 0.0004533857886546739
+ 4.6316600889636817e-05 0.00045222299034028662
+ 4.6316674140146425e-05 0.00045086399130210022
+ 4.6316747390656032e-05 0.00044949844535668453
+ 4.631682064116564e-05 0.00044812878579885432
+ 4.6316905619421585e-05 0.00044653719761490697
+ 4.6316990597677523e-05 0.0004449449586312652
+ 4.6317093836844786e-05 0.00044301214871122791
+ 4.631719817176941e-05 0.00044106269601017851
+ 4.6317302506694042e-05 0.00043911870626636078
+ 4.631742666446916e-05 0.00043681393387383496
+ 4.6317550822244286e-05 0.00043451951813961668
+ 4.631770580080653e-05 0.00043167106196547318
+ 4.6317884937131783e-05 0.00042840086834201771
+ 4.6318098556602386e-05 0.00042453293757745131
+ 4.6318364485722955e-05 0.00041976628303681877
+ 4.6318717982712203e-05 0.00041351261779238365
+ 4.6319242097564145e-05 0.00040441158298440465
+ 4.6320136340120472e-05 0.00038934346113524376
+ 4.6322132807185037e-05 0.00035769765454050228
+ 4.6323988816858015e-05 0.00033058981538904275
+ 4.6326421668443079e-05 0.00029814348467284587
+ 4.6328854520028143e-05 0.00026888165874455468
+ 4.6331287371613208e-05 0.00024249178888257299
+ 4.6333720223198272e-05 0.00021869200206866874
+ 4.6336153074783329e-05 0.00019722808975099272
+ 4.6338585926368394e-05 0.00017787079297825666
+ 4.6341018777953458e-05 0.00016041335425741158
+ 4.6343451629538522e-05 0.0001446693086575522
+ 4.6345767705239777e-05 0.00013111903917235234
+ 4.6348819440406715e-05 0.00011518312547724692
+ 4.635187117557366e-05 0.00010118403045864018
+ 4.6354922910740598e-05 8.8886357108097517e-05
+ 4.6357974645907537e-05 7.8083318131395906e-05
+ 4.6361026381074475e-05 6.8593258842393536e-05
+ 4.6364078116241413e-05 6.025660181923537e-05
+ 4.63677736187736e-05 5.1505809187250614e-05
+ 4.6371134288610905e-05 4.4656271026532631e-05
+ 4.6374494958448217e-05 3.8717628008379948e-05
+ 4.637862073169028e-05 3.2495702272495222e-05
+ 4.6382746504932337e-05 2.7273646663031209e-05
+ 4.6386872278174393e-05 2.2890780980831938e-05
+ 4.6390998051416456e-05 1.9212246512347876e-05
+ 4.6395123824658513e-05 1.6124856494297113e-05
+ 4.6400251138437096e-05 1.2970141364146993e-05
+ 4.6405378452215679e-05 1.0432633172092827e-05
+ 4.6410505765994262e-05 8.3915781182774641e-06
+ 4.6415633079772845e-05 6.7498471833962207e-06
+ 4.6421995979825152e-05 5.1518189724579756e-06
+ 4.6428358879877459e-05 3.9321378049054371e-06
+ 4.6434721779929766e-05 3.0012267671564931e-06
+ 4.644249725625451e-05 2.15737185496337e-06
+ 4.6450272732579248e-05 1.5508026051292012e-06
+ 4.6458048208903993e-05 1.1147960586695601e-06
+ 4.6467983441936069e-05 7.3118840550782522e-07
+ 4.6477918674968138e-05 4.7961075194826108e-07
+ 4.6490125706218144e-05 2.8571159964289929e-07
+ 4.6502332737468142e-05 1.7024209705967684e-07
+ 4.6514539768718141e-05 1.0147848625806179e-07
+ 4.652674679996814e-05 6.0528851952355526e-08
+ 4.6538953831218138e-05 3.6142806128821739e-08
+ 4.6551160862468144e-05 2.1620593980565466e-08
+ 4.6563367893718142e-05 1.2972424953734794e-08
+ 4.6575574924968141e-05 7.8223266739669589e-09
+ 4.658778195621814e-05 4.7553755500354248e-09
+ 4.6599988987468138e-05 2.9289656540459339e-09
+ 4.6612196018718137e-05 1.8413143839828223e-09
+ 4.6624403049968142e-05 1.1936037658401295e-09
+ 4.6636610081218141e-05 8.078836241498485e-10
+ 4.664881711246814e-05 5.7818218790680653e-10
+ 4.6661024143718138e-05 4.4139192644487092e-10
+ 4.6673231174968137e-05 3.5993152647751398e-10
+ 4.6685438206218142e-05 3.1142080027758294e-10
+ 4.6697645237468141e-05 2.8253202431124535e-10
+ 4.670985226871814e-05 2.653283707170538e-10
+ 4.6722059299968138e-05 2.5508336753526945e-10
+ 4.6734266331218137e-05 2.4898233649178344e-10
+ 4.6746473362468143e-05 2.4534909287155193e-10
+ 4.6758680393718141e-05 2.4318544696123555e-10
+ 4.677088742496814e-05 2.4189696683490067e-10
+ 4.6783094456218139e-05 2.411296605642883e-10
+ 4.6795301487468137e-05 2.406727199550333e-10
+ 4.6807508518718143e-05 2.4040060549918595e-10
+ 4.6819715549968141e-05 2.4023855751768804e-10
+ 4.683192258121814e-05 2.4014205601586099e-10
+ 4.6844129612468139e-05 2.4008458822552009e-10
+ 4.6856336643718137e-05 2.4005036536744095e-10
+ 4.6868543674968136e-05 2.4002998505548136e-10
+ 4.6880750706218141e-05 2.4001784836154639e-10
+ 4.689295773746814e-05 2.4001062082534474e-10
+ 4.6905164768718139e-05 2.4000631674323626e-10
+ 4.6917371799968137e-05 2.4000375361391963e-10
+ 4.6929578831218136e-05 2.4000222718017004e-10
+ 4.6941785862468141e-05 2.4000131819356677e-10
+ 4.695399289371814e-05 2.4000077702242996e-10
+ 4.6966199924968139e-05 2.4000045459933931e-10
+ 4.6978406956218137e-05 2.4000026257884156e-10
+ 4.6990613987468136e-05 2.4000014832025053e-10
+ 4.7002821018718135e-05 2.4000008023582484e-10
+ 4.701502804996814e-05 2.4000003966625581e-10
+ 4.7027235081218139e-05 2.400000155533385e-10
+ 4.7039442112468137e-05 2.4000000121814107e-10
+ 4.7051649143718136e-05 2.3999999261673205e-10
+ 4.7063856174968135e-05 2.3999998758456908e-10
+ 4.707606320621814e-05 2.3999998453222656e-10
+ 4.7088270237468139e-05 2.3999998265390494e-10
+ 4.7100477268718137e-05 2.3999998161732485e-10
+ 4.7112684299968136e-05 2.3999998104358188e-10
+ 4.7124891331218135e-05 2.3999998057389865e-10
+ 4.713709836246814e-05 2.3999998026292464e-10
+ 4.7149305393718139e-05 2.3999998019001177e-10
+ 4.7161512424968138e-05 2.3999998019899801e-10
+ 4.7173719456218136e-05 2.3999998020597388e-10
+ 4.7185926487468135e-05 2.3999998012855701e-10
+ 4.719813351871814e-05 2.3999998005534517e-10
+ 4.7210340549968139e-05 2.3999998008389102e-10
+ 4.7222547581218138e-05 2.3999998009224399e-10
+ 4.7234754612468136e-05 2.3999998012219294e-10
+ 4.7246961643718135e-05 2.3999998013282356e-10
+ 4.7259168674968134e-05 2.3999998009115475e-10
+ 4.7271375706218139e-05 2.3999998009706464e-10
+ 4.7283582737468138e-05 2.3999998010363494e-10
+ 4.7295789768718136e-05 2.3999998011314167e-10
+ 4.7307996799968135e-05 2.3999998013616955e-10
+ 4.7320203831218134e-05 2.3999998011363462e-10
+ 4.7332410862468139e-05 2.3999998009274014e-10
+ 4.7344617893718138e-05 2.399999801011231e-10
+ 4.7356824924968136e-05 2.399999800977465e-10
+ 4.7369031956218135e-05 2.3999998010717031e-10
+ 4.7381238987468134e-05 2.3999998026497155e-10
+ 4.7393446018718132e-05 2.3999998018940695e-10
+ 4.7405653049968138e-05 2.399999801489314e-10
+ 4.7417860081218136e-05 2.3999998016252337e-10
+ 4.7430067112468135e-05 2.3999998017736873e-10
+ 4.7442274143718134e-05 2.3999998008841631e-10
+ 4.7454481174968132e-05 2.399999801406156e-10
+ 4.7466688206218138e-05 2.3999998027111368e-10
+ 4.7478895237468136e-05 2.399999803096209e-10
+ 4.7491102268718135e-05 2.399999801745041e-10
+ 4.7503309299968134e-05 2.3999998014351678e-10
+ 4.7515516331218132e-05 2.399999802735929e-10
+ 4.7527723362468138e-05 2.3999998026179471e-10
+ 4.7539930393718136e-05 2.3999998016976751e-10
+ 4.7552137424968135e-05 2.3999998022820648e-10
+ 4.7564344456218134e-05 2.3999998018386391e-10
+ 4.7576551487468132e-05 2.3999998024457121e-10
+ 4.7588758518718138e-05 2.399999802712344e-10
+ 4.7600965549968137e-05 2.3999998016906244e-10
+ 4.7613172581218135e-05 2.399999802251944e-10
+ 4.7625379612468134e-05 2.3999998029674961e-10
+ 4.7637586643718139e-05 2.3999998024490881e-10
+ 4.7649793674968138e-05 2.3999998022841694e-10
+ 4.7662000706218137e-05 2.3999998027402318e-10
+ 4.7674207737468135e-05 2.3999998031284179e-10
+ 4.7686414768718141e-05 2.3999998024592236e-10
+ 4.7698621799968139e-05 2.3999998028900653e-10
+ 4.7710828831218138e-05 2.3999998029018118e-10
+ 4.7723035862468137e-05 2.3999998020407995e-10
+ 4.7735242893718142e-05 2.3999998030027903e-10
+ 4.7747449924968141e-05 2.3999998034659856e-10
+ 4.7759656956218139e-05 2.3999998035710371e-10
+ 4.7771863987468138e-05 2.3999998035781327e-10
+ 4.7784071018718143e-05 2.3999998028429372e-10
+ 4.7796278049968142e-05 2.3999998026462584e-10
+ 4.7808485081218141e-05 2.3999998034401652e-10
+ 4.7820692112468139e-05 2.3999998040748526e-10
+ 4.7832899143718145e-05 2.399999802904164e-10
+ 4.7845106174968144e-05 2.3999998026488739e-10
+ 4.7857313206218142e-05 2.399999803948264e-10
+ 4.7869520237468141e-05 2.399999803901337e-10
+ 4.7881727268718146e-05 2.3999998030809217e-10
+ 4.7893934299968145e-05 2.3999998036169063e-10
+ 4.7906141331218144e-05 2.3999998033495331e-10
+ 4.7918348362468142e-05 2.3999998039429674e-10
+ 4.7930555393718148e-05 2.3999998043834603e-10
+ 4.7942762424968146e-05 2.3999998042747548e-10
+ 4.7954969456218145e-05 2.3999998033813589e-10
+ 4.7967176487468144e-05 2.3999998042749197e-10
+ 4.7979383518718149e-05 2.3999998045576412e-10
+ 4.7991590549968148e-05 2.3999998040668088e-10
+ 4.8003797581218146e-05 2.3999998041015307e-10
+ 4.8016004612468145e-05 2.3999998038280188e-10
+ 4.802821164371815e-05 2.399999804963409e-10
+ 4.8040418674968149e-05 2.3999998050724164e-10
+ 4.8052625706218148e-05 2.3999998043757132e-10
+ 4.8064832737468146e-05 2.3999998042873677e-10
+ 4.8077039768718152e-05 2.3999998048062938e-10
+ 4.8089246799968151e-05 2.3999998046244087e-10
+ 4.8101453831218149e-05 2.3999998047367506e-10
+ 4.8113660862468148e-05 2.3999998045481209e-10
+ 4.8125867893718153e-05 2.3999998043752122e-10
+ 4.8138074924968152e-05 2.3999998042446345e-10
+ 4.8150281956218151e-05 2.3999998041722252e-10
+ 4.8162488987468149e-05 2.3999998041674074e-10
+ 4.8174696018718155e-05 2.3999998042357827e-10
+ 4.8186903049968153e-05 2.3999998043806778e-10
+ 4.8199110081218152e-05 2.3999998047660411e-10
+ 4.8211317112468151e-05 2.3999998051655456e-10
+ 4.8223524143718156e-05 2.3999998052591767e-10
+ 4.8235731174968155e-05 2.3999998048427911e-10
+ 4.8247938206218153e-05 2.3999998054712477e-10
+ 4.8260145237468152e-05 2.3999998057013456e-10
+ 4.8272352268718157e-05 2.3999998051176627e-10
+ 4.8284559299968156e-05 2.3999998057450993e-10
+ 4.8296766331218155e-05 2.3999998053652084e-10
+ 4.8308973362468153e-05 2.3999998056705243e-10
+ 4.8321180393718159e-05 2.399999805326457e-10
+ 4.8333387424968158e-05 2.399999805718764e-10
+ 4.8345594456218156e-05 2.3999998054921403e-10
+ 4.8357801487468155e-05 2.3999998061819825e-10
+ 4.837000851871816e-05 2.399999805688973e-10
+ 4.8382215549968159e-05 2.3999998054792621e-10
+ 4.8394422581218158e-05 2.39999980627754e-10
+ 4.8406629612468156e-05 2.3999998059474422e-10
+ 4.8418836643718162e-05 2.399999805933057e-10
+ 4.843104367496816e-05 2.3999998057922352e-10
+ 4.8443250706218159e-05 2.3999998056088616e-10
+ 4.8455457737468158e-05 2.3999998058786213e-10
+ 4.8467664768718163e-05 2.399999806005213e-10
+ 4.8479871799968162e-05 2.3999998060792622e-10
+ 4.849207883121816e-05 2.3999998061547279e-10
+ 4.8504285862468159e-05 2.3999998062637359e-10
+ 4.8516492893718164e-05 2.3999998064254068e-10
+ 4.8528699924968163e-05 2.399999806651119e-10
+ 4.8540906956218162e-05 2.3999998065019003e-10
+ 4.855311398746816e-05 2.3999998066078063e-10
+ 4.8565321018718166e-05 2.399999807158811e-10
+ 4.8577528049968165e-05 2.3999998065933043e-10
+ 4.8589735081218163e-05 2.3999998069949765e-10
+ 4.8601942112468162e-05 2.3999998071137632e-10
+ 4.8614149143718167e-05 2.3999998066492584e-10
+ 4.8626356174968166e-05 2.3999998067631891e-10
+ 4.8638563206218165e-05 2.3999998068067386e-10
+ 4.8650770237468163e-05 2.3999998072884115e-10
+ 4.8662977268718169e-05 2.3999998071703879e-10
+ 4.8675184299968167e-05 2.399999807620995e-10
+ 4.8687391331218166e-05 2.3999998071038665e-10
+ 4.8699598362468165e-05 2.3999998068359319e-10
+ 4.871180539371817e-05 2.3999998073934671e-10
+ 4.8724012424968169e-05 2.3999998074833904e-10
+ 4.8736219456218167e-05 2.3999998072288318e-10
+ 4.8748426487468166e-05 2.3999998078919143e-10
+ 4.8760633518718171e-05 2.3999998076965073e-10
+ 4.877284054996817e-05 2.399999807468099e-10
+ 4.8785047581218169e-05 2.3999998076982682e-10
+ 4.8797254612468167e-05 2.3999998077882701e-10
+ 4.8809461643718173e-05 2.3999998078272732e-10
+ 4.8821668674968172e-05 2.3999998077698307e-10
+ 4.883387570621817e-05 2.3999998078844893e-10
+ 4.8846082737468169e-05 2.3999998080355428e-10
+ 4.8858289768718174e-05 2.3999998082407074e-10
+ 4.8870496799968173e-05 2.3999998085105249e-10
+ 4.8882703831218172e-05 2.3999998076975625e-10
+ 4.889491086246817e-05 2.399999808033618e-10
+ 4.8907117893718176e-05 2.3999998080328762e-10
+ 4.8919324924968174e-05 2.3999998084082399e-10
+ 4.8931531956218173e-05 2.3999998077877215e-10
+ 4.8943738987468172e-05 2.3999998083679345e-10
+ 4.8955946018718177e-05 2.3999998087406507e-10
+ 4.8968153049968176e-05 2.3999998083776306e-10
+ 4.8980360081218174e-05 2.3999998086990843e-10
+ 4.8992567112468173e-05 2.3999998083702247e-10
+ 4.9004774143718178e-05 2.399999808776692e-10
+ 4.9016981174968177e-05 2.3999998085631119e-10
+ 4.9029188206218176e-05 2.3999998083949021e-10
+ 4.9041395237468174e-05 2.3999929577393646e-10
+ 4.905360226871818e-05 2.3999721430085655e-10
+ 4.9065809299968178e-05 2.3999541801853927e-10
+ 4.9078016331218177e-05 2.3999352441667849e-10
+ 4.9090223362468176e-05 2.3998998231508299e-10
+ 4.9102430393718181e-05 2.3998269751518182e-10
+ 4.911463742496818e-05 2.3996731785187146e-10
+ 4.9120740940593179e-05 2.3994983464395233e-10
+ 4.9126844456218179e-05 2.3990674100743305e-10
+ 4.9129896214030678e-05 2.3985615585153402e-10
+ 4.9132947971843178e-05 2.3973456609508262e-10
+ 4.9134473850749431e-05 2.3959023649420816e-10
+ 4.9135999729655678e-05 2.3924487360909957e-10
+ 4.9136991106889184e-05 2.3866252493064795e-10
+ 4.9137269733896244e-05 2.3836567845599657e-10
+ 4.9137548360903296e-05 2.3795958755937176e-10
+ 4.9138098835627971e-05 2.3707317678626589e-10
+ 4.9140875273912438e-05 2.3289947932096134e-10
+ 4.9153082305162436e-05 2.1857108082062022e-10
+ 4.9165289336412435e-05 2.0744394567167327e-10
+ 4.9177496367662434e-05 1.9657101424192844e-10
+ 4.9189703398912432e-05 1.8444183633608339e-10
+ 4.9201910430162438e-05 1.7048236032410772e-10
+ 4.9214117461412436e-05 1.5473832156939622e-10
+ 4.9226324492662435e-05 1.376643966131987e-10
+ 4.9238531523912441e-05 1.1997405552563603e-10
+ 4.9250738555162439e-05 1.0252468847149855e-10
+ 4.9262945586412438e-05 8.622433036431135e-11
+ 4.9275152617662437e-05 7.1953269034585456e-11
+ 4.9287359648912435e-05 6.0497851486217764e-11
+ 4.9299566680162441e-05 5.2496010132610782e-11
+ 4.9311773711412439e-05 4.8395088933560857e-11
+ 4.9323980742662438e-05 4.8422873289603413e-11
+ 4.9336187773912443e-05 5.2572582289997926e-11
+ 4.9348394805162442e-05 6.0602144636946106e-11
+ 4.9360601836412441e-05 7.2047475992215135e-11
+ 4.9372808867662439e-05 8.6248800170538565e-11
+ 4.9385015898912438e-05 1.0238838404643464e-10
+ 4.9397222930162443e-05 1.19537446121802e-10
+ 4.9409429961412442e-05 1.367094991032434e-10
+ 4.9421636992662441e-05 1.5291703382970249e-10
+ 4.9433844023912446e-05 1.6722827017382802e-10
+ 4.9436895781724939e-05 1.7041028620342427e-10
+ 4.9437048369615565e-05 1.7056469761267313e-10
+ 4.9437429839342133e-05 1.7094872387604414e-10
+ 4.9437467986314788e-05 1.7098696858623529e-10
+ 4.9437475615709321e-05 1.7099461407315297e-10
+ 4.9437490874498378e-05 1.7100990159048815e-10
+ 4.9437496978014007e-05 1.7101601530675094e-10
+ 4.9437499419420256e-05 1.7101846058671687e-10
+ 4.9437499604455782e-05 1.7101864591102341e-10
+ 4.9437499974526835e-05 1.710190165576025e-10
+ 4.9437500714668947e-05 2.9362295535076986e-10
+ 4.943750145481106e-05 6.7955376462053112e-10
+ 4.9437508856232143e-05 1.9019685483973129e-08
+ 4.9437516257653239e-05 6.3680162617685321e-08
+ 4.9437523659074322e-05 1.3464578979540883e-07
+ 4.9437531060495419e-05 2.3189729697639808e-07
+ 4.9437538461916502e-05 3.5541134357275011e-07
+ 4.9437547512355685e-05 5.4209487018455778e-07
+ 4.9437556562794869e-05 7.6794744751962639e-07
+ 4.9437565613234046e-05 1.032901665904789e-06
+ 4.9437574663673229e-05 1.3368810846168448e-06
+ 4.9437583714112413e-05 1.6798002590529673e-06
+ 4.9437595044533512e-05 2.1638522289015684e-06
+ 4.943760637495461e-05 2.7085809274094572e-06
+ 4.9437617705375708e-05 3.3137595140903088e-06
+ 4.9437629035796807e-05 3.9791394372703589e-06
+ 4.9437643214653362e-05 4.8961848891924115e-06
+ 4.9437657393509916e-05 5.9065041934527361e-06
+ 4.9437671572366471e-05 7.0094688242501652e-06
+ 4.9437689032396936e-05 8.4939484121898285e-06
+ 4.9437706492427394e-05 1.011650368403691e-05
+ 4.9437723952457858e-05 1.187564441966631e-05
+ 4.9437746268477828e-05 1.4320324258348367e-05
+ 4.9437768584497798e-05 1.6981891243476683e-05
+ 4.9437790900517768e-05 1.9856448881756975e-05
+ 4.9437819090217237e-05 2.3785542948120637e-05
+ 4.9437847279916713e-05 2.8038794641957824e-05
+ 4.9437875469616182e-05 3.2606525910010655e-05
+ 4.9437903659315652e-05 3.7478440563006991e-05
+ 4.9437931849015121e-05 4.2643660624918842e-05
+ 4.943796003871459e-05 4.809076449946518e-05
+ 4.9437988228414059e-05 5.3807826764352856e-05
+ 4.9438019414106468e-05 6.0432058501488789e-05
+ 4.9438050599798884e-05 6.7354141141263776e-05
+ 4.9438081785491292e-05 7.4556149339010216e-05
+ 4.9438112971183708e-05 8.2019674226669682e-05
+ 4.9438150418414334e-05 9.1300740447793598e-05
+ 4.9438187865644966e-05 0.00010089852928503813
+ 4.9438225312875599e-05 0.00011077933330704341
+ 4.9438270844195809e-05 0.00012312530862772575
+ 4.9438316375516019e-05 0.00013577798574481139
+ 4.9438361906836236e-05 0.00014867616552750304
+ 4.9438407438156445e-05 0.00016175929991125412
+ 4.9438441084028111e-05 0.00017151113091571656
+ 4.9438474729899776e-05 0.00018130797963939794
+ 4.9438508375771442e-05 0.00019112690048319055
+ 4.9438542021643107e-05 0.000200945563836072
+ 4.9438575667514773e-05 0.0002107423308290232
+ 4.9438609313386438e-05 0.00022049632214156449
+ 4.9438642959258104e-05 0.00023018748061678874
+ 4.9438676605129769e-05 0.00023979662749408118
+ 4.9438710251001435e-05 0.0002493055121224335
+ 4.9438736870668145e-05 0.00025674620625396695
+ 4.9438763490334855e-05 0.00026410519322842072
+ 4.9438790110001564e-05 0.00027137476557784006
+ 4.9438816729668281e-05 0.00027854762813939171
+ 4.9438843349334991e-05 0.00028561690431054267
+ 4.9438869969001701e-05 0.0002925761407342706
+ 4.9438896588668411e-05 0.0002994193104460534
+ 4.9438923208335121e-05 0.00030614081452042582
+ 4.9438949828001831e-05 0.00031273548226053464
+ 4.9438976447668541e-05 0.00031919856997935221
+ 4.943900306733525e-05 0.00032552575842600295
+ 4.943902968700196e-05 0.00033171314891500655
+ 4.9439056306668677e-05 0.00033775725822013397
+ 4.9439082926335387e-05 0.00034365501229800138
+ 4.9439109546002097e-05 0.00034940373890948994
+ 4.9439136165668807e-05 0.00035500115920957621
+ 4.9439162785335517e-05 0.00036044537837818884
+ 4.9439189405002227e-05 0.00036573487536628151
+ 4.9439216024668936e-05 0.00037086849183281574
+ 4.9439239404935226e-05 0.00037524816041470616
+ 4.9439262785201516e-05 0.00037950661982143294
+ 4.9439286165467806e-05 0.00038364373347733212
+ 4.9439309545734089e-05 0.00038765955240256639
+ 4.9439332926000379e-05 0.00039155430797307712
+ 4.9439356306266669e-05 0.00039532840450424615
+ 4.9439379686532959e-05 0.00039898241168751826
+ 4.9439403066799242e-05 0.00040251705690861332
+ 4.9439426447065532e-05 0.00040593321747524688
+ 4.9439449827331822e-05 0.0004092319127814815
+ 4.9439473207598112e-05 0.00041241429643495774
+ 4.9439496587864395e-05 0.00041548164837231091
+ 4.9439519968130685e-05 0.00041843536698707185
+ 4.9439543348396975e-05 0.00042127696129328835
+ 4.9439566728663265e-05 0.00042400804314699181
+ 4.9439590108929548e-05 0.00042663031954648096
+ 4.9439613489195838e-05 0.00042914558503120656
+ 4.9439636869462128e-05 0.00043155571419782471
+ 4.9439660249728417e-05 0.00043386265435075173
+ 4.9439683629994701e-05 0.0004360684183033
+ 4.943970701026099e-05 0.00043817507734421687
+ 4.9439735591237518e-05 0.00044061881915944171
+ 4.9439764172214038e-05 0.00044292160557832261
+ 4.9439792753190565e-05 0.00044508748731897325
+ 4.9439821334167086e-05 0.0004471205811035718
+ 4.9439849915143613e-05 0.00044902505354874717
+ 4.9439886199806211e-05 0.00045126415767136695
+ 4.9439925453373378e-05 0.00045347065125915753
+ 4.9439946977215264e-05 0.00045458914938144757
+ 4.94399736967147e-05 0.00045589098737442259
+ 4.9440000416214136e-05 0.00045710004038524538
+ 4.9440027135713572e-05 0.00045821970861944291
+ 4.9440053855213008e-05 0.00045925335947318648
+ 4.9440080574712444e-05 0.00046020432082601948
+ 4.944010729421188e-05 0.00046107587487371744
+ 4.9440134013711316e-05 0.00046187125249194449
+ 4.9440160733210752e-05 0.00046259362811953432
+ 4.9440187452710188e-05 0.00046324611514856153
+ 4.9440214172209624e-05 0.00046383176180687778
+ 4.9440240891709061e-05 0.00046435354751746608
+ 4.9440262548859607e-05 0.00046473161709406521
+ 4.9440284206010161e-05 0.00046507115570231151
+ 4.9440305863160714e-05 0.00046537364255429416
+ 4.9440327520311267e-05 0.00046564052306956875
+ 4.9440349177461821e-05 0.00046587320827894959
+ 4.9440370834612368e-05 0.00046607307433484731
+ 4.9440392491762921e-05 0.00046624146212347479
+ 4.9440414148913474e-05 0.00046637967697419719
+ 4.9440435806064021e-05 0.00046648898846127722
+ 4.9440457463214575e-05 0.00046657063029325929
+ 4.9440479120365128e-05 0.0004666258002852115
+ 4.9440496765399603e-05 0.00046665198683365781
+ 4.9440514410434077e-05 0.00046666198405394353
+ 4.9440532055468552e-05 0.00046665638716889121
+ 4.9440549700503026e-05 0.00046663577581361698
+ 4.9440567345537494e-05 0.00046660071413966874
+ 4.9440584990571969e-05 0.00046655175093608377
+ 4.9440602635606444e-05 0.00046648941976632619
+ 4.9440620280640918e-05 0.00046641423912008399
+ 4.9440637925675393e-05 0.00046632671257892689
+ 4.9440655570709867e-05 0.00046622732899484812
+ 4.9440673215744342e-05 0.00046611656268073646
+ 4.944069086077881e-05 0.00046599487361184948
+ 4.9440708505813284e-05 0.00046586270763738396
+ 4.9440726150847759e-05 0.00046572049670126538
+ 4.9440743795882234e-05 0.00046556865907130521
+ 4.9440761440916708e-05 0.00046540759957590188
+ 4.9440779085951183e-05 0.00046523770984748908
+ 4.9440796730985657e-05 0.00046505936857196291
+ 4.9440814376020132e-05 0.00046487294174334804
+ 4.9440832021054607e-05 0.00046467878292299136
+ 4.9440849666089075e-05 0.00046447723350260048
+ 4.9440867311123549e-05 0.00046426862297047311
+ 4.9440884956158024e-05 0.00046405326918029163
+ 4.9440902601192498e-05 0.00046383147862188659
+ 4.9440920246226973e-05 0.0004636035466933999
+ 4.9440937891261448e-05 0.00046336975797430831
+ 4.9440955536295922e-05 0.00046313038649879376
+ 4.944097318133039e-05 0.00046288569602897633
+ 4.9440990826364865e-05 0.00046263594032755121
+ 4.9441008471399339e-05 0.00046238136342939871
+ 4.9441026116433814e-05 0.00046212219991176166
+ 4.9441043761468289e-05 0.00046185867516261082
+ 4.9441061406502763e-05 0.00046159100564684353
+ 4.9441079051537238e-05 0.00046131939916998468
+ 4.9441096696571712e-05 0.00046104405513908457
+ 4.9441114341606187e-05 0.00046076516482052872
+ 4.9441131986640655e-05 0.00046048291159450004
+ 4.9441149631675129e-05 0.00046019747120585279
+ 4.9441167276709604e-05 0.00045990901201118061
+ 4.9441184921744079e-05 0.00045961769522188066
+ 4.9441202566778553e-05 0.00045932367514303494
+ 4.9441220211813028e-05 0.00045902709940794936
+ 4.9441237856847503e-05 0.00045872810920820898
+ 4.944125550188197e-05 0.00045842683951912496
+ 4.9441273146916445e-05 0.00045812341932046545
+ 4.944129079195092e-05 0.00045781797181237863
+ 4.9441308436985394e-05 0.00045751061462643097
+ 4.9441326082019869e-05 0.00045720146003169808
+ 4.9441343727054343e-05 0.00045689061513585962
+ 4.9441361372088818e-05 0.00045657818208126165
+ 4.9441379017123293e-05 0.00045626425823592343
+ 4.9441396662157767e-05 0.0004559489363794755
+ 4.9441414307192235e-05 0.0004556323048840281
+ 4.944143195222671e-05 0.00045531444788997848
+ 4.9441449597261184e-05 0.00045499544547677518
+ 4.9441467242295659e-05 0.00045467537382866608
+ 4.9441484887330134e-05 0.00045435430539546583
+ 4.9441502532364608e-05 0.00045403230904838535
+ 4.9441520177399083e-05 0.00045370945023097327
+ 4.9441537822433551e-05 0.00045338579110522598
+ 4.9441555467468025e-05 0.00045306139069292836
+ 4.94415731125025e-05 0.00045273630501229328
+ 4.9441590757536974e-05 0.00045241058720997258
+ 4.9441608402571449e-05 0.00045208428768851668
+ 4.9441626047605924e-05 0.00045175745422936376
+ 4.9441643692640398e-05 0.00045143013211144381
+ 4.9441661337674873e-05 0.00045110236422548483
+ 4.9441682620107578e-05 0.00045070649383213837
+ 4.9441702745281675e-05 0.00045033166770387813
+ 4.9441722870455778e-05 0.00044995642757493547
+ 4.9441742995629881e-05 0.00044958082330929242
+ 4.9441763120803985e-05 0.00044920490166811688
+ 4.9441783245978088e-05 0.00044882870648050557
+ 4.9441803371152192e-05 0.00044845227880637947
+ 4.9441823496326295e-05 0.00044807565709178331
+ 4.9441843621500392e-05 0.00044769887731683952
+ 4.9441863746674495e-05 0.00044732197313660687
+ 4.9441888110746128e-05 0.00044686556133260454
+ 4.9441912474817754e-05 0.00044640906499999366
+ 4.944193683888938e-05 0.00044595253182312878
+ 4.9441961202961005e-05 0.00044549600565976083
+ 4.9441985567032638e-05 0.00044503952681690417
+ 4.9442009931104264e-05 0.00044458313230938829
+ 4.944203429517589e-05 0.00044412685610195336
+ 4.9442058659247515e-05 0.00044367072933572632
+ 4.9442083023319148e-05 0.00044321478053989036
+ 4.9442107387390774e-05 0.00044275903582933563
+ 4.9442136719683567e-05 0.00044221066197735565
+ 4.944216605197636e-05 0.00044166265618977781
+ 4.944219538426916e-05 0.00044111505229614979
+ 4.9442224716561953e-05 0.000440567880571222
+ 4.9442254048854746e-05 0.0004400211680723513
+ 4.9442283381147539e-05 0.0004394749389480193
+ 4.9442312713440339e-05 0.0004389292147195882
+ 4.9442342045733132e-05 0.00043838401453830063
+ 4.9442377848029197e-05 0.00043771929099924211
+ 4.9442412335454631e-05 0.00043707976746529866
+ 4.9442446822880059e-05 0.00043644103787377733
+ 4.9442481310305493e-05 0.00043580312030283216
+ 4.9442515797730928e-05 0.00043516603032572377
+ 4.9442557828321206e-05 0.00043439073279079223
+ 4.9442599858911484e-05 0.00043361670459320404
+ 4.9442641889501762e-05 0.00043284396248195208
+ 4.9442683920092046e-05 0.00043207252012209858
+ 4.9442725950682324e-05 0.00043130238856505936
+ 4.9442777518503423e-05 0.00043035930871672526
+ 4.9442828186666482e-05 0.00042943462880424378
+ 4.944287885482954e-05 0.00042851188736760037
+ 4.9442929522992599e-05 0.00042759109050169295
+ 4.9442993215143463e-05 0.00042643637215815307
+ 4.9443056907294328e-05 0.0004252847370223043
+ 4.9443120599445192e-05 0.00042413618616643506
+ 4.9443198945610712e-05 0.00042272760989246018
+ 4.944327865764969e-05 0.00042129925771114857
+ 4.9443358369688668e-05 0.00041987571829712041
+ 4.9443461292370764e-05 0.00041804477075287836
+ 4.944356950890982e-05 0.00041612824858809757
+ 4.9443701914804438e-05 0.00041379527174881443
+ 4.944384706503018e-05 0.00041125276249577136
+ 4.9444034315235681e-05 0.00040799587225246868
+ 4.9444255865010422e-05 0.00040417569543334638
+ 4.9444554034092499e-05 0.00039909077578923559
+ 4.9444998769870888e-05 0.00039162496079868337
+ 4.944580500398899e-05 0.00037844492463713218
+ 4.9446711764368311e-05 0.00036415075183872955
+ 4.9447737475686438e-05 0.00034863113834200367
+ 4.9448801143402342e-05 0.00033323544260725887
+ 4.9449944764949548e-05 0.00031744009309453978
+ 4.9452231646278907e-05 0.00028806442739914481
+ 4.9454182681216655e-05 0.00026516169925578173
+ 4.9456291228517249e-05 0.00024245284579639417
+ 4.9458581467436158e-05 0.00021998507757767748
+ 4.9460926666850022e-05 0.00019913410083615226
+ 4.9463271866263887e-05 0.00018025945489984468
+ 4.9465590537179631e-05 0.00016335772611693962
+ 4.9468474569484277e-05 0.00014452917890563918
+ 4.947135860178893e-05 0.00012787080313841811
+ 4.9474242634093577e-05 0.00011313246567173927
+ 4.9477126666398223e-05 0.00010009286360866482
+ 4.9480010698702877e-05 8.8556201336288662e-05
+ 4.9482894731007523e-05 7.8349250567829904e-05
+ 4.948577876331217e-05 6.9318749243295542e-05
+ 4.9489342797663594e-05 5.9583601550415324e-05
+ 4.9492906832015011e-05 5.12156620124964e-05
+ 4.9496470866366434e-05 4.4022919356413453e-05
+ 4.9500034900717851e-05 3.7840328450154061e-05
+ 4.9503598935069269e-05 3.2526023165760874e-05
+ 4.9507899961127362e-05 2.7096692323683933e-05
+ 4.9512200987185448e-05 2.2573641128908005e-05
+ 4.9516502013243534e-05 1.8805590756409222e-05
+ 4.9520803039301628e-05 1.5666514280396347e-05
+ 4.9525104065359714e-05 1.3051421554109079e-05
+ 4.9530502505986984e-05 1.0377818664489998e-05
+ 4.9535900946614248e-05 8.251909089995107e-06
+ 4.9541299387241512e-05 6.5614966739560858e-06
+ 4.9546697827868782e-05 5.2173688876777125e-06
+ 4.955346824765747e-05 3.9138135354349389e-06
+ 4.9560238667446158e-05 2.9359531577328348e-06
+ 4.9567009087234845e-05 2.2024124497970242e-06
+ 4.9575385304343958e-05 1.5432541258101081e-06
+ 4.958376152145307e-05 1.081378721967762e-06
+ 4.9592137738562183e-05 7.5774041132707628e-07
+ 4.9603043385488655e-05 4.7689837631713853e-07
+ 4.9613949032415128e-05 3.0015113649486665e-07
+ 4.9626156063665126e-05 1.7876217937191045e-07
+ 4.9638363094915132e-05 1.0647330757921957e-07
+ 4.965057012616513e-05 6.3424252544034479e-08
+ 4.9662777157415129e-05 3.7787934734000867e-08
+ 4.9674984188665135e-05 2.2521155841269887e-08
+ 4.9687191219915133e-05 1.3429588576020001e-08
+ 4.9699398251165132e-05 8.015449872567151e-09
+ 4.9711605282415131e-05 4.7912734917149069e-09
+ 4.9723812313665129e-05 2.871251600636248e-09
+ 4.9736019344915135e-05 1.7278727196949598e-09
+ 4.9748226376165133e-05 1.0469960699243559e-09
+ 4.9760433407415132e-05 6.4154623608527275e-10
+ 4.9772640438665137e-05 4.0011708092908531e-10
+ 4.9784847469915136e-05 2.563646256420896e-10
+ 4.9797054501165135e-05 1.7078006330613652e-10
+ 4.9809261532415133e-05 1.1983532309874618e-10
+ 4.9821468563665132e-05 8.9519095817165878e-11
+ 4.9833675594915137e-05 7.14874426319846e-11
+ 4.9845882626165136e-05 6.0771426293748156e-11
+ 4.9858089657415135e-05 5.4411972164600532e-11
+ 4.987029668866514e-05 5.0646908151112081e-11
+ 4.9882503719915139e-05 4.8426835103990855e-11
+ 4.9894710751165137e-05 4.7126820532761082e-11
+ 4.9906917782415136e-05 4.6374708016315066e-11
+ 4.9919124813665135e-05 4.594887297816922e-11
+ 4.993133184491514e-05 4.5717334758833713e-11
+ 4.9943538876165139e-05 4.5601496954841019e-11
+ 4.9955745907415138e-05 4.5554554261028926e-11
+ 4.9967952938665143e-05 4.5548633436145208e-11
+ 4.9980159969915142e-05 4.5567135561437956e-11
+ 4.999236700116514e-05 4.5600175741221697e-11
+ 5.0000000000000002e-05 4.5624752229059989e-11
+ 5.0012207031250001e-05 4.5669966819297461e-11
+ 5.00244140625e-05 4.5718898557805248e-11
+ 5.0036621093750005e-05 4.5770037749483043e-11
+ 5.0048828125000004e-05 4.5822485350610839e-11
+ 5.0061035156250002e-05 4.5875705969269391e-11
+ 5.0073242187500001e-05 4.5929380773488921e-11
+ 5.008544921875e-05 4.5983319895906806e-11
+ 5.0097656250000005e-05 4.6037410269464089e-11
+ 5.0109863281250004e-05 4.6091584562801975e-11
+ 5.0122070312500003e-05 4.6145802680837535e-11
+ 5.0134277343750001e-05 4.6200040748086769e-11
+ 5.0146484375e-05 4.6254284548072891e-11
+ 5.0158691406250005e-05 4.6308525616398256e-11
+ 5.0170898437500004e-05 4.6362758914111761e-11
+ 5.0183105468750003e-05 4.641698144216514e-11
+ 5.0195312500000001e-05 4.6471191416301583e-11
+ 5.020751953125e-05 4.6525387775689795e-11
+ 5.0219726562500005e-05 4.6579569890308451e-11
+ 5.0231933593750004e-05 4.663373738668933e-11
+ 5.0244140625000003e-05 4.6687890044144897e-11
+ 5.0256347656250001e-05 4.6742027732970226e-11
+ 5.02685546875e-05 4.6796150377641402e-11
+ 5.0280761718750005e-05 4.6850257934899579e-11
+ 5.0292968750000004e-05 4.690435038069982e-11
+ 5.0305175781250003e-05 4.695842770243876e-11
+ 5.0317382812500001e-05 4.7012489894326265e-11
+ 5.032958984375e-05 4.7066536954629075e-11
+ 5.0341796875000005e-05 4.7120568884029375e-11
+ 5.0354003906250004e-05 4.7174585684647293e-11
+ 5.0366210937500003e-05 4.7228587359458799e-11
+ 5.0378417968750001e-05 4.728257391194907e-11
+ 5.0390625e-05 4.7336545345906017e-11
+ 5.0402832031250005e-05 4.7390501665297362e-11
+ 5.0415039062500004e-05 4.7444442874197415e-11
+ 5.0427246093750003e-05 4.7498368976743532e-11
+ 5.0439453125000001e-05 4.7552279977110043e-11
+ 5.045166015625e-05 4.7606175879492929e-11
+ 5.0463867187499999e-05 4.76600566881005e-11
+ 5.0476074218750004e-05 4.771392240714795e-11
+ 5.0488281250000003e-05 4.7767773040854128e-11
+ 5.0500488281250001e-05 4.7821608593439534e-11
+ 5.05126953125e-05 4.7875429069125182e-11
+ 5.0524902343750006e-05 4.7929234472131972e-11
+ 5.0537109375000004e-05 4.7983024806680162e-11
+ 5.0549316406250003e-05 4.8036800076989225e-11
+ 5.0561523437500002e-05 4.8090560287277661e-11
+ 5.057373046875e-05 4.81443054417629e-11
+ 5.0585937500000006e-05 4.8198035544661283e-11
+ 5.0598144531250004e-05 4.8251750600188019e-11
+ 5.0610351562500003e-05 4.8305450612557161e-11
+ 5.0622558593750002e-05 4.835913558598157e-11
+ 5.0634765625e-05 4.8412805524672993e-11
+ 5.0646972656250006e-05 4.846646043284194e-11
+ 5.0659179687500004e-05 4.8520100314697792e-11
+ 5.0671386718750003e-05 4.8573725174448732e-11
+ 5.0683593750000002e-05 4.8627335016301782e-11
+ 5.069580078125e-05 4.8680929844462761e-11
+ 5.0708007812500006e-05 4.8734509663136332e-11
+ 5.0720214843750004e-05 4.8788074476525962e-11
+ 5.0732421875000003e-05 4.8841624288833967e-11
+ 5.0744628906250002e-05 4.8895159104261467e-11
+ 5.07568359375e-05 4.894867892700839e-11
+ 5.0769042968750006e-05 4.9002183761273549e-11
+ 5.0781250000000004e-05 4.905567361125451e-11
+ 5.0793457031250003e-05 4.9109148481147716e-11
+ 5.0805664062500002e-05 4.9162608375148381e-11
+ 5.081787109375e-05 4.9216053297450589e-11
+ 5.0830078125000006e-05 4.9269483252247235e-11
+ 5.0842285156250004e-05 4.932289824373005e-11
+ 5.0854492187500003e-05 4.9376298276089576e-11
+ 5.0866699218750002e-05 4.9429683353515166e-11
+ 5.087890625e-05 4.9483053480195042e-11
+ 5.0891113281250006e-05 4.9536408660316226e-11
+ 5.0903320312500005e-05 4.9589748898064572e-11
+ 5.0915527343750003e-05 4.9643074197624777e-11
+ 5.0927734375000002e-05 4.9696384563180337e-11
+ 5.0939941406250001e-05 4.9749679998913594e-11
+ 5.0952148437500006e-05 4.980296050900572e-11
+ 5.0964355468750005e-05 4.9856226097636712e-11
+ 5.0976562500000003e-05 4.99094767689854e-11
+ 5.0988769531250002e-05 4.9962712527229435e-11
+ 5.1000976562500001e-05 5.0015933376545304e-11
+ 5.1013183593750006e-05 5.0069139321108297e-11
+ 5.1025390625000005e-05 5.0122330365092602e-11
+ 5.1037597656250003e-05 5.0175506512671175e-11
+ 5.1049804687500002e-05 5.0228667768015851e-11
+ 5.1062011718750001e-05 5.0281814135297241e-11
+ 5.1074218749999999e-05 5.0334945618684835e-11
+ 5.1086425781250005e-05 5.0388062222346936e-11
+ 5.1098632812500003e-05 5.0441163950450669e-11
+ 5.1110839843750002e-05 5.0494250807162017e-11
+ 5.1123046875000001e-05 5.0547322796645784e-11
+ 5.1135253906249999e-05 5.060037992306559e-11
+ 5.1147460937500005e-05 5.0653422190583924e-11
+ 5.1159667968750003e-05 5.0706449603362099e-11
+ 5.1171875000000002e-05 5.0759462165560252e-11
+ 5.1184082031250001e-05 5.0812459881337356e-11
+ 5.1196289062499999e-05 5.086544275485121e-11
+ 5.1208496093750005e-05 5.0918410790258479e-11
+ 5.1220703125000003e-05 5.0971363991714641e-11
+ 5.1232910156250002e-05 5.1024302363374004e-11
+ 5.1245117187500001e-05 5.1077225909389738e-11
+ 5.1257324218749999e-05 5.1130134633913832e-11
+ 5.1269531250000005e-05 5.1183028541097097e-11
+ 5.1281738281250004e-05 5.123590763508922e-11
+ 5.1293945312500002e-05 5.1288771920038706e-11
+ 5.1306152343750001e-05 5.1341621400092889e-11
+ 5.1318359375e-05 5.1394456079397949e-11
+ 5.1330566406249998e-05 5.1447275962098919e-11
+ 5.1342773437500004e-05 5.1500081052339658e-11
+ 5.1354980468750002e-05 5.1552871354262853e-11
+ 5.1367187500000001e-05 5.1605646872010057e-11
+ 5.137939453125e-05 5.1658407609721638e-11
+ 5.1391601562499998e-05 5.171115357153682e-11
+ 5.1403808593750004e-05 5.1763884761593666e-11
+ 5.1416015625000002e-05 5.1816601184029079e-11
+ 5.1428222656250001e-05 5.1869302842978788e-11
+ 5.14404296875e-05 5.1921989742577379e-11
+ 5.1452636718749998e-05 5.1974661886958285e-11
+ 5.1464843749999997e-05 5.2027319280253771e-11
+ 5.1477050781250002e-05 5.2079961926594946e-11
+ 5.1489257812500001e-05 5.2132589830111786e-11
+ 5.150146484375e-05 5.2185202994933079e-11
+ 5.1513671874999998e-05 5.2237801425186463e-11
+ 5.1525878906249997e-05 5.2290385124998426e-11
+ 5.1538085937500002e-05 5.2342954098494298e-11
+ 5.1550292968750001e-05 5.2395508349798247e-11
+ 5.15625e-05 5.2448047883033309e-11
+ 5.1574707031249998e-05 5.2500572702321331e-11
+ 5.1586914062499997e-05 5.2553082811783024e-11
+ 5.1599121093750002e-05 5.260557821553798e-11
+ 5.1611328125000001e-05 5.265805891770455e-11
+ 5.162353515625e-05 5.2710524922400013e-11
+ 5.1635742187499998e-05 5.2762976233740464e-11
+ 5.1647949218749997e-05 5.281541285584085e-11
+ 5.1660156250000003e-05 5.2867834792814952e-11
+ 5.1672363281250001e-05 5.2920242048775429e-11
+ 5.16845703125e-05 5.297263462783375e-11
+ 5.1696777343749998e-05 5.3025012534100265e-11
+ 5.1708984374999997e-05 5.3077375771684144e-11
+ 5.1721191406249996e-05 5.3129724344693429e-11
+ 5.1733398437500001e-05 5.3182058257235008e-11
+ 5.174560546875e-05 5.3234377513414598e-11
+ 5.1757812499999999e-05 5.3286682117336819e-11
+ 5.1770019531249997e-05 5.3338972073105086e-11
+ 5.1782226562499996e-05 5.339124738482168e-11
+ 5.1794433593750001e-05 5.3443508056587737e-11
+ 5.1806640625e-05 5.349575409250326e-11
+ 5.1818847656249999e-05 5.3547985496667078e-11
+ 5.1831054687499997e-05 5.3600202273176877e-11
+ 5.1843261718749996e-05 5.3652404426129203e-11
+ 5.1855468749999995e-05 5.3704591959619454e-11
+ 5.186767578125e-05 5.3756764877741888e-11
+ 5.1879882812499999e-05 5.3808923184589598e-11
+ 5.1892089843749997e-05 5.3861066884254534e-11
+ 5.1904296874999996e-05 5.3913195980827531e-11
+ 5.1916503906249995e-05 5.3965310478398236e-11
+ 5.19287109375e-05 5.4017410381055188e-11
+ 5.1940917968749999e-05 5.4069495692885746e-11
+ 5.1953124999999997e-05 5.4121566417976143e-11
+ 5.1965332031249996e-05 5.4173622560411455e-11
+ 5.1977539062499995e-05 5.4225664124275648e-11
+ 5.198974609375e-05 5.4277691113651499e-11
+ 5.2001953124999999e-05 5.4329703532620677e-11
+ 5.2014160156249997e-05 5.4381701385263697e-11
+ 5.2026367187499996e-05 5.4433684675659917e-11
+ 5.2038574218749995e-05 5.4485653407887576e-11
+ 5.205078125e-05 5.4537607586023745e-11
+ 5.2062988281249999e-05 5.4589547214144361e-11
+ 5.2075195312499997e-05 5.4641472296324253e-11
+ 5.2087402343749996e-05 5.4693382836637059e-11
+ 5.2099609374999995e-05 5.4745278839155299e-11
+ 5.2111816406249993e-05 5.4797160307950356e-11
+ 5.2124023437499999e-05 5.4849027247092475e-11
+ 5.2136230468749998e-05 5.4900879660650734e-11
+ 5.2148437499999996e-05 5.4952717552693121e-11
+ 5.2160644531249995e-05 5.5004540927286431e-11
+ 5.2172851562499993e-05 5.5055228596414379e-11
+ 5.2185058593749999e-05 5.510627065877697e-11
+ 5.2197265624999998e-05 5.5158092921228189e-11
+ 5.2209472656249996e-05 5.5210849104087091e-11
+ 5.2221679687499995e-05 5.5264521350196526e-11
+ 5.2233886718749994e-05 5.5318219478297029e-11
+ 5.2239990234374993e-05 5.5343709041866146e-11
+ 5.2246093749999992e-05 5.5365175813779936e-11
+ 5.2249145507812499e-05 5.537183500008943e-11
+ 5.2252197265624998e-05 5.5371668509114686e-11
+ 5.2255249023437498e-05 5.5354771851498252e-11
+ 5.225660679077409e-05 5.5334751403020664e-11
+ 5.2256998216660863e-05 5.5326313558461538e-11
+ 5.2257389642547636e-05 5.5316205768572161e-11
+ 5.2258368207264578e-05 5.5280832763072969e-11
+ 5.2259409502908188e-05 5.5216998316807767e-11
+ 5.2259970598735324e-05 5.5162661637241072e-11
+ 5.226033962929837e-05 5.5114439869388932e-11
+ 5.2261110323815845e-05 5.4960015216721681e-11
+ 5.2261741481233848e-05 5.4732817211499076e-11
+ 5.226211308400901e-05 5.4516300482441227e-11
+ 5.2262434193795794e-05 5.42419953316085e-11
+ 5.226264709792541e-05 5.400886072195258e-11
+ 5.2262860002055032e-05 5.3774257755821461e-11
+ 5.2264989043351246e-05 5.1549852354822979e-11
+ 5.2277196074601245e-05 4.2855387214314058e-11
+ 5.2289403105851244e-05 4.053247294954365e-11
+ 5.2301610137101249e-05 4.3931039996784842e-11
+ 5.2313817168351248e-05 5.2388572167819672e-11
+ 5.2326024199601246e-05 6.5140225940715896e-11
+ 5.2338231230851245e-05 8.1286621114128428e-11
+ 5.2350438262101244e-05 9.9800201152591339e-11
+ 5.2362645293351249e-05 1.1955731974057662e-10
+ 5.2374852324601248e-05 1.3938677731239894e-10
+ 5.2387059355851246e-05 1.581275910662053e-10
+ 5.2399266387101245e-05 1.7469004130247602e-10
+ 5.2411473418351244e-05 1.881149150311095e-10
+ 5.2423680449601242e-05 1.9762660690176225e-10
+ 5.2435887480851248e-05 2.026764694324815e-10
+ 5.2448094512101246e-05 2.0297359093770258e-10
+ 5.2460301543351245e-05 1.9850103705845601e-10
+ 5.2472508574601244e-05 1.8951650785639057e-10
+ 5.2484715605851242e-05 1.7653730627935789e-10
+ 5.2496922637101248e-05 1.6031044421422816e-10
+ 5.2509129668351247e-05 1.4176958358946107e-10
+ 5.2521336699601245e-05 1.2198127662112241e-10
+ 5.2533543730851244e-05 1.0208359001036545e-10
+ 5.2545750762101242e-05 8.3220638681385549e-11
+ 5.2557957793351241e-05 6.6476791169901555e-11
+ 5.2561009551163748e-05 6.2738216402259133e-11
+ 5.2561314726944993e-05 6.2375524734021021e-11
+ 5.2562077666398123e-05 6.1477937832984702e-11
+ 5.2562459136124684e-05 6.1034090082773124e-11
+ 5.2562482977982589e-05 6.1006459924724939e-11
+ 5.2562487746354172e-05 6.1000935454857881e-11
+ 5.2562497283097339e-05 6.0989888077255491e-11
+ 5.2562498046036788e-05 6.0989004377034889e-11
+ 5.2562499571915698e-05 6.0987237016591268e-11
+ 5.2562499693986007e-05 6.0987095630059761e-11
+ 5.2562499938126632e-05 6.0986812858020706e-11
+ 5.2562499957657884e-05 6.0986790236316644e-11
+ 5.2562499996720387e-05 6.098674499293473e-11
+ 5.2562500074845387e-05 6.2330481534674083e-11
+ 5.2562500152970386e-05 6.6608198187672893e-11
+ 5.2562500934220383e-05 2.7075208822833839e-10
+ 5.2562508051845978e-05 1.5641542586395462e-08
+ 5.2562515169471572e-05 5.5354276368357439e-08
+ 5.2562522287097173e-05 1.1939590331347595e-07
+ 5.2562529404722767e-05 2.0774988808958391e-07
+ 5.2562536522348361e-05 3.2039621340029153e-07
+ 5.2562543639973956e-05 4.5731138406416947e-07
+ 5.2562550757599557e-05 6.1846843192454422e-07
+ 5.2562557875225151e-05 8.0383692158836119e-07
+ 5.2562564992850745e-05 1.0133829569922963e-06
+ 5.2562572110476346e-05 1.2470691887940203e-06
+ 5.2562579228101941e-05 1.5048548225862434e-06
+ 5.2562587807568573e-05 1.8475543476526228e-06
+ 5.2562596387035205e-05 2.2251205386231599e-06
+ 5.2562604966501837e-05 2.637462112110794e-06
+ 5.2562613545968469e-05 3.0844806091734263e-06
+ 5.2562622125435101e-05 3.5660704276185103e-06
+ 5.2562630704901733e-05 4.0821188567621002e-06
+ 5.2562639284368365e-05 4.6325061146258863e-06
+ 5.2562647863834997e-05 5.2171053875545835e-06
+ 5.256265818077025e-05 5.965211217502911e-06
+ 5.2562668497705504e-05 6.7623492313414161e-06
+ 5.2562678814640765e-05 7.6082590651614992e-06
+ 5.2562689131576018e-05 8.5026660760363497e-06
+ 5.2562699448511272e-05 9.4452814742207388e-06
+ 5.2562709765446533e-05 1.0435802462230257e-05
+ 5.2562720082381786e-05 1.147391238070454e-05
+ 5.256273039931704e-05 1.25592808609545e-05
+ 5.2562742902012262e-05 1.393744004677843e-05
+ 5.2562755404707478e-05 1.538385928477854e-05
+ 5.25627679074027e-05 1.6897871760843825e-05
+ 5.2562780410097916e-05 1.8478782715895571e-05
+ 5.2562792912793139e-05 2.0125869935940648e-05
+ 5.2562805415488354e-05 2.1838384260846487e-05
+ 5.2562817918183577e-05 2.3615550111329756e-05
+ 5.2562830420878792e-05 2.5456566033633845e-05
+ 5.2562845592253874e-05 2.7775100207116592e-05
+ 5.2562860763628955e-05 3.0184906039223483e-05
+ 5.2562875935004037e-05 3.2684405463249104e-05
+ 5.2562891106379118e-05 3.5271969973378807e-05
+ 5.2562906277754193e-05 3.7945922288216153e-05
+ 5.2562921449129275e-05 4.0704538058428326e-05
+ 5.2562936620504356e-05 4.3546047616054653e-05
+ 5.2562954860519561e-05 4.7069469432613542e-05
+ 5.2562973100534772e-05 5.0706855826657106e-05
+ 5.2562991340549976e-05 5.4454893918205257e-05
+ 5.2563009580565187e-05 5.8310193146384224e-05
+ 5.2563027820580391e-05 6.2269290123695639e-05
+ 5.2563046060595596e-05 6.6328653564053143e-05
+ 5.2563068199865844e-05 7.1385338233594827e-05
+ 5.2563090339136093e-05 7.6577901326810804e-05
+ 5.2563112478406348e-05 8.189969012601315e-05
+ 5.2563134617676596e-05 8.7343953274172687e-05
+ 5.2563161293011321e-05 9.4056657818521804e-05
+ 5.2563187873095808e-05 0.00010090035482762358
+ 5.2563214453180296e-05 0.00010788664307091889
+ 5.2563248688484341e-05 0.00011707548567577072
+ 5.2563282923788386e-05 0.00012645461865043843
+ 5.2563315356127047e-05 0.00013549167951766453
+ 5.2563347788465715e-05 0.00014465398332574899
+ 5.2563380220804377e-05 0.00015391958689944246
+ 5.2563412653143038e-05 0.00016326679416820027
+ 5.2563445085481706e-05 0.00017267423453976973
+ 5.2563477517820368e-05 0.00018212093762926101
+ 5.2563509950159029e-05 0.00019158640400330904
+ 5.2563542382497698e-05 0.00020105067163597072
+ 5.256356958499815e-05 0.00020897371829601134
+ 5.2563596787498601e-05 0.00021687121736840308
+ 5.2563623989999053e-05 0.0002247324443841368
+ 5.2563651192499505e-05 0.00023254704172942061
+ 5.2563678394999964e-05 0.00024030503688061725
+ 5.2563705597500415e-05 0.00024799685880477063
+ 5.2563732800000867e-05 0.00025561335251051022
+ 5.2563760002501326e-05 0.00026314579174345146
+ 5.2563787205001778e-05 0.00027058588982929906
+ 5.256381440750223e-05 0.00027792580867665878
+ 5.2563841610002681e-05 0.0002851581659600263
+ 5.2563868812503133e-05 0.00029227604051150784
+ 5.2563896015003592e-05 0.00029927297595749906
+ 5.2563923217504044e-05 0.00030614298264376868
+ 5.2563950420004496e-05 0.00031288053789913813
+ 5.2563977622504954e-05 0.00031948058469418605
+ 5.2564004825005406e-05 0.00032593852875712024
+ 5.2564032027505858e-05 0.00033225023421413059
+ 5.256405923000631e-05 0.00033841201782615327
+ 5.2564086432506762e-05 0.0003444206418985982
+ 5.2564115300883499e-05 0.00035062659892727544
+ 5.2564144169260237e-05 0.0003566540934654631
+ 5.2564173037636967e-05 0.00036250083298786399
+ 5.2564201906013705e-05 0.00036816503744223664
+ 5.2564230774390442e-05 0.00037364542226806104
+ 5.2564259642767173e-05 0.00037894118026981165
+ 5.256428851114391e-05 0.00038405196247931109
+ 5.2564317379520648e-05 0.000388977858140999
+ 5.2564346247897379e-05 0.00039371937395252178
+ 5.2564381135166688e-05 0.0003992047348763101
+ 5.256441602243599e-05 0.00040442447430172904
+ 5.2564449985506051e-05 0.00040925368585940502
+ 5.2564483948576112e-05 0.00041383750344981278
+ 5.256451791164618e-05 0.00041817993390062743
+ 5.2564551874716241e-05 0.00042228549548244641
+ 5.2564585837786302e-05 0.00042615916749456922
+ 5.2564627381082822e-05 0.0004305900119691504
+ 5.2564668924379335e-05 0.00043469258490726371
+ 5.2564710467675848e-05 0.0004384781612780042
+ 5.2564752010972367e-05 0.00044195857402361564
+ 5.2564802322523103e-05 0.00044578261210212054
+ 5.2564853125173635e-05 0.00044923093231022854
+ 5.2564903927824173e-05 0.00045228765276156626
+ 5.2564971607266248e-05 0.00045579239535176001
+ 5.2565039286708322e-05 0.00045870005395461338
+ 5.2565091919396569e-05 0.00046058369469111949
+ 5.2565144552084816e-05 0.00046216451732223918
+ 5.2565197184773056e-05 0.00046346681282214352
+ 5.2565249817461303e-05 0.00046451393123718372
+ 5.2565297809929104e-05 0.00046526519657479943
+ 5.2565345802396906e-05 0.00046583893527304737
+ 5.2565393794864714e-05 0.00046625041073407677
+ 5.2565441787332515e-05 0.00046651403875466578
+ 5.2565489779800317e-05 0.0004666433740508164
+ 5.2565537261554868e-05 0.00046665162291553914
+ 5.2565584743309412e-05 0.000466552308242554
+ 5.2565632225063963e-05 0.00046635608374731292
+ 5.2565679706818515e-05 0.00046607281339991539
+ 5.2565727188573059e-05 0.00046571159614456351
+ 5.256577467032761e-05 0.00046528079492301239
+ 5.2565824358583365e-05 0.00046476378468933915
+ 5.2565874046839126e-05 0.00046418694952370777
+ 5.2565923735094881e-05 0.00046355752837163748
+ 5.2565973423350635e-05 0.00046288205221083837
+ 5.2566023111606397e-05 0.00046216639229460844
+ 5.2566072799862151e-05 0.00046141580830294233
+ 5.2566127951386077e-05 0.00046054748419045071
+ 5.2566183102910002e-05 0.00045964758393211987
+ 5.2566238254433927e-05 0.00045872107390199996
+ 5.2566293405957853e-05 0.00045777228079549998
+ 5.2566348557481785e-05 0.00045680495887963081
+ 5.2566411640520544e-05 0.000455679953428722
+ 5.2566474723559302e-05 0.00045453907391423655
+ 5.2566537806598061e-05 0.0004533857886546739
+ 5.256660088963682e-05 0.00045222299034028662
+ 5.2566674140146427e-05 0.00045086399130210022
+ 5.2566747390656035e-05 0.00044949844535668453
+ 5.2566820641165643e-05 0.00044812878579885432
+ 5.2566905619421588e-05 0.00044653719761490697
+ 5.2566990597677526e-05 0.0004449449586312652
+ 5.2567093836844789e-05 0.00044301214871122791
+ 5.2567198171769413e-05 0.00044106269601017851
+ 5.2567302506694045e-05 0.00043911870626636078
+ 5.2567426664469163e-05 0.00043681393387383496
+ 5.2567550822244289e-05 0.00043451951813961668
+ 5.2567705800806533e-05 0.00043167106196547318
+ 5.2567884937131786e-05 0.00042840086834201771
+ 5.2568098556602389e-05 0.00042453293757745131
+ 5.2568364485722957e-05 0.00041976628303681877
+ 5.2568717982712206e-05 0.00041351261779238365
+ 5.2569242097564148e-05 0.00040441158298440465
+ 5.2570136340120474e-05 0.00038934346113524376
+ 5.257213280718504e-05 0.00035769765454050228
+ 5.2573988816858017e-05 0.00033058981538904275
+ 5.2576421668443082e-05 0.00029814348467284587
+ 5.2578854520028146e-05 0.00026888165874455468
+ 5.258128737161321e-05 0.00024249178888257299
+ 5.2583720223198275e-05 0.00021869200206866874
+ 5.2586153074783332e-05 0.00019722808975099272
+ 5.2588585926368397e-05 0.00017787079297825666
+ 5.2591018777953461e-05 0.00016041335425741158
+ 5.2593451629538525e-05 0.0001446693086575522
+ 5.2595767705239779e-05 0.00013111903917235234
+ 5.2598819440406718e-05 0.00011518312547724692
+ 5.2601871175573663e-05 0.00010118403045864018
+ 5.2604922910740601e-05 8.8886357108097517e-05
+ 5.2607974645907539e-05 7.8083318131395906e-05
+ 5.2611026381074478e-05 6.8593258842393536e-05
+ 5.2614078116241416e-05 6.025660181923537e-05
+ 5.2617773618773603e-05 5.1505809187250614e-05
+ 5.2621134288610908e-05 4.4656271026532631e-05
+ 5.262449495844822e-05 3.8717628008379948e-05
+ 5.2628620731690283e-05 3.2495702272495222e-05
+ 5.263274650493234e-05 2.7273646663031209e-05
+ 5.2636872278174396e-05 2.2890780980831938e-05
+ 5.2640998051416459e-05 1.9212246512347876e-05
+ 5.2645123824658516e-05 1.6124856494297113e-05
+ 5.2650251138437099e-05 1.2970141364146993e-05
+ 5.2655378452215682e-05 1.0432633172092827e-05
+ 5.2660505765994265e-05 8.3915781182774641e-06
+ 5.2665633079772848e-05 6.7498471833962207e-06
+ 5.2671995979825155e-05 5.1518189724579756e-06
+ 5.2678358879877462e-05 3.9321378049054371e-06
+ 5.2684721779929769e-05 3.0012267671564931e-06
+ 5.2692497256254513e-05 2.15737185496337e-06
+ 5.2700272732579251e-05 1.5508026051292012e-06
+ 5.2708048208903995e-05 1.1147960586695601e-06
+ 5.2717983441936072e-05 7.3118840550782522e-07
+ 5.2727918674968141e-05 4.7961075194826108e-07
+ 5.2740125706218147e-05 2.8571159964289929e-07
+ 5.2752332737468145e-05 1.7024209705967684e-07
+ 5.2764539768718144e-05 1.0147848625806179e-07
+ 5.2776746799968142e-05 6.0528851952355526e-08
+ 5.2788953831218141e-05 3.6142806128821739e-08
+ 5.2801160862468147e-05 2.1620593980565466e-08
+ 5.2813367893718145e-05 1.2972424953734794e-08
+ 5.2825574924968144e-05 7.8223266739669589e-09
+ 5.2837781956218143e-05 4.7553755500354248e-09
+ 5.2849988987468141e-05 2.9289656540459339e-09
+ 5.286219601871814e-05 1.8413143839828223e-09
+ 5.2874403049968145e-05 1.1936037658401295e-09
+ 5.2886610081218144e-05 8.078836241498485e-10
+ 5.2898817112468143e-05 5.7818218790680653e-10
+ 5.2911024143718141e-05 4.4139192644487092e-10
+ 5.292323117496814e-05 3.5993152647751398e-10
+ 5.2935438206218145e-05 3.1142080027758294e-10
+ 5.2947645237468144e-05 2.8253202431124535e-10
+ 5.2959852268718143e-05 2.653283707170538e-10
+ 5.2972059299968141e-05 2.5508336753526945e-10
+ 5.298426633121814e-05 2.4898233649178344e-10
+ 5.2996473362468145e-05 2.4534909287155193e-10
+ 5.3008680393718144e-05 2.4318544696123555e-10
+ 5.3020887424968143e-05 2.4189696683490067e-10
+ 5.3033094456218141e-05 2.411296605642883e-10
+ 5.304530148746814e-05 2.406727199550333e-10
+ 5.3057508518718145e-05 2.4040060549918595e-10
+ 5.3069715549968144e-05 2.4023855751768804e-10
+ 5.3081922581218143e-05 2.4014205601586099e-10
+ 5.3094129612468141e-05 2.4008458822552009e-10
+ 5.310633664371814e-05 2.4005036536744095e-10
+ 5.3118543674968139e-05 2.4002998505548136e-10
+ 5.3130750706218144e-05 2.4001784836154639e-10
+ 5.3142957737468143e-05 2.4001062082534474e-10
+ 5.3155164768718141e-05 2.4000631674323626e-10
+ 5.316737179996814e-05 2.4000375361391963e-10
+ 5.3179578831218139e-05 2.4000222718017004e-10
+ 5.3191785862468144e-05 2.4000131819356677e-10
+ 5.3203992893718143e-05 2.4000077702242996e-10
+ 5.3216199924968142e-05 2.4000045459933931e-10
+ 5.322840695621814e-05 2.4000026257884156e-10
+ 5.3240613987468139e-05 2.4000014832025053e-10
+ 5.3252821018718137e-05 2.4000008023582484e-10
+ 5.3265028049968143e-05 2.4000003966625581e-10
+ 5.3277235081218142e-05 2.400000155533385e-10
+ 5.328944211246814e-05 2.4000000121814107e-10
+ 5.3301649143718139e-05 2.3999999261673205e-10
+ 5.3313856174968138e-05 2.3999998758456908e-10
+ 5.3326063206218143e-05 2.3999998453222656e-10
+ 5.3338270237468142e-05 2.3999998265390494e-10
+ 5.335047726871814e-05 2.3999998161732485e-10
+ 5.3362684299968139e-05 2.3999998104358188e-10
+ 5.3374891331218138e-05 2.3999998057389865e-10
+ 5.3387098362468143e-05 2.3999998026292464e-10
+ 5.3399305393718142e-05 2.3999998019001177e-10
+ 5.341151242496814e-05 2.3999998019899801e-10
+ 5.3423719456218139e-05 2.3999998020597388e-10
+ 5.3435926487468138e-05 2.3999998012855701e-10
+ 5.3448133518718143e-05 2.3999998005534517e-10
+ 5.3460340549968142e-05 2.3999998008389102e-10
+ 5.347254758121814e-05 2.3999998009224399e-10
+ 5.3484754612468139e-05 2.3999998012219294e-10
+ 5.3496961643718138e-05 2.3999998013282356e-10
+ 5.3509168674968136e-05 2.3999998009115475e-10
+ 5.3521375706218142e-05 2.3999998009706464e-10
+ 5.353358273746814e-05 2.3999998010363494e-10
+ 5.3545789768718139e-05 2.3999998011314167e-10
+ 5.3557996799968138e-05 2.3999998013616955e-10
+ 5.3570203831218136e-05 2.3999998011363462e-10
+ 5.3582410862468142e-05 2.3999998009274014e-10
+ 5.3594617893718141e-05 2.399999801011231e-10
+ 5.3606824924968139e-05 2.399999800977465e-10
+ 5.3619031956218138e-05 2.3999998010717031e-10
+ 5.3631238987468136e-05 2.3999998026497155e-10
+ 5.3643446018718135e-05 2.3999998018940695e-10
+ 5.3655653049968141e-05 2.399999801489314e-10
+ 5.3667860081218139e-05 2.3999998016252337e-10
+ 5.3680067112468138e-05 2.3999998017736873e-10
+ 5.3692274143718137e-05 2.3999998008841631e-10
+ 5.3704481174968135e-05 2.399999801406156e-10
+ 5.3716688206218141e-05 2.3999998027111368e-10
+ 5.3728895237468139e-05 2.399999803096209e-10
+ 5.3741102268718138e-05 2.399999801745041e-10
+ 5.3753309299968137e-05 2.3999998014351678e-10
+ 5.3765516331218135e-05 2.399999802735929e-10
+ 5.3777723362468141e-05 2.3999998026179471e-10
+ 5.3789930393718139e-05 2.3999998016976751e-10
+ 5.3802137424968138e-05 2.3999998022820648e-10
+ 5.3814344456218137e-05 2.3999998018386391e-10
+ 5.3826551487468135e-05 2.3999998024457121e-10
+ 5.3838758518718141e-05 2.399999802712344e-10
+ 5.3850965549968139e-05 2.3999998016906244e-10
+ 5.3863172581218138e-05 2.399999802251944e-10
+ 5.3875379612468137e-05 2.3999998029674961e-10
+ 5.3887586643718142e-05 2.3999998024490881e-10
+ 5.3899793674968141e-05 2.3999998022841694e-10
+ 5.3912000706218139e-05 2.3999998027402318e-10
+ 5.3924207737468138e-05 2.3999998031284179e-10
+ 5.3936414768718144e-05 2.3999998024592236e-10
+ 5.3948621799968142e-05 2.3999998028900653e-10
+ 5.3960828831218141e-05 2.3999998029018118e-10
+ 5.3973035862468139e-05 2.3999998020407995e-10
+ 5.3985242893718145e-05 2.3999998030027903e-10
+ 5.3997449924968144e-05 2.3999998034659856e-10
+ 5.4009656956218142e-05 2.3999998035710371e-10
+ 5.4021863987468141e-05 2.3999998035781327e-10
+ 5.4034071018718146e-05 2.3999998028429372e-10
+ 5.4046278049968145e-05 2.3999998026462584e-10
+ 5.4058485081218144e-05 2.3999998034401652e-10
+ 5.4070692112468142e-05 2.3999998040748526e-10
+ 5.4082899143718148e-05 2.399999802904164e-10
+ 5.4095106174968146e-05 2.3999998026488739e-10
+ 5.4107313206218145e-05 2.399999803948264e-10
+ 5.4119520237468144e-05 2.399999803901337e-10
+ 5.4131727268718149e-05 2.3999998030809217e-10
+ 5.4143934299968148e-05 2.3999998036169063e-10
+ 5.4156141331218146e-05 2.3999998033495331e-10
+ 5.4168348362468145e-05 2.3999998039429674e-10
+ 5.4180555393718151e-05 2.3999998043834603e-10
+ 5.4192762424968149e-05 2.3999998042747548e-10
+ 5.4204969456218148e-05 2.3999998033813589e-10
+ 5.4217176487468146e-05 2.3999998042749197e-10
+ 5.4229383518718152e-05 2.3999998045576412e-10
+ 5.4241590549968151e-05 2.3999998040668088e-10
+ 5.4253797581218149e-05 2.3999998041015307e-10
+ 5.4266004612468148e-05 2.3999998038280188e-10
+ 5.4278211643718153e-05 2.399999804963409e-10
+ 5.4290418674968152e-05 2.3999998050724164e-10
+ 5.4302625706218151e-05 2.3999998043757132e-10
+ 5.4314832737468149e-05 2.3999998042873677e-10
+ 5.4327039768718155e-05 2.3999998048062938e-10
+ 5.4339246799968153e-05 2.3999998046244087e-10
+ 5.4351453831218152e-05 2.3999998047367506e-10
+ 5.4363660862468151e-05 2.3999998045481209e-10
+ 5.4375867893718156e-05 2.3999998043752122e-10
+ 5.4388074924968155e-05 2.3999998042446345e-10
+ 5.4400281956218153e-05 2.3999998041722252e-10
+ 5.4412488987468152e-05 2.3999998041674074e-10
+ 5.4424696018718158e-05 2.3999998042357827e-10
+ 5.4436903049968156e-05 2.3999998043806778e-10
+ 5.4449110081218155e-05 2.3999998047660411e-10
+ 5.4461317112468153e-05 2.3999998051655456e-10
+ 5.4473524143718159e-05 2.3999998052591767e-10
+ 5.4485731174968158e-05 2.3999998048427911e-10
+ 5.4497938206218156e-05 2.3999998054712477e-10
+ 5.4510145237468155e-05 2.3999998057013456e-10
+ 5.452235226871816e-05 2.3999998051176627e-10
+ 5.4534559299968159e-05 2.3999998057450993e-10
+ 5.4546766331218158e-05 2.3999998053652084e-10
+ 5.4558973362468156e-05 2.3999998056705243e-10
+ 5.4571180393718162e-05 2.399999805326457e-10
+ 5.458338742496816e-05 2.399999805718764e-10
+ 5.4595594456218159e-05 2.3999998054921403e-10
+ 5.4607801487468158e-05 2.3999998061819825e-10
+ 5.4620008518718163e-05 2.399999805688973e-10
+ 5.4632215549968162e-05 2.3999998054792621e-10
+ 5.464442258121816e-05 2.39999980627754e-10
+ 5.4656629612468159e-05 2.3999998059474422e-10
+ 5.4668836643718164e-05 2.399999805933057e-10
+ 5.4681043674968163e-05 2.3999998057922352e-10
+ 5.4693250706218162e-05 2.3999998056088616e-10
+ 5.470545773746816e-05 2.3999998058786213e-10
+ 5.4717664768718166e-05 2.399999806005213e-10
+ 5.4729871799968165e-05 2.3999998060792622e-10
+ 5.4742078831218163e-05 2.3999998061547279e-10
+ 5.4754285862468162e-05 2.3999998062637359e-10
+ 5.4766492893718167e-05 2.3999998064254068e-10
+ 5.4778699924968166e-05 2.399999806651119e-10
+ 5.4790906956218165e-05 2.3999998065019003e-10
+ 5.4803113987468163e-05 2.3999998066078063e-10
+ 5.4815321018718169e-05 2.399999807158811e-10
+ 5.4827528049968167e-05 2.3999998065933043e-10
+ 5.4839735081218166e-05 2.3999998069949765e-10
+ 5.4851942112468165e-05 2.3999998071137632e-10
+ 5.486414914371817e-05 2.3999998066492584e-10
+ 5.4876356174968169e-05 2.3999998067631891e-10
+ 5.4888563206218167e-05 2.3999998068067386e-10
+ 5.4900770237468166e-05 2.3999998072884115e-10
+ 5.4912977268718171e-05 2.3999998071703879e-10
+ 5.492518429996817e-05 2.399999807620995e-10
+ 5.4937391331218169e-05 2.3999998071038665e-10
+ 5.4949598362468167e-05 2.3999998068359319e-10
+ 5.4961805393718173e-05 2.3999998073934671e-10
+ 5.4974012424968172e-05 2.3999998074833904e-10
+ 5.498621945621817e-05 2.3999998072288318e-10
+ 5.4998426487468169e-05 2.3999998078919143e-10
+ 5.5010633518718174e-05 2.3999998076965073e-10
+ 5.5022840549968173e-05 2.399999807468099e-10
+ 5.5035047581218172e-05 2.3999998076982682e-10
+ 5.504725461246817e-05 2.3999998077882701e-10
+ 5.5059461643718176e-05 2.3999998078272732e-10
+ 5.5071668674968174e-05 2.3999998077698307e-10
+ 5.5083875706218173e-05 2.3999998078844893e-10
+ 5.5096082737468172e-05 2.3999998080355428e-10
+ 5.5108289768718177e-05 2.3999998082407074e-10
+ 5.5120496799968176e-05 2.3999998085105249e-10
+ 5.5132703831218174e-05 2.3999998076975625e-10
+ 5.5144910862468173e-05 2.399999808033618e-10
+ 5.5157117893718178e-05 2.3999998080328762e-10
+ 5.5169324924968177e-05 2.3999998084082399e-10
+ 5.5181531956218176e-05 2.3999998077877215e-10
+ 5.5193738987468174e-05 2.3999998083679345e-10
+ 5.520594601871818e-05 2.3999998087406507e-10
+ 5.5218153049968179e-05 2.3999998083776306e-10
+ 5.5230360081218177e-05 2.3999998086990843e-10
+ 5.5242567112468176e-05 2.3999998083702247e-10
+ 5.5254774143718181e-05 2.399999808776692e-10
+ 5.526698117496818e-05 2.3999998085631119e-10
+ 5.5279188206218179e-05 2.3999998083949021e-10
+ 5.5291395237468177e-05 2.3999929577393646e-10
+ 5.5303602268718183e-05 2.3999721430085655e-10
+ 5.5315809299968181e-05 2.3999541801853927e-10
+ 5.532801633121818e-05 2.3999352441667849e-10
+ 5.5340223362468179e-05 2.3998998231508299e-10
+ 5.5352430393718184e-05 2.3998269751518182e-10
+ 5.5364637424968183e-05 2.3996731785187146e-10
+ 5.5370740940593182e-05 2.3994983464395233e-10
+ 5.5376844456218181e-05 2.3990674100743305e-10
+ 5.5379896214030681e-05 2.3985615585153402e-10
+ 5.5382947971843181e-05 2.3973456609508262e-10
+ 5.5384473850749434e-05 2.3959023649420816e-10
+ 5.538599972965568e-05 2.3924487360909957e-10
+ 5.5386991106889187e-05 2.3866252493064795e-10
+ 5.5387269733896247e-05 2.3836567845599657e-10
+ 5.5387548360903299e-05 2.3795958755937176e-10
+ 5.5388098835627974e-05 2.3707317678626589e-10
+ 5.5390875273912441e-05 2.3289947932096134e-10
+ 5.5403082305162439e-05 2.1857108082062022e-10
+ 5.5415289336412438e-05 2.0744394567167327e-10
+ 5.5427496367662437e-05 1.9657101424192844e-10
+ 5.5439703398912435e-05 1.8444183633608339e-10
+ 5.5451910430162441e-05 1.7048236032410772e-10
+ 5.5464117461412439e-05 1.5473832156939622e-10
+ 5.5476324492662438e-05 1.376643966131987e-10
+ 5.5488531523912443e-05 1.1997405552563603e-10
+ 5.5500738555162442e-05 1.0252468847149855e-10
+ 5.5512945586412441e-05 8.622433036431135e-11
+ 5.5525152617662439e-05 7.1953269034585456e-11
+ 5.5537359648912438e-05 6.0497851486217764e-11
+ 5.5549566680162443e-05 5.2496010132610782e-11
+ 5.5561773711412442e-05 4.8395088933560857e-11
+ 5.5573980742662441e-05 4.8422873289603413e-11
+ 5.5586187773912446e-05 5.2572582289997926e-11
+ 5.5598394805162445e-05 6.0602144636946106e-11
+ 5.5610601836412443e-05 7.2047475992215135e-11
+ 5.5622808867662442e-05 8.6248800170538565e-11
+ 5.5635015898912441e-05 1.0238838404643464e-10
+ 5.5647222930162446e-05 1.19537446121802e-10
+ 5.5659429961412445e-05 1.367094991032434e-10
+ 5.5671636992662444e-05 1.5291703382970249e-10
+ 5.5683844023912449e-05 1.6722827017382802e-10
+ 5.5686895781724942e-05 1.7041028620342427e-10
+ 5.5687048369615568e-05 1.7056469761267313e-10
+ 5.5687429839342136e-05 1.7094872387604414e-10
+ 5.5687467986314791e-05 1.7098696858623529e-10
+ 5.5687475615709323e-05 1.7099461407315297e-10
+ 5.5687490874498381e-05 1.7100990159048815e-10
+ 5.568749697801401e-05 1.7101601530675094e-10
+ 5.5687499419420259e-05 1.7101846058671687e-10
+ 5.5687499604455785e-05 1.7101864591102341e-10
+ 5.5687499974526838e-05 1.710190165576025e-10
+ 5.568750071466895e-05 2.9362295535076986e-10
+ 5.5687501454811062e-05 6.7955376462053112e-10
+ 5.5687508856232145e-05 1.9019685483973129e-08
+ 5.5687516257653242e-05 6.3680162617685321e-08
+ 5.5687523659074325e-05 1.3464578979540883e-07
+ 5.5687531060495422e-05 2.3189729697639808e-07
+ 5.5687538461916505e-05 3.5541134357275011e-07
+ 5.5687547512355688e-05 5.4209487018455778e-07
+ 5.5687556562794872e-05 7.6794744751962639e-07
+ 5.5687565613234049e-05 1.032901665904789e-06
+ 5.5687574663673232e-05 1.3368810846168448e-06
+ 5.5687583714112416e-05 1.6798002590529673e-06
+ 5.5687595044533514e-05 2.1638522289015684e-06
+ 5.5687606374954613e-05 2.7085809274094572e-06
+ 5.5687617705375711e-05 3.3137595140903088e-06
+ 5.568762903579681e-05 3.9791394372703589e-06
+ 5.5687643214653364e-05 4.8961848891924115e-06
+ 5.5687657393509919e-05 5.9065041934527361e-06
+ 5.5687671572366474e-05 7.0094688242501652e-06
+ 5.5687689032396939e-05 8.4939484121898285e-06
+ 5.5687706492427397e-05 1.011650368403691e-05
+ 5.5687723952457861e-05 1.187564441966631e-05
+ 5.5687746268477831e-05 1.4320324258348367e-05
+ 5.5687768584497801e-05 1.6981891243476683e-05
+ 5.568779090051777e-05 1.9856448881756975e-05
+ 5.568781909021724e-05 2.3785542948120637e-05
+ 5.5687847279916716e-05 2.8038794641957824e-05
+ 5.5687875469616185e-05 3.2606525910010655e-05
+ 5.5687903659315654e-05 3.7478440563006991e-05
+ 5.5687931849015124e-05 4.2643660624918842e-05
+ 5.5687960038714593e-05 4.809076449946518e-05
+ 5.5687988228414062e-05 5.3807826764352856e-05
+ 5.5688019414106471e-05 6.0432058501488789e-05
+ 5.5688050599798886e-05 6.7354141141263776e-05
+ 5.5688081785491295e-05 7.4556149339010216e-05
+ 5.5688112971183711e-05 8.2019674226669682e-05
+ 5.5688150418414337e-05 9.1300740447793598e-05
+ 5.5688187865644969e-05 0.00010089852928503813
+ 5.5688225312875602e-05 0.00011077933330704341
+ 5.5688270844195812e-05 0.00012312530862772575
+ 5.5688316375516022e-05 0.00013577798574481139
+ 5.5688361906836238e-05 0.00014867616552750304
+ 5.5688407438156448e-05 0.00016175929991125412
+ 5.5688441084028114e-05 0.00017151113091571656
+ 5.5688474729899779e-05 0.00018130797963939794
+ 5.5688508375771445e-05 0.00019112690048319055
+ 5.568854202164311e-05 0.000200945563836072
+ 5.5688575667514776e-05 0.0002107423308290232
+ 5.5688609313386441e-05 0.00022049632214156449
+ 5.5688642959258107e-05 0.00023018748061678874
+ 5.5688676605129772e-05 0.00023979662749408118
+ 5.5688710251001438e-05 0.0002493055121224335
+ 5.5688736870668147e-05 0.00025674620625396695
+ 5.5688763490334857e-05 0.00026410519322842072
+ 5.5688790110001567e-05 0.00027137476557784006
+ 5.5688816729668284e-05 0.00027854762813939171
+ 5.5688843349334994e-05 0.00028561690431054267
+ 5.5688869969001704e-05 0.0002925761407342706
+ 5.5688896588668414e-05 0.0002994193104460534
+ 5.5688923208335124e-05 0.00030614081452042582
+ 5.5688949828001833e-05 0.00031273548226053464
+ 5.5688976447668543e-05 0.00031919856997935221
+ 5.5689003067335253e-05 0.00032552575842600295
+ 5.5689029687001963e-05 0.00033171314891500655
+ 5.568905630666868e-05 0.00033775725822013397
+ 5.568908292633539e-05 0.00034365501229800138
+ 5.56891095460021e-05 0.00034940373890948994
+ 5.568913616566881e-05 0.00035500115920957621
+ 5.5689162785335519e-05 0.00036044537837818884
+ 5.5689189405002229e-05 0.00036573487536628151
+ 5.5689216024668939e-05 0.00037086849183281574
+ 5.5689239404935229e-05 0.00037524816041470616
+ 5.5689262785201519e-05 0.00037950661982143294
+ 5.5689286165467809e-05 0.00038364373347733212
+ 5.5689309545734092e-05 0.00038765955240256639
+ 5.5689332926000382e-05 0.00039155430797307712
+ 5.5689356306266672e-05 0.00039532840450424615
+ 5.5689379686532962e-05 0.00039898241168751826
+ 5.5689403066799245e-05 0.00040251705690861332
+ 5.5689426447065535e-05 0.00040593321747524688
+ 5.5689449827331825e-05 0.0004092319127814815
+ 5.5689473207598115e-05 0.00041241429643495774
+ 5.5689496587864398e-05 0.00041548164837231091
+ 5.5689519968130688e-05 0.00041843536698707185
+ 5.5689543348396978e-05 0.00042127696129328835
+ 5.5689566728663267e-05 0.00042400804314699181
+ 5.5689590108929551e-05 0.00042663031954648096
+ 5.568961348919584e-05 0.00042914558503120656
+ 5.568963686946213e-05 0.00043155571419782471
+ 5.568966024972842e-05 0.00043386265435075173
+ 5.5689683629994703e-05 0.0004360684183033
+ 5.5689707010260993e-05 0.00043817507734421687
+ 5.5689735591237521e-05 0.00044061881915944171
+ 5.5689764172214041e-05 0.00044292160557832261
+ 5.5689792753190568e-05 0.00044508748731897325
+ 5.5689821334167089e-05 0.0004471205811035718
+ 5.5689849915143616e-05 0.00044902505354874717
+ 5.5689886199806214e-05 0.00045126415767136695
+ 5.5689925453373381e-05 0.00045347065125915753
+ 5.5689946977215266e-05 0.00045458914938144757
+ 5.5689973696714703e-05 0.00045589098737442259
+ 5.5690000416214139e-05 0.00045710004038524538
+ 5.5690027135713575e-05 0.00045821970861944291
+ 5.5690053855213011e-05 0.00045925335947318648
+ 5.5690080574712447e-05 0.00046020432082601948
+ 5.5690107294211883e-05 0.00046107587487371744
+ 5.5690134013711319e-05 0.00046187125249194449
+ 5.5690160733210755e-05 0.00046259362811953432
+ 5.5690187452710191e-05 0.00046324611514856153
+ 5.5690214172209627e-05 0.00046383176180687778
+ 5.5690240891709063e-05 0.00046435354751746608
+ 5.569026254885961e-05 0.00046473161709406521
+ 5.5690284206010163e-05 0.00046507115570231151
+ 5.5690305863160717e-05 0.00046537364255429416
+ 5.569032752031127e-05 0.00046564052306956875
+ 5.5690349177461824e-05 0.00046587320827894959
+ 5.569037083461237e-05 0.00046607307433484731
+ 5.5690392491762924e-05 0.00046624146212347479
+ 5.5690414148913477e-05 0.00046637967697419719
+ 5.5690435806064024e-05 0.00046648898846127722
+ 5.5690457463214577e-05 0.00046657063029325929
+ 5.5690479120365131e-05 0.0004666258002852115
+ 5.5690496765399605e-05 0.00046665198683365781
+ 5.569051441043408e-05 0.00046666198405394353
+ 5.5690532055468555e-05 0.00046665638716889121
+ 5.5690549700503029e-05 0.00046663577581361698
+ 5.5690567345537497e-05 0.00046660071413966874
+ 5.5690584990571972e-05 0.00046655175093608377
+ 5.5690602635606446e-05 0.00046648941976632619
+ 5.5690620280640921e-05 0.00046641423912008399
+ 5.5690637925675396e-05 0.00046632671257892689
+ 5.569065557070987e-05 0.00046622732899484812
+ 5.5690673215744345e-05 0.00046611656268073646
+ 5.5690690860778813e-05 0.00046599487361184948
+ 5.5690708505813287e-05 0.00046586270763738396
+ 5.5690726150847762e-05 0.00046572049670126538
+ 5.5690743795882236e-05 0.00046556865907130521
+ 5.5690761440916711e-05 0.00046540759957590188
+ 5.5690779085951186e-05 0.00046523770984748908
+ 5.569079673098566e-05 0.00046505936857196291
+ 5.5690814376020135e-05 0.00046487294174334804
+ 5.569083202105461e-05 0.00046467878292299136
+ 5.5690849666089077e-05 0.00046447723350260048
+ 5.5690867311123552e-05 0.00046426862297047311
+ 5.5690884956158027e-05 0.00046405326918029163
+ 5.5690902601192501e-05 0.00046383147862188659
+ 5.5690920246226976e-05 0.0004636035466933999
+ 5.569093789126145e-05 0.00046336975797430831
+ 5.5690955536295925e-05 0.00046313038649879376
+ 5.5690973181330393e-05 0.00046288569602897633
+ 5.5690990826364868e-05 0.00046263594032755121
+ 5.5691008471399342e-05 0.00046238136342939871
+ 5.5691026116433817e-05 0.00046212219991176166
+ 5.5691043761468291e-05 0.00046185867516261082
+ 5.5691061406502766e-05 0.00046159100564684353
+ 5.5691079051537241e-05 0.00046131939916998468
+ 5.5691096696571715e-05 0.00046104405513908457
+ 5.569111434160619e-05 0.00046076516482052872
+ 5.5691131986640658e-05 0.00046048291159450004
+ 5.5691149631675132e-05 0.00046019747120585279
+ 5.5691167276709607e-05 0.00045990901201118061
+ 5.5691184921744082e-05 0.00045961769522188066
+ 5.5691202566778556e-05 0.00045932367514303494
+ 5.5691220211813031e-05 0.00045902709940794936
+ 5.5691237856847505e-05 0.00045872810920820898
+ 5.5691255501881973e-05 0.00045842683951912496
+ 5.5691273146916448e-05 0.00045812341932046545
+ 5.5691290791950922e-05 0.00045781797181237863
+ 5.5691308436985397e-05 0.00045751061462643097
+ 5.5691326082019872e-05 0.00045720146003169808
+ 5.5691343727054346e-05 0.00045689061513585962
+ 5.5691361372088821e-05 0.00045657818208126165
+ 5.5691379017123296e-05 0.00045626425823592343
+ 5.569139666215777e-05 0.0004559489363794755
+ 5.5691414307192238e-05 0.0004556323048840281
+ 5.5691431952226713e-05 0.00045531444788997848
+ 5.5691449597261187e-05 0.00045499544547677518
+ 5.5691467242295662e-05 0.00045467537382866608
+ 5.5691484887330136e-05 0.00045435430539546583
+ 5.5691502532364611e-05 0.00045403230904838535
+ 5.5691520177399086e-05 0.00045370945023097327
+ 5.5691537822433553e-05 0.00045338579110522598
+ 5.5691555467468028e-05 0.00045306139069292836
+ 5.5691573112502503e-05 0.00045273630501229328
+ 5.5691590757536977e-05 0.00045241058720997258
+ 5.5691608402571452e-05 0.00045208428768851668
+ 5.5691626047605927e-05 0.00045175745422936376
+ 5.5691643692640401e-05 0.00045143013211144381
+ 5.5691661337674876e-05 0.00045110236422548483
+ 5.5691682620107581e-05 0.00045070649383213837
+ 5.5691702745281677e-05 0.00045033166770387813
+ 5.5691722870455781e-05 0.00044995642757493547
+ 5.5691742995629884e-05 0.00044958082330929242
+ 5.5691763120803988e-05 0.00044920490166811688
+ 5.5691783245978091e-05 0.00044882870648050557
+ 5.5691803371152195e-05 0.00044845227880637947
+ 5.5691823496326298e-05 0.00044807565709178331
+ 5.5691843621500395e-05 0.00044769887731683952
+ 5.5691863746674498e-05 0.00044732197313660687
+ 5.5691888110746131e-05 0.00044686556133260454
+ 5.5691912474817757e-05 0.00044640906499999366
+ 5.5691936838889382e-05 0.00044595253182312878
+ 5.5691961202961008e-05 0.00044549600565976083
+ 5.5691985567032641e-05 0.00044503952681690417
+ 5.5692009931104267e-05 0.00044458313230938829
+ 5.5692034295175892e-05 0.00044412685610195336
+ 5.5692058659247518e-05 0.00044367072933572632
+ 5.5692083023319151e-05 0.00044321478053989036
+ 5.5692107387390777e-05 0.00044275903582933563
+ 5.569213671968357e-05 0.00044221066197735565
+ 5.5692166051976363e-05 0.00044166265618977781
+ 5.5692195384269163e-05 0.00044111505229614979
+ 5.5692224716561956e-05 0.000440567880571222
+ 5.5692254048854749e-05 0.0004400211680723513
+ 5.5692283381147542e-05 0.0004394749389480193
+ 5.5692312713440342e-05 0.0004389292147195882
+ 5.5692342045733135e-05 0.00043838401453830063
+ 5.56923778480292e-05 0.00043771929099924211
+ 5.5692412335454634e-05 0.00043707976746529866
+ 5.5692446822880062e-05 0.00043644103787377733
+ 5.5692481310305496e-05 0.00043580312030283216
+ 5.5692515797730931e-05 0.00043516603032572377
+ 5.5692557828321209e-05 0.00043439073279079223
+ 5.5692599858911487e-05 0.00043361670459320404
+ 5.5692641889501765e-05 0.00043284396248195208
+ 5.5692683920092049e-05 0.00043207252012209858
+ 5.5692725950682327e-05 0.00043130238856505936
+ 5.5692777518503426e-05 0.00043035930871672526
+ 5.5692828186666485e-05 0.00042943462880424378
+ 5.5692878854829543e-05 0.00042851188736760037
+ 5.5692929522992602e-05 0.00042759109050169295
+ 5.5692993215143466e-05 0.00042643637215815307
+ 5.569305690729433e-05 0.0004252847370223043
+ 5.5693120599445195e-05 0.00042413618616643506
+ 5.5693198945610715e-05 0.00042272760989246018
+ 5.5693278657649693e-05 0.00042129925771114857
+ 5.5693358369688671e-05 0.00041987571829712041
+ 5.5693461292370767e-05 0.00041804477075287836
+ 5.5693569508909822e-05 0.00041612824858809757
+ 5.5693701914804441e-05 0.00041379527174881443
+ 5.5693847065030183e-05 0.00041125276249577136
+ 5.5694034315235683e-05 0.00040799587225246868
+ 5.5694255865010425e-05 0.00040417569543334638
+ 5.5694554034092501e-05 0.00039909077578923559
+ 5.5694998769870891e-05 0.00039162496079868337
+ 5.5695805003988993e-05 0.00037844492463713218
+ 5.5696711764368313e-05 0.00036415075183872955
+ 5.5697737475686441e-05 0.00034863113834200367
+ 5.5698801143402345e-05 0.00033323544260725887
+ 5.5699944764949551e-05 0.00031744009309453978
+ 5.570223164627891e-05 0.00028806442739914481
+ 5.5704182681216658e-05 0.00026516169925578173
+ 5.5706291228517252e-05 0.00024245284579639417
+ 5.570858146743616e-05 0.00021998507757767748
+ 5.5710926666850025e-05 0.00019913410083615226
+ 5.571327186626389e-05 0.00018025945489984468
+ 5.5715590537179633e-05 0.00016335772611693962
+ 5.571847456948428e-05 0.00014452917890563918
+ 5.5721358601788933e-05 0.00012787080313841811
+ 5.572424263409358e-05 0.00011313246567173927
+ 5.5727126666398226e-05 0.00010009286360866482
+ 5.5730010698702879e-05 8.8556201336288662e-05
+ 5.5732894731007526e-05 7.8349250567829904e-05
+ 5.5735778763312173e-05 6.9318749243295542e-05
+ 5.5739342797663596e-05 5.9583601550415324e-05
+ 5.5742906832015013e-05 5.12156620124964e-05
+ 5.5746470866366437e-05 4.4022919356413453e-05
+ 5.5750034900717854e-05 3.7840328450154061e-05
+ 5.5753598935069271e-05 3.2526023165760874e-05
+ 5.5757899961127365e-05 2.7096692323683933e-05
+ 5.5762200987185451e-05 2.2573641128908005e-05
+ 5.5766502013243537e-05 1.8805590756409222e-05
+ 5.577080303930163e-05 1.5666514280396347e-05
+ 5.5775104065359717e-05 1.3051421554109079e-05
+ 5.5780502505986987e-05 1.0377818664489998e-05
+ 5.5785900946614251e-05 8.251909089995107e-06
+ 5.5791299387241515e-05 6.5614966739560858e-06
+ 5.5796697827868785e-05 5.2173688876777125e-06
+ 5.5803468247657473e-05 3.9138135354349389e-06
+ 5.5810238667446161e-05 2.9359531577328348e-06
+ 5.5817009087234848e-05 2.2024124497970242e-06
+ 5.5825385304343961e-05 1.5432541258101081e-06
+ 5.5833761521453073e-05 1.081378721967762e-06
+ 5.5842137738562186e-05 7.5774041132707628e-07
+ 5.5853043385488658e-05 4.7689837631713853e-07
+ 5.5863949032415131e-05 3.0015113649486665e-07
+ 5.5876156063665129e-05 1.7876217937191045e-07
+ 5.5888363094915135e-05 1.0647330757921957e-07
+ 5.5900570126165133e-05 6.3424252544034479e-08
+ 5.5912777157415132e-05 3.7787934734000867e-08
+ 5.5924984188665137e-05 2.2521155841269887e-08
+ 5.5937191219915136e-05 1.3429588576020001e-08
+ 5.5949398251165135e-05 8.015449872567151e-09
+ 5.5961605282415133e-05 4.7912734917149069e-09
+ 5.5973812313665132e-05 2.871251600636248e-09
+ 5.5986019344915137e-05 1.7278727196949598e-09
+ 5.5998226376165136e-05 1.0469960699243559e-09
+ 5.6010433407415135e-05 6.4154623608527275e-10
+ 5.602264043866514e-05 4.0011708092908531e-10
+ 5.6034847469915139e-05 2.563646256420896e-10
+ 5.6047054501165138e-05 1.7078006330613652e-10
+ 5.6059261532415136e-05 1.1983532309874618e-10
+ 5.6071468563665135e-05 8.9519095817165878e-11
+ 5.608367559491514e-05 7.14874426319846e-11
+ 5.6095882626165139e-05 6.0771426293748156e-11
+ 5.6108089657415138e-05 5.4411972164600532e-11
+ 5.6120296688665143e-05 5.0646908151112081e-11
+ 5.6132503719915142e-05 4.8426835103990855e-11
+ 5.614471075116514e-05 4.7126820532761082e-11
+ 5.6156917782415139e-05 4.6374708016315066e-11
+ 5.6169124813665138e-05 4.594887297816922e-11
+ 5.6181331844915143e-05 4.5717334758833713e-11
+ 5.6193538876165142e-05 4.5601496954841019e-11
+ 5.620574590741514e-05 4.5554554261028926e-11
+ 5.6217952938665146e-05 4.5548633436145208e-11
+ 5.6230159969915144e-05 4.5567135561437956e-11
+ 5.6242367001165143e-05 4.5600175741221697e-11
+ 5.6250000000000005e-05 4.5624752229059989e-11
+ 5.6262207031250004e-05 4.5669966819297461e-11
+ 5.6274414062500003e-05 4.5718898557805248e-11
+ 5.6286621093750008e-05 4.5770037749483043e-11
+ 5.6298828125000007e-05 4.5822485350610839e-11
+ 5.6311035156250005e-05 4.5875705969269391e-11
+ 5.6323242187500004e-05 4.5929380773488921e-11
+ 5.6335449218750003e-05 4.5983319895906806e-11
+ 5.6347656250000008e-05 4.6037410269464089e-11
+ 5.6359863281250007e-05 4.6091584562801975e-11
+ 5.6372070312500005e-05 4.6145802680837535e-11
+ 5.6384277343750004e-05 4.6200040748086769e-11
+ 5.6396484375000003e-05 4.6254284548072891e-11
+ 5.6408691406250008e-05 4.6308525616398256e-11
+ 5.6420898437500007e-05 4.6362758914111761e-11
+ 5.6433105468750005e-05 4.641698144216514e-11
+ 5.6445312500000004e-05 4.6471191416301583e-11
+ 5.6457519531250003e-05 4.6525387775689795e-11
+ 5.6469726562500008e-05 4.6579569890308451e-11
+ 5.6481933593750007e-05 4.663373738668933e-11
+ 5.6494140625000005e-05 4.6687890044144897e-11
+ 5.6506347656250004e-05 4.6742027732970226e-11
+ 5.6518554687500003e-05 4.6796150377641402e-11
+ 5.6530761718750008e-05 4.6850257934899579e-11
+ 5.6542968750000007e-05 4.690435038069982e-11
+ 5.6555175781250006e-05 4.695842770243876e-11
+ 5.6567382812500004e-05 4.7012489894326265e-11
+ 5.6579589843750003e-05 4.7066536954629075e-11
+ 5.6591796875000008e-05 4.7120568884029375e-11
+ 5.6604003906250007e-05 4.7174585684647293e-11
+ 5.6616210937500006e-05 4.7228587359458799e-11
+ 5.6628417968750004e-05 4.728257391194907e-11
+ 5.6640625000000003e-05 4.7336545345906017e-11
+ 5.6652832031250008e-05 4.7390501665297362e-11
+ 5.6665039062500007e-05 4.7444442874197415e-11
+ 5.6677246093750006e-05 4.7498368976743532e-11
+ 5.6689453125000004e-05 4.7552279977110043e-11
+ 5.6701660156250003e-05 4.7606175879492929e-11
+ 5.6713867187500002e-05 4.76600566881005e-11
+ 5.6726074218750007e-05 4.771392240714795e-11
+ 5.6738281250000006e-05 4.7767773040854128e-11
+ 5.6750488281250004e-05 4.7821608593439534e-11
+ 5.6762695312500003e-05 4.7875429069125182e-11
+ 5.6774902343750008e-05 4.7929234472131972e-11
+ 5.6787109375000007e-05 4.7983024806680162e-11
+ 5.6799316406250006e-05 4.8036800076989225e-11
+ 5.6811523437500004e-05 4.8090560287277661e-11
+ 5.6823730468750003e-05 4.81443054417629e-11
+ 5.6835937500000008e-05 4.8198035544661283e-11
+ 5.6848144531250007e-05 4.8251750600188019e-11
+ 5.6860351562500006e-05 4.8305450612557161e-11
+ 5.6872558593750004e-05 4.835913558598157e-11
+ 5.6884765625000003e-05 4.8412805524672993e-11
+ 5.6896972656250009e-05 4.846646043284194e-11
+ 5.6909179687500007e-05 4.8520100314697792e-11
+ 5.6921386718750006e-05 4.8573725174448732e-11
+ 5.6933593750000004e-05 4.8627335016301782e-11
+ 5.6945800781250003e-05 4.8680929844462761e-11
+ 5.6958007812500009e-05 4.8734509663136332e-11
+ 5.6970214843750007e-05 4.8788074476525962e-11
+ 5.6982421875000006e-05 4.8841624288833967e-11
+ 5.6994628906250005e-05 4.8895159104261467e-11
+ 5.7006835937500003e-05 4.894867892700839e-11
+ 5.7019042968750009e-05 4.9002183761273549e-11
+ 5.7031250000000007e-05 4.905567361125451e-11
+ 5.7043457031250006e-05 4.9109148481147716e-11
+ 5.7055664062500005e-05 4.9162608375148381e-11
+ 5.7067871093750003e-05 4.9216053297450589e-11
+ 5.7080078125000009e-05 4.9269483252247235e-11
+ 5.7092285156250007e-05 4.932289824373005e-11
+ 5.7104492187500006e-05 4.9376298276089576e-11
+ 5.7116699218750005e-05 4.9429683353515166e-11
+ 5.7128906250000003e-05 4.9483053480195042e-11
+ 5.7141113281250009e-05 4.9536408660316226e-11
+ 5.7153320312500007e-05 4.9589748898064572e-11
+ 5.7165527343750006e-05 4.9643074197624777e-11
+ 5.7177734375000005e-05 4.9696384563180337e-11
+ 5.7189941406250003e-05 4.9749679998913594e-11
+ 5.7202148437500009e-05 4.980296050900572e-11
+ 5.7214355468750007e-05 4.9856226097636712e-11
+ 5.7226562500000006e-05 4.99094767689854e-11
+ 5.7238769531250005e-05 4.9962712527229435e-11
+ 5.7250976562500003e-05 5.0015933376545304e-11
+ 5.7263183593750009e-05 5.0069139321108297e-11
+ 5.7275390625000008e-05 5.0122330365092602e-11
+ 5.7287597656250006e-05 5.0175506512671175e-11
+ 5.7299804687500005e-05 5.0228667768015851e-11
+ 5.7312011718750003e-05 5.0281814135297241e-11
+ 5.7324218750000002e-05 5.0334945618684835e-11
+ 5.7336425781250008e-05 5.0388062222346936e-11
+ 5.7348632812500006e-05 5.0441163950450669e-11
+ 5.7360839843750005e-05 5.0494250807162017e-11
+ 5.7373046875000004e-05 5.0547322796645784e-11
+ 5.7385253906250002e-05 5.060037992306559e-11
+ 5.7397460937500008e-05 5.0653422190583924e-11
+ 5.7409667968750006e-05 5.0706449603362099e-11
+ 5.7421875000000005e-05 5.0759462165560252e-11
+ 5.7434082031250004e-05 5.0812459881337356e-11
+ 5.7446289062500002e-05 5.086544275485121e-11
+ 5.7458496093750008e-05 5.0918410790258479e-11
+ 5.7470703125000006e-05 5.0971363991714641e-11
+ 5.7482910156250005e-05 5.1024302363374004e-11
+ 5.7495117187500004e-05 5.1077225909389738e-11
+ 5.7507324218750002e-05 5.1130134633913832e-11
+ 5.7519531250000008e-05 5.1183028541097097e-11
+ 5.7531738281250006e-05 5.123590763508922e-11
+ 5.7543945312500005e-05 5.1288771920038706e-11
+ 5.7556152343750004e-05 5.1341621400092889e-11
+ 5.7568359375000002e-05 5.1394456079397949e-11
+ 5.7580566406250001e-05 5.1447275962098919e-11
+ 5.7592773437500006e-05 5.1500081052339658e-11
+ 5.7604980468750005e-05 5.1552871354262853e-11
+ 5.7617187500000004e-05 5.1605646872010057e-11
+ 5.7629394531250002e-05 5.1658407609721638e-11
+ 5.7641601562500001e-05 5.171115357153682e-11
+ 5.7653808593750006e-05 5.1763884761593666e-11
+ 5.7666015625000005e-05 5.1816601184029079e-11
+ 5.7678222656250004e-05 5.1869302842978788e-11
+ 5.7690429687500002e-05 5.1921989742577379e-11
+ 5.7702636718750001e-05 5.1974661886958285e-11
+ 5.771484375e-05 5.2027319280253771e-11
+ 5.7727050781250005e-05 5.2079961926594946e-11
+ 5.7739257812500004e-05 5.2132589830111786e-11
+ 5.7751464843750003e-05 5.2185202994933079e-11
+ 5.7763671875000001e-05 5.2237801425186463e-11
+ 5.777587890625e-05 5.2290385124998426e-11
+ 5.7788085937500005e-05 5.2342954098494298e-11
+ 5.7800292968750004e-05 5.2395508349798247e-11
+ 5.7812500000000003e-05 5.2448047883033309e-11
+ 5.7824707031250001e-05 5.2500572702321331e-11
+ 5.78369140625e-05 5.2553082811783024e-11
+ 5.7849121093750005e-05 5.260557821553798e-11
+ 5.7861328125000004e-05 5.265805891770455e-11
+ 5.7873535156250003e-05 5.2710524922400013e-11
+ 5.7885742187500001e-05 5.2762976233740464e-11
+ 5.789794921875e-05 5.281541285584085e-11
+ 5.7910156250000005e-05 5.2867834792814952e-11
+ 5.7922363281250004e-05 5.2920242048775429e-11
+ 5.7934570312500003e-05 5.297263462783375e-11
+ 5.7946777343750001e-05 5.3025012534100265e-11
+ 5.7958984375e-05 5.3077375771684144e-11
+ 5.7971191406249999e-05 5.3129724344693429e-11
+ 5.7983398437500004e-05 5.3182058257235008e-11
+ 5.7995605468750003e-05 5.3234377513414598e-11
+ 5.8007812500000001e-05 5.3286682117336819e-11
+ 5.802001953125e-05 5.3338972073105086e-11
+ 5.8032226562499999e-05 5.339124738482168e-11
+ 5.8044433593750004e-05 5.3443508056587737e-11
+ 5.8056640625000003e-05 5.349575409250326e-11
+ 5.8068847656250001e-05 5.3547985496667078e-11
+ 5.80810546875e-05 5.3600202273176877e-11
+ 5.8093261718749999e-05 5.3652404426129203e-11
+ 5.8105468749999997e-05 5.3704591959619454e-11
+ 5.8117675781250003e-05 5.3756764877741888e-11
+ 5.8129882812500001e-05 5.3808923184589598e-11
+ 5.814208984375e-05 5.3861066884254534e-11
+ 5.8154296874999999e-05 5.3913195980827531e-11
+ 5.8166503906249997e-05 5.3965310478398236e-11
+ 5.8178710937500003e-05 5.4017410381055188e-11
+ 5.8190917968750002e-05 5.4069495692885746e-11
+ 5.8203125e-05 5.4121566417976143e-11
+ 5.8215332031249999e-05 5.4173622560411455e-11
+ 5.8227539062499998e-05 5.4225664124275648e-11
+ 5.8239746093750003e-05 5.4277691113651499e-11
+ 5.8251953125000002e-05 5.4329703532620677e-11
+ 5.826416015625e-05 5.4381701385263697e-11
+ 5.8276367187499999e-05 5.4433684675659917e-11
+ 5.8288574218749998e-05 5.4485653407887576e-11
+ 5.8300781250000003e-05 5.4537607586023745e-11
+ 5.8312988281250002e-05 5.4589547214144361e-11
+ 5.83251953125e-05 5.4641472296324253e-11
+ 5.8337402343749999e-05 5.4693382836637059e-11
+ 5.8349609374999998e-05 5.4745278839155299e-11
+ 5.8361816406249996e-05 5.4797160307950356e-11
+ 5.8374023437500002e-05 5.4849027247092475e-11
+ 5.838623046875e-05 5.4900879660650734e-11
+ 5.8398437499999999e-05 5.4952717552693121e-11
+ 5.8410644531249998e-05 5.5004540927286431e-11
+ 5.8422851562499996e-05 5.5055228596414379e-11
+ 5.8435058593750002e-05 5.510627065877697e-11
+ 5.8447265625e-05 5.5158092921228189e-11
+ 5.8459472656249999e-05 5.5210849104087091e-11
+ 5.8471679687499998e-05 5.5264521350196526e-11
+ 5.8483886718749996e-05 5.5318219478297029e-11
+ 5.8489990234374996e-05 5.5343709041866146e-11
+ 5.8496093749999995e-05 5.5365175813779936e-11
+ 5.8499145507812501e-05 5.537183500008943e-11
+ 5.8502197265625001e-05 5.5371668509114686e-11
+ 5.8505249023437501e-05 5.5354771851498252e-11
+ 5.8506606790774093e-05 5.5334751403020664e-11
+ 5.8506998216660865e-05 5.5326313558461538e-11
+ 5.8507389642547638e-05 5.5316205768572161e-11
+ 5.8508368207264581e-05 5.5280832763072969e-11
+ 5.8509409502908191e-05 5.5216998316807767e-11
+ 5.8509970598735327e-05 5.5162661637241072e-11
+ 5.8510339629298372e-05 5.5114439869388932e-11
+ 5.8511110323815848e-05 5.4960015216721681e-11
+ 5.8511741481233851e-05 5.4732817211499076e-11
+ 5.8512113084009013e-05 5.4516300482441227e-11
+ 5.8512434193795797e-05 5.42419953316085e-11
+ 5.8512647097925413e-05 5.400886072195258e-11
+ 5.8512860002055035e-05 5.3774257755821461e-11
+ 5.8514989043351249e-05 5.1549852354822979e-11
+ 5.8527196074601248e-05 4.2855387214314058e-11
+ 5.8539403105851246e-05 4.053247294954365e-11
+ 5.8551610137101252e-05 4.3931039996784842e-11
+ 5.8563817168351251e-05 5.2388572167819672e-11
+ 5.8576024199601249e-05 6.5140225940715896e-11
+ 5.8588231230851248e-05 8.1286621114128428e-11
+ 5.8600438262101246e-05 9.9800201152591339e-11
+ 5.8612645293351252e-05 1.1955731974057662e-10
+ 5.8624852324601251e-05 1.3938677731239894e-10
+ 5.8637059355851249e-05 1.581275910662053e-10
+ 5.8649266387101248e-05 1.7469004130247602e-10
+ 5.8661473418351247e-05 1.881149150311095e-10
+ 5.8673680449601245e-05 1.9762660690176225e-10
+ 5.8685887480851251e-05 2.026764694324815e-10
+ 5.8698094512101249e-05 2.0297359093770258e-10
+ 5.8710301543351248e-05 1.9850103705845601e-10
+ 5.8722508574601247e-05 1.8951650785639057e-10
+ 5.8734715605851245e-05 1.7653730627935789e-10
+ 5.8746922637101251e-05 1.6031044421422816e-10
+ 5.8759129668351249e-05 1.4176958358946107e-10
+ 5.8771336699601248e-05 1.2198127662112241e-10
+ 5.8783543730851247e-05 1.0208359001036545e-10
+ 5.8795750762101245e-05 8.3220638681385549e-11
+ 5.8807957793351244e-05 6.6476791169901555e-11
+ 5.881100955116375e-05 6.2738216402259133e-11
+ 5.8811314726944996e-05 6.2375524734021021e-11
+ 5.8812077666398126e-05 6.1477937832984702e-11
+ 5.8812459136124687e-05 6.1034090082773124e-11
+ 5.8812482977982591e-05 6.1006459924724939e-11
+ 5.8812487746354175e-05 6.1000935454857881e-11
+ 5.8812497283097342e-05 6.0989888077255491e-11
+ 5.8812498046036791e-05 6.0989004377034889e-11
+ 5.8812499571915701e-05 6.0987237016591268e-11
+ 5.881249969398601e-05 6.0987095630059761e-11
+ 5.8812499938126635e-05 6.0986812858020706e-11
+ 5.8812499957657887e-05 6.0986790236316644e-11
+ 5.881249999672039e-05 6.098674499293473e-11
+ 5.881250007484539e-05 6.2330481534674083e-11
+ 5.8812500152970389e-05 6.6608198187672893e-11
+ 5.8812500934220386e-05 2.7075208822833839e-10
+ 5.881250805184598e-05 1.5641542586395462e-08
+ 5.8812515169471575e-05 5.5354276368357439e-08
+ 5.8812522287097176e-05 1.1939590331347595e-07
+ 5.881252940472277e-05 2.0774988808958391e-07
+ 5.8812536522348364e-05 3.2039621340029153e-07
+ 5.8812543639973958e-05 4.5731138406416947e-07
+ 5.881255075759956e-05 6.1846843192454422e-07
+ 5.8812557875225154e-05 8.0383692158836119e-07
+ 5.8812564992850748e-05 1.0133829569922963e-06
+ 5.8812572110476349e-05 1.2470691887940203e-06
+ 5.8812579228101943e-05 1.5048548225862434e-06
+ 5.8812587807568575e-05 1.8475543476526228e-06
+ 5.8812596387035207e-05 2.2251205386231599e-06
+ 5.8812604966501839e-05 2.637462112110794e-06
+ 5.8812613545968472e-05 3.0844806091734263e-06
+ 5.8812622125435104e-05 3.5660704276185103e-06
+ 5.8812630704901736e-05 4.0821188567621002e-06
+ 5.8812639284368368e-05 4.6325061146258863e-06
+ 5.8812647863835e-05 5.2171053875545835e-06
+ 5.8812658180770253e-05 5.965211217502911e-06
+ 5.8812668497705507e-05 6.7623492313414161e-06
+ 5.8812678814640768e-05 7.6082590651614992e-06
+ 5.8812689131576021e-05 8.5026660760363497e-06
+ 5.8812699448511275e-05 9.4452814742207388e-06
+ 5.8812709765446535e-05 1.0435802462230257e-05
+ 5.8812720082381789e-05 1.147391238070454e-05
+ 5.8812730399317043e-05 1.25592808609545e-05
+ 5.8812742902012265e-05 1.393744004677843e-05
+ 5.8812755404707481e-05 1.538385928477854e-05
+ 5.8812767907402703e-05 1.6897871760843825e-05
+ 5.8812780410097919e-05 1.8478782715895571e-05
+ 5.8812792912793141e-05 2.0125869935940648e-05
+ 5.8812805415488357e-05 2.1838384260846487e-05
+ 5.881281791818358e-05 2.3615550111329756e-05
+ 5.8812830420878795e-05 2.5456566033633845e-05
+ 5.8812845592253877e-05 2.7775100207116592e-05
+ 5.8812860763628958e-05 3.0184906039223483e-05
+ 5.881287593500404e-05 3.2684405463249104e-05
+ 5.8812891106379121e-05 3.5271969973378807e-05
+ 5.8812906277754196e-05 3.7945922288216153e-05
+ 5.8812921449129278e-05 4.0704538058428326e-05
+ 5.8812936620504359e-05 4.3546047616054653e-05
+ 5.8812954860519563e-05 4.7069469432613542e-05
+ 5.8812973100534775e-05 5.0706855826657106e-05
+ 5.8812991340549979e-05 5.4454893918205257e-05
+ 5.881300958056519e-05 5.8310193146384224e-05
+ 5.8813027820580394e-05 6.2269290123695639e-05
+ 5.8813046060595599e-05 6.6328653564053143e-05
+ 5.8813068199865847e-05 7.1385338233594827e-05
+ 5.8813090339136095e-05 7.6577901326810804e-05
+ 5.881311247840635e-05 8.189969012601315e-05
+ 5.8813134617676599e-05 8.7343953274172687e-05
+ 5.8813161293011324e-05 9.4056657818521804e-05
+ 5.8813187873095811e-05 0.00010090035482762358
+ 5.8813214453180299e-05 0.00010788664307091889
+ 5.8813248688484344e-05 0.00011707548567577072
+ 5.8813282923788388e-05 0.00012645461865043843
+ 5.881331535612705e-05 0.00013549167951766453
+ 5.8813347788465718e-05 0.00014465398332574899
+ 5.881338022080438e-05 0.00015391958689944246
+ 5.8813412653143041e-05 0.00016326679416820027
+ 5.8813445085481709e-05 0.00017267423453976973
+ 5.8813477517820371e-05 0.00018212093762926101
+ 5.8813509950159032e-05 0.00019158640400330904
+ 5.8813542382497701e-05 0.00020105067163597072
+ 5.8813569584998152e-05 0.00020897371829601134
+ 5.8813596787498604e-05 0.00021687121736840308
+ 5.8813623989999056e-05 0.0002247324443841368
+ 5.8813651192499508e-05 0.00023254704172942061
+ 5.8813678394999966e-05 0.00024030503688061725
+ 5.8813705597500418e-05 0.00024799685880477063
+ 5.881373280000087e-05 0.00025561335251051022
+ 5.8813760002501329e-05 0.00026314579174345146
+ 5.8813787205001781e-05 0.00027058588982929906
+ 5.8813814407502232e-05 0.00027792580867665878
+ 5.8813841610002684e-05 0.0002851581659600263
+ 5.8813868812503136e-05 0.00029227604051150784
+ 5.8813896015003595e-05 0.00029927297595749906
+ 5.8813923217504047e-05 0.00030614298264376868
+ 5.8813950420004498e-05 0.00031288053789913813
+ 5.8813977622504957e-05 0.00031948058469418605
+ 5.8814004825005409e-05 0.00032593852875712024
+ 5.8814032027505861e-05 0.00033225023421413059
+ 5.8814059230006313e-05 0.00033841201782615327
+ 5.8814086432506764e-05 0.0003444206418985982
+ 5.8814115300883502e-05 0.00035062659892727544
+ 5.8814144169260239e-05 0.0003566540934654631
+ 5.881417303763697e-05 0.00036250083298786399
+ 5.8814201906013708e-05 0.00036816503744223664
+ 5.8814230774390445e-05 0.00037364542226806104
+ 5.8814259642767176e-05 0.00037894118026981165
+ 5.8814288511143913e-05 0.00038405196247931109
+ 5.8814317379520651e-05 0.000388977858140999
+ 5.8814346247897381e-05 0.00039371937395252178
+ 5.8814381135166691e-05 0.0003992047348763101
+ 5.8814416022435993e-05 0.00040442447430172904
+ 5.8814449985506054e-05 0.00040925368585940502
+ 5.8814483948576115e-05 0.00041383750344981278
+ 5.8814517911646183e-05 0.00041817993390062743
+ 5.8814551874716244e-05 0.00042228549548244641
+ 5.8814585837786305e-05 0.00042615916749456922
+ 5.8814627381082825e-05 0.0004305900119691504
+ 5.8814668924379338e-05 0.00043469258490726371
+ 5.881471046767585e-05 0.0004384781612780042
+ 5.881475201097237e-05 0.00044195857402361564
+ 5.8814802322523106e-05 0.00044578261210212054
+ 5.8814853125173638e-05 0.00044923093231022854
+ 5.8814903927824176e-05 0.00045228765276156626
+ 5.8814971607266251e-05 0.00045579239535176001
+ 5.8815039286708325e-05 0.00045870005395461338
+ 5.8815091919396572e-05 0.00046058369469111949
+ 5.8815144552084819e-05 0.00046216451732223918
+ 5.8815197184773059e-05 0.00046346681282214352
+ 5.8815249817461306e-05 0.00046451393123718372
+ 5.8815297809929107e-05 0.00046526519657479943
+ 5.8815345802396909e-05 0.00046583893527304737
+ 5.8815393794864717e-05 0.00046625041073407677
+ 5.8815441787332518e-05 0.00046651403875466578
+ 5.881548977980032e-05 0.0004666433740508164
+ 5.8815537261554871e-05 0.00046665162291553914
+ 5.8815584743309415e-05 0.000466552308242554
+ 5.8815632225063966e-05 0.00046635608374731292
+ 5.8815679706818517e-05 0.00046607281339991539
+ 5.8815727188573062e-05 0.00046571159614456351
+ 5.8815774670327613e-05 0.00046528079492301239
+ 5.8815824358583368e-05 0.00046476378468933915
+ 5.8815874046839129e-05 0.00046418694952370777
+ 5.8815923735094884e-05 0.00046355752837163748
+ 5.8815973423350638e-05 0.00046288205221083837
+ 5.88160231116064e-05 0.00046216639229460844
+ 5.8816072799862154e-05 0.00046141580830294233
+ 5.881612795138608e-05 0.00046054748419045071
+ 5.8816183102910005e-05 0.00045964758393211987
+ 5.881623825443393e-05 0.00045872107390199996
+ 5.8816293405957856e-05 0.00045777228079549998
+ 5.8816348557481788e-05 0.00045680495887963081
+ 5.8816411640520546e-05 0.000455679953428722
+ 5.8816474723559305e-05 0.00045453907391423655
+ 5.8816537806598064e-05 0.0004533857886546739
+ 5.8816600889636823e-05 0.00045222299034028662
+ 5.881667414014643e-05 0.00045086399130210022
+ 5.8816747390656038e-05 0.00044949844535668453
+ 5.8816820641165645e-05 0.00044812878579885432
+ 5.8816905619421591e-05 0.00044653719761490697
+ 5.8816990597677529e-05 0.0004449449586312652
+ 5.8817093836844791e-05 0.00044301214871122791
+ 5.8817198171769416e-05 0.00044106269601017851
+ 5.8817302506694047e-05 0.00043911870626636078
+ 5.8817426664469166e-05 0.00043681393387383496
+ 5.8817550822244292e-05 0.00043451951813961668
+ 5.8817705800806535e-05 0.00043167106196547318
+ 5.8817884937131789e-05 0.00042840086834201771
+ 5.8818098556602392e-05 0.00042453293757745131
+ 5.881836448572296e-05 0.00041976628303681877
+ 5.8818717982712209e-05 0.00041351261779238365
+ 5.8819242097564151e-05 0.00040441158298440465
+ 5.8820136340120477e-05 0.00038934346113524376
+ 5.8822132807185043e-05 0.00035769765454050228
+ 5.882398881685802e-05 0.00033058981538904275
+ 5.8826421668443085e-05 0.00029814348467284587
+ 5.8828854520028149e-05 0.00026888165874455468
+ 5.8831287371613213e-05 0.00024249178888257299
+ 5.8833720223198278e-05 0.00021869200206866874
+ 5.8836153074783335e-05 0.00019722808975099272
+ 5.8838585926368399e-05 0.00017787079297825666
+ 5.8841018777953464e-05 0.00016041335425741158
+ 5.8843451629538528e-05 0.0001446693086575522
+ 5.8845767705239782e-05 0.00013111903917235234
+ 5.8848819440406721e-05 0.00011518312547724692
+ 5.8851871175573666e-05 0.00010118403045864018
+ 5.8854922910740604e-05 8.8886357108097517e-05
+ 5.8857974645907542e-05 7.8083318131395906e-05
+ 5.8861026381074481e-05 6.8593258842393536e-05
+ 5.8864078116241419e-05 6.025660181923537e-05
+ 5.8867773618773606e-05 5.1505809187250614e-05
+ 5.8871134288610911e-05 4.4656271026532631e-05
+ 5.8874494958448223e-05 3.8717628008379948e-05
+ 5.8878620731690286e-05 3.2495702272495222e-05
+ 5.8882746504932342e-05 2.7273646663031209e-05
+ 5.8886872278174399e-05 2.2890780980831938e-05
+ 5.8890998051416462e-05 1.9212246512347876e-05
+ 5.8895123824658519e-05 1.6124856494297113e-05
+ 5.8900251138437102e-05 1.2970141364146993e-05
+ 5.8905378452215685e-05 1.0432633172092827e-05
+ 5.8910505765994268e-05 8.3915781182774641e-06
+ 5.8915633079772851e-05 6.7498471833962207e-06
+ 5.8921995979825158e-05 5.1518189724579756e-06
+ 5.8928358879877465e-05 3.9321378049054371e-06
+ 5.8934721779929772e-05 3.0012267671564931e-06
+ 5.8942497256254516e-05 2.15737185496337e-06
+ 5.8950272732579254e-05 1.5508026051292012e-06
+ 5.8958048208903998e-05 1.1147960586695601e-06
+ 5.8967983441936075e-05 7.3118840550782522e-07
+ 5.8977918674968144e-05 4.7961075194826108e-07
+ 5.8990125706218149e-05 2.8571159964289929e-07
+ 5.9002332737468148e-05 1.7024209705967684e-07
+ 5.9014539768718147e-05 1.0147848625806179e-07
+ 5.9026746799968145e-05 6.0528851952355526e-08
+ 5.9038953831218144e-05 3.6142806128821739e-08
+ 5.9051160862468149e-05 2.1620593980565466e-08
+ 5.9063367893718148e-05 1.2972424953734794e-08
+ 5.9075574924968147e-05 7.8223266739669589e-09
+ 5.9087781956218145e-05 4.7553755500354248e-09
+ 5.9099988987468144e-05 2.9289656540459339e-09
+ 5.9112196018718143e-05 1.8413143839828223e-09
+ 5.9124403049968148e-05 1.1936037658401295e-09
+ 5.9136610081218147e-05 8.078836241498485e-10
+ 5.9148817112468145e-05 5.7818218790680653e-10
+ 5.9161024143718144e-05 4.4139192644487092e-10
+ 5.9173231174968143e-05 3.5993152647751398e-10
+ 5.9185438206218148e-05 3.1142080027758294e-10
+ 5.9197645237468147e-05 2.8253202431124535e-10
+ 5.9209852268718145e-05 2.653283707170538e-10
+ 5.9222059299968144e-05 2.5508336753526945e-10
+ 5.9234266331218143e-05 2.4898233649178344e-10
+ 5.9246473362468148e-05 2.4534909287155193e-10
+ 5.9258680393718147e-05 2.4318544696123555e-10
+ 5.9270887424968146e-05 2.4189696683490067e-10
+ 5.9283094456218144e-05 2.411296605642883e-10
+ 5.9295301487468143e-05 2.406727199550333e-10
+ 5.9307508518718148e-05 2.4040060549918595e-10
+ 5.9319715549968147e-05 2.4023855751768804e-10
+ 5.9331922581218146e-05 2.4014205601586099e-10
+ 5.9344129612468144e-05 2.4008458822552009e-10
+ 5.9356336643718143e-05 2.4005036536744095e-10
+ 5.9368543674968142e-05 2.4002998505548136e-10
+ 5.9380750706218147e-05 2.4001784836154639e-10
+ 5.9392957737468146e-05 2.4001062082534474e-10
+ 5.9405164768718144e-05 2.4000631674323626e-10
+ 5.9417371799968143e-05 2.4000375361391963e-10
+ 5.9429578831218142e-05 2.4000222718017004e-10
+ 5.9441785862468147e-05 2.4000131819356677e-10
+ 5.9453992893718146e-05 2.4000077702242996e-10
+ 5.9466199924968144e-05 2.4000045459933931e-10
+ 5.9478406956218143e-05 2.4000026257884156e-10
+ 5.9490613987468142e-05 2.4000014832025053e-10
+ 5.950282101871814e-05 2.4000008023582484e-10
+ 5.9515028049968146e-05 2.4000003966625581e-10
+ 5.9527235081218144e-05 2.400000155533385e-10
+ 5.9539442112468143e-05 2.4000000121814107e-10
+ 5.9551649143718142e-05 2.3999999261673205e-10
+ 5.956385617496814e-05 2.3999998758456908e-10
+ 5.9576063206218146e-05 2.3999998453222656e-10
+ 5.9588270237468144e-05 2.3999998265390494e-10
+ 5.9600477268718143e-05 2.3999998161732485e-10
+ 5.9612684299968142e-05 2.3999998104358188e-10
+ 5.962489133121814e-05 2.3999998057389865e-10
+ 5.9637098362468146e-05 2.3999998026292464e-10
+ 5.9649305393718145e-05 2.3999998019001177e-10
+ 5.9661512424968143e-05 2.3999998019899801e-10
+ 5.9673719456218142e-05 2.3999998020597388e-10
+ 5.968592648746814e-05 2.3999998012855701e-10
+ 5.9698133518718146e-05 2.3999998005534517e-10
+ 5.9710340549968145e-05 2.3999998008389102e-10
+ 5.9722547581218143e-05 2.3999998009224399e-10
+ 5.9734754612468142e-05 2.3999998012219294e-10
+ 5.9746961643718141e-05 2.3999998013282356e-10
+ 5.9759168674968139e-05 2.3999998009115475e-10
+ 5.9771375706218145e-05 2.3999998009706464e-10
+ 5.9783582737468143e-05 2.3999998010363494e-10
+ 5.9795789768718142e-05 2.3999998011314167e-10
+ 5.9807996799968141e-05 2.3999998013616955e-10
+ 5.9820203831218139e-05 2.3999998011363462e-10
+ 5.9832410862468145e-05 2.3999998009274014e-10
+ 5.9844617893718143e-05 2.399999801011231e-10
+ 5.9856824924968142e-05 2.399999800977465e-10
+ 5.9869031956218141e-05 2.3999998010717031e-10
+ 5.9881238987468139e-05 2.3999998026497155e-10
+ 5.9893446018718138e-05 2.3999998018940695e-10
+ 5.9905653049968143e-05 2.399999801489314e-10
+ 5.9917860081218142e-05 2.3999998016252337e-10
+ 5.9930067112468141e-05 2.3999998017736873e-10
+ 5.9942274143718139e-05 2.3999998008841631e-10
+ 5.9954481174968138e-05 2.399999801406156e-10
+ 5.9966688206218143e-05 2.3999998027111368e-10
+ 5.9978895237468142e-05 2.399999803096209e-10
+ 5.9991102268718141e-05 2.399999801745041e-10
+ 6.0003309299968139e-05 2.3999998014351678e-10
+ 6.0015516331218138e-05 2.399999802735929e-10
+ 6.0027723362468144e-05 2.3999998026179471e-10
+ 6.0039930393718142e-05 2.3999998016976751e-10
+ 6.0052137424968141e-05 2.3999998022820648e-10
+ 6.0064344456218139e-05 2.3999998018386391e-10
+ 6.0076551487468138e-05 2.3999998024457121e-10
+ 6.0088758518718144e-05 2.399999802712344e-10
+ 6.0100965549968142e-05 2.3999998016906244e-10
+ 6.0113172581218141e-05 2.399999802251944e-10
+ 6.012537961246814e-05 2.3999998029674961e-10
+ 6.0137586643718145e-05 2.3999998024490881e-10
+ 6.0149793674968144e-05 2.3999998022841694e-10
+ 6.0162000706218142e-05 2.3999998027402318e-10
+ 6.0174207737468141e-05 2.3999998031284179e-10
+ 6.0186414768718146e-05 2.3999998024592236e-10
+ 6.0198621799968145e-05 2.3999998028900653e-10
+ 6.0210828831218144e-05 2.3999998029018118e-10
+ 6.0223035862468142e-05 2.3999998020407995e-10
+ 6.0235242893718148e-05 2.3999998030027903e-10
+ 6.0247449924968146e-05 2.3999998034659856e-10
+ 6.0259656956218145e-05 2.3999998035710371e-10
+ 6.0271863987468144e-05 2.3999998035781327e-10
+ 6.0284071018718149e-05 2.3999998028429372e-10
+ 6.0296278049968148e-05 2.3999998026462584e-10
+ 6.0308485081218146e-05 2.3999998034401652e-10
+ 6.0320692112468145e-05 2.3999998040748526e-10
+ 6.0332899143718151e-05 2.399999802904164e-10
+ 6.0345106174968149e-05 2.3999998026488739e-10
+ 6.0357313206218148e-05 2.399999803948264e-10
+ 6.0369520237468147e-05 2.399999803901337e-10
+ 6.0381727268718152e-05 2.3999998030809217e-10
+ 6.0393934299968151e-05 2.3999998036169063e-10
+ 6.0406141331218149e-05 2.3999998033495331e-10
+ 6.0418348362468148e-05 2.3999998039429674e-10
+ 6.0430555393718153e-05 2.3999998043834603e-10
+ 6.0442762424968152e-05 2.3999998042747548e-10
+ 6.0454969456218151e-05 2.3999998033813589e-10
+ 6.0467176487468149e-05 2.3999998042749197e-10
+ 6.0479383518718155e-05 2.3999998045576412e-10
+ 6.0491590549968153e-05 2.3999998040668088e-10
+ 6.0503797581218152e-05 2.3999998041015307e-10
+ 6.0516004612468151e-05 2.3999998038280188e-10
+ 6.0528211643718156e-05 2.399999804963409e-10
+ 6.0540418674968155e-05 2.3999998050724164e-10
+ 6.0552625706218153e-05 2.3999998043757132e-10
+ 6.0564832737468152e-05 2.3999998042873677e-10
+ 6.0577039768718158e-05 2.3999998048062938e-10
+ 6.0589246799968156e-05 2.3999998046244087e-10
+ 6.0601453831218155e-05 2.3999998047367506e-10
+ 6.0613660862468154e-05 2.3999998045481209e-10
+ 6.0625867893718159e-05 2.3999998043752122e-10
+ 6.0638074924968158e-05 2.3999998042446345e-10
+ 6.0650281956218156e-05 2.3999998041722252e-10
+ 6.0662488987468155e-05 2.3999998041674074e-10
+ 6.067469601871816e-05 2.3999998042357827e-10
+ 6.0686903049968159e-05 2.3999998043806778e-10
+ 6.0699110081218158e-05 2.3999998047660411e-10
+ 6.0711317112468156e-05 2.3999998051655456e-10
+ 6.0723524143718162e-05 2.3999998052591767e-10
+ 6.073573117496816e-05 2.3999998048427911e-10
+ 6.0747938206218159e-05 2.3999998054712477e-10
+ 6.0760145237468158e-05 2.3999998057013456e-10
+ 6.0772352268718163e-05 2.3999998051176627e-10
+ 6.0784559299968162e-05 2.3999998057450993e-10
+ 6.079676633121816e-05 2.3999998053652084e-10
+ 6.0808973362468159e-05 2.3999998056705243e-10
+ 6.0821180393718165e-05 2.399999805326457e-10
+ 6.0833387424968163e-05 2.399999805718764e-10
+ 6.0845594456218162e-05 2.3999998054921403e-10
+ 6.0857801487468161e-05 2.3999998061819825e-10
+ 6.0870008518718166e-05 2.399999805688973e-10
+ 6.0882215549968165e-05 2.3999998054792621e-10
+ 6.0894422581218163e-05 2.39999980627754e-10
+ 6.0906629612468162e-05 2.3999998059474422e-10
+ 6.0918836643718167e-05 2.399999805933057e-10
+ 6.0931043674968166e-05 2.3999998057922352e-10
+ 6.0943250706218165e-05 2.3999998056088616e-10
+ 6.0955457737468163e-05 2.3999998058786213e-10
+ 6.0967664768718169e-05 2.399999806005213e-10
+ 6.0979871799968167e-05 2.3999998060792622e-10
+ 6.0992078831218166e-05 2.3999998061547279e-10
+ 6.1004285862468165e-05 2.3999998062637359e-10
+ 6.101649289371817e-05 2.3999998064254068e-10
+ 6.1028699924968169e-05 2.399999806651119e-10
+ 6.1040906956218174e-05 2.3999998065019003e-10
+ 6.1053113987468173e-05 2.3999998066078063e-10
+ 6.1065321018718172e-05 2.399999807158811e-10
+ 6.107752804996817e-05 2.3999998065933043e-10
+ 6.1089735081218169e-05 2.3999998069949765e-10
+ 6.1101942112468168e-05 2.3999998071137632e-10
+ 6.1114149143718166e-05 2.3999998066492584e-10
+ 6.1126356174968165e-05 2.3999998067631891e-10
+ 6.1138563206218177e-05 2.3999998068067386e-10
+ 6.1150770237468176e-05 2.3999998072884115e-10
+ 6.1162977268718174e-05 2.3999998071703879e-10
+ 6.1175184299968173e-05 2.399999807620995e-10
+ 6.1187391331218172e-05 2.3999998071038665e-10
+ 6.119959836246817e-05 2.3999998068359319e-10
+ 6.1211805393718169e-05 2.3999998073934671e-10
+ 6.1224012424968168e-05 2.3999998074833904e-10
+ 6.123621945621818e-05 2.3999998072288318e-10
+ 6.1248426487468178e-05 2.3999998078919143e-10
+ 6.1260633518718177e-05 2.3999998076965073e-10
+ 6.1272840549968176e-05 2.399999807468099e-10
+ 6.1285047581218174e-05 2.3999998076982682e-10
+ 6.1297254612468173e-05 2.3999998077882701e-10
+ 6.1309461643718172e-05 2.3999998078272732e-10
+ 6.132166867496817e-05 2.3999998077698307e-10
+ 6.1333875706218183e-05 2.3999998078844893e-10
+ 6.1346082737468181e-05 2.3999998080355428e-10
+ 6.135828976871818e-05 2.3999998082407074e-10
+ 6.1370496799968179e-05 2.3999998085105249e-10
+ 6.1382703831218177e-05 2.3999998076975625e-10
+ 6.1394910862468176e-05 2.399999808033618e-10
+ 6.1407117893718175e-05 2.3999998080328762e-10
+ 6.1419324924968173e-05 2.3999998084082399e-10
+ 6.1431531956218185e-05 2.3999998077877215e-10
+ 6.1443738987468184e-05 2.3999998083679345e-10
+ 6.1455946018718183e-05 2.3999998087406507e-10
+ 6.1468153049968181e-05 2.3999998083776306e-10
+ 6.148036008121818e-05 2.3999998086990843e-10
+ 6.1492567112468179e-05 2.3999998083702247e-10
+ 6.1504774143718177e-05 2.399999808776692e-10
+ 6.1516981174968176e-05 2.3999998085631119e-10
+ 6.1529188206218188e-05 2.3999998083949021e-10
+ 6.1541395237468187e-05 2.3999929577393646e-10
+ 6.1553602268718186e-05 2.3999721430085655e-10
+ 6.1565809299968184e-05 2.3999541801853927e-10
+ 6.1578016331218183e-05 2.3999352441667849e-10
+ 6.1590223362468181e-05 2.3998998231508299e-10
+ 6.160243039371818e-05 2.3998269751518182e-10
+ 6.1614637424968179e-05 2.3996731785187146e-10
+ 6.1620740940593192e-05 2.3994983464395233e-10
+ 6.1626844456218191e-05 2.3990674100743305e-10
+ 6.1629896214030684e-05 2.3985615585153402e-10
+ 6.163294797184319e-05 2.3973456609508262e-10
+ 6.1634473850749437e-05 2.3959023649420816e-10
+ 6.1635999729655683e-05 2.3924487360909957e-10
+ 6.163699110688919e-05 2.3866252493064795e-10
+ 6.1637269733896249e-05 2.3836567845599657e-10
+ 6.1637548360903309e-05 2.3795958755937176e-10
+ 6.1638098835627977e-05 2.3707317678626589e-10
+ 6.1640875273912443e-05 2.3289947932096134e-10
+ 6.1653082305162442e-05 2.1857108082062022e-10
+ 6.1665289336412441e-05 2.0744394567167327e-10
+ 6.1677496367662439e-05 1.9657101424192844e-10
+ 6.1689703398912438e-05 1.8444183633608339e-10
+ 6.1701910430162437e-05 1.7048236032410772e-10
+ 6.1714117461412435e-05 1.5473832156939622e-10
+ 6.1726324492662448e-05 1.376643966131987e-10
+ 6.1738531523912446e-05 1.1997405552563603e-10
+ 6.1750738555162445e-05 1.0252468847149855e-10
+ 6.1762945586412444e-05 8.622433036431135e-11
+ 6.1775152617662442e-05 7.1953269034585456e-11
+ 6.1787359648912441e-05 6.0497851486217764e-11
+ 6.179956668016244e-05 5.2496010132610782e-11
+ 6.1811773711412452e-05 4.8395088933560857e-11
+ 6.182398074266245e-05 4.8422873289603413e-11
+ 6.1836187773912449e-05 5.2572582289997926e-11
+ 6.1848394805162448e-05 6.0602144636946106e-11
+ 6.1860601836412446e-05 7.2047475992215135e-11
+ 6.1872808867662445e-05 8.6248800170538565e-11
+ 6.1885015898912444e-05 1.0238838404643464e-10
+ 6.1897222930162442e-05 1.19537446121802e-10
+ 6.1909429961412441e-05 1.367094991032434e-10
+ 6.1921636992662453e-05 1.5291703382970249e-10
+ 6.1933844023912452e-05 1.6722827017382802e-10
+ 6.1936895781724945e-05 1.7041028620342427e-10
+ 6.1937048369615577e-05 1.7056469761267313e-10
+ 6.1937429839342139e-05 1.7094872387604414e-10
+ 6.1937467986314794e-05 1.7098696858623529e-10
+ 6.1937475615709319e-05 1.7099461407315297e-10
+ 6.1937490874498384e-05 1.7100990159048815e-10
+ 6.1937496978014013e-05 1.7101601530675094e-10
+ 6.1937499419420261e-05 1.7101846058671687e-10
+ 6.1937499604455788e-05 1.7101864591102341e-10
+ 6.1937499974526841e-05 1.710190165576025e-10
+ 6.1937500714668946e-05 2.9362295535076986e-10
+ 6.1937501454811065e-05 6.7955376462053112e-10
+ 6.1937508856232148e-05 1.9019685483973129e-08
+ 6.1937516257653245e-05 6.3680162617685321e-08
+ 6.1937523659074328e-05 1.3464578979540883e-07
+ 6.1937531060495424e-05 2.3189729697639808e-07
+ 6.1937538461916507e-05 3.5541134357275011e-07
+ 6.1937547512355698e-05 5.4209487018455778e-07
+ 6.1937556562794875e-05 7.6794744751962639e-07
+ 6.1937565613234052e-05 1.032901665904789e-06
+ 6.1937574663673228e-05 1.3368810846168448e-06
+ 6.1937583714112419e-05 1.6798002590529673e-06
+ 6.1937595044533517e-05 2.1638522289015684e-06
+ 6.1937606374954616e-05 2.7085809274094572e-06
+ 6.1937617705375714e-05 3.3137595140903088e-06
+ 6.1937629035796812e-05 3.9791394372703589e-06
+ 6.1937643214653361e-05 4.8961848891924115e-06
+ 6.1937657393509922e-05 5.9065041934527361e-06
+ 6.1937671572366484e-05 7.0094688242501652e-06
+ 6.1937689032396935e-05 8.4939484121898285e-06
+ 6.1937706492427399e-05 1.011650368403691e-05
+ 6.1937723952457864e-05 1.187564441966631e-05
+ 6.1937746268477841e-05 1.4320324258348367e-05
+ 6.1937768584497803e-05 1.6981891243476683e-05
+ 6.193779090051778e-05 1.9856448881756975e-05
+ 6.1937819090217243e-05 2.3785542948120637e-05
+ 6.1937847279916719e-05 2.8038794641957824e-05
+ 6.1937875469616181e-05 3.2606525910010655e-05
+ 6.1937903659315657e-05 3.7478440563006991e-05
+ 6.193793184901512e-05 4.2643660624918842e-05
+ 6.1937960038714596e-05 4.809076449946518e-05
+ 6.1937988228414072e-05 5.3807826764352856e-05
+ 6.1938019414106474e-05 6.0432058501488789e-05
+ 6.1938050599798889e-05 6.7354141141263776e-05
+ 6.1938081785491305e-05 7.4556149339010216e-05
+ 6.1938112971183707e-05 8.2019674226669682e-05
+ 6.1938150418414339e-05 9.1300740447793598e-05
+ 6.1938187865644972e-05 0.00010089852928503813
+ 6.1938225312875605e-05 0.00011077933330704341
+ 6.1938270844195815e-05 0.00012312530862772575
+ 6.1938316375516025e-05 0.00013577798574481139
+ 6.1938361906836234e-05 0.00014867616552750304
+ 6.1938407438156444e-05 0.00016175929991125412
+ 6.1938441084028123e-05 0.00017151113091571656
+ 6.1938474729899775e-05 0.00018130797963939794
+ 6.1938508375771454e-05 0.00019112690048319055
+ 6.1938542021643106e-05 0.000200945563836072
+ 6.1938575667514785e-05 0.0002107423308290232
+ 6.1938609313386437e-05 0.00022049632214156449
+ 6.1938642959258116e-05 0.00023018748061678874
+ 6.1938676605129768e-05 0.00023979662749408118
+ 6.1938710251001447e-05 0.0002493055121224335
+ 6.193873687066815e-05 0.00025674620625396695
+ 6.1938763490334867e-05 0.00026410519322842072
+ 6.193879011000157e-05 0.00027137476557784006
+ 6.1938816729668287e-05 0.00027854762813939171
+ 6.193884334933499e-05 0.00028561690431054267
+ 6.1938869969001707e-05 0.0002925761407342706
+ 6.193889658866841e-05 0.0002994193104460534
+ 6.1938923208335126e-05 0.00030614081452042582
+ 6.1938949828001843e-05 0.00031273548226053464
+ 6.1938976447668546e-05 0.00031919856997935221
+ 6.1939003067335263e-05 0.00032552575842600295
+ 6.1939029687001966e-05 0.00033171314891500655
+ 6.1939056306668683e-05 0.00033775725822013397
+ 6.1939082926335386e-05 0.00034365501229800138
+ 6.1939109546002102e-05 0.00034940373890948994
+ 6.1939136165668806e-05 0.00035500115920957621
+ 6.1939162785335522e-05 0.00036044537837818884
+ 6.1939189405002239e-05 0.00036573487536628151
+ 6.1939216024668942e-05 0.00037086849183281574
+ 6.1939239404935239e-05 0.00037524816041470616
+ 6.1939262785201522e-05 0.00037950661982143294
+ 6.1939286165467805e-05 0.00038364373347733212
+ 6.1939309545734102e-05 0.00038765955240256639
+ 6.1939332926000385e-05 0.00039155430797307712
+ 6.1939356306266668e-05 0.00039532840450424615
+ 6.1939379686532965e-05 0.00039898241168751826
+ 6.1939403066799248e-05 0.00040251705690861332
+ 6.1939426447065544e-05 0.00040593321747524688
+ 6.1939449827331828e-05 0.0004092319127814815
+ 6.1939473207598111e-05 0.00041241429643495774
+ 6.1939496587864407e-05 0.00041548164837231091
+ 6.193951996813069e-05 0.00041843536698707185
+ 6.1939543348396974e-05 0.00042127696129328835
+ 6.193956672866327e-05 0.00042400804314699181
+ 6.1939590108929553e-05 0.00042663031954648096
+ 6.193961348919585e-05 0.00042914558503120656
+ 6.1939636869462133e-05 0.00043155571419782471
+ 6.1939660249728416e-05 0.00043386265435075173
+ 6.1939683629994713e-05 0.0004360684183033
+ 6.1939707010260996e-05 0.00043817507734421687
+ 6.1939735591237517e-05 0.00044061881915944171
+ 6.1939764172214051e-05 0.00044292160557832261
+ 6.1939792753190571e-05 0.00044508748731897325
+ 6.1939821334167092e-05 0.0004471205811035718
+ 6.1939849915143612e-05 0.00044902505354874717
+ 6.193988619980621e-05 0.00045126415767136695
+ 6.193992545337339e-05 0.00045347065125915753
+ 6.1939946977215263e-05 0.00045458914938144757
+ 6.1939973696714705e-05 0.00045589098737442259
+ 6.1940000416214135e-05 0.00045710004038524538
+ 6.1940027135713578e-05 0.00045821970861944291
+ 6.1940053855213007e-05 0.00045925335947318648
+ 6.194008057471245e-05 0.00046020432082601948
+ 6.1940107294211879e-05 0.00046107587487371744
+ 6.1940134013711322e-05 0.00046187125249194449
+ 6.1940160733210751e-05 0.00046259362811953432
+ 6.1940187452710194e-05 0.00046324611514856153
+ 6.1940214172209623e-05 0.00046383176180687778
+ 6.1940240891709066e-05 0.00046435354751746608
+ 6.1940262548859613e-05 0.00046473161709406521
+ 6.1940284206010173e-05 0.00046507115570231151
+ 6.194030586316072e-05 0.00046537364255429416
+ 6.1940327520311266e-05 0.00046564052306956875
+ 6.1940349177461827e-05 0.00046587320827894959
+ 6.1940370834612373e-05 0.00046607307433484731
+ 6.1940392491762933e-05 0.00046624146212347479
+ 6.194041414891348e-05 0.00046637967697419719
+ 6.1940435806064027e-05 0.00046648898846127722
+ 6.1940457463214587e-05 0.00046657063029325929
+ 6.1940479120365134e-05 0.0004666258002852115
+ 6.1940496765399601e-05 0.00046665198683365781
+ 6.1940514410434083e-05 0.00046666198405394353
+ 6.1940532055468551e-05 0.00046665638716889121
+ 6.1940549700503032e-05 0.00046663577581361698
+ 6.19405673455375e-05 0.00046660071413966874
+ 6.1940584990571981e-05 0.00046655175093608377
+ 6.1940602635606449e-05 0.00046648941976632619
+ 6.1940620280640917e-05 0.00046641423912008399
+ 6.1940637925675398e-05 0.00046632671257892689
+ 6.1940655570709866e-05 0.00046622732899484812
+ 6.1940673215744348e-05 0.00046611656268073646
+ 6.1940690860778815e-05 0.00046599487361184948
+ 6.1940708505813297e-05 0.00046586270763738396
+ 6.1940726150847765e-05 0.00046572049670126538
+ 6.1940743795882246e-05 0.00046556865907130521
+ 6.1940761440916714e-05 0.00046540759957590188
+ 6.1940779085951182e-05 0.00046523770984748908
+ 6.1940796730985663e-05 0.00046505936857196291
+ 6.1940814376020131e-05 0.00046487294174334804
+ 6.1940832021054612e-05 0.00046467878292299136
+ 6.194084966608908e-05 0.00046447723350260048
+ 6.1940867311123562e-05 0.00046426862297047311
+ 6.1940884956158029e-05 0.00046405326918029163
+ 6.1940902601192511e-05 0.00046383147862188659
+ 6.1940920246226979e-05 0.0004636035466933999
+ 6.1940937891261447e-05 0.00046336975797430831
+ 6.1940955536295928e-05 0.00046313038649879376
+ 6.1940973181330396e-05 0.00046288569602897633
+ 6.1940990826364877e-05 0.00046263594032755121
+ 6.1941008471399345e-05 0.00046238136342939871
+ 6.1941026116433826e-05 0.00046212219991176166
+ 6.1941043761468294e-05 0.00046185867516261082
+ 6.1941061406502762e-05 0.00046159100564684353
+ 6.1941079051537243e-05 0.00046131939916998468
+ 6.1941096696571711e-05 0.00046104405513908457
+ 6.1941114341606193e-05 0.00046076516482052872
+ 6.1941131986640661e-05 0.00046048291159450004
+ 6.1941149631675142e-05 0.00046019747120585279
+ 6.194116727670961e-05 0.00045990901201118061
+ 6.1941184921744078e-05 0.00045961769522188066
+ 6.1941202566778559e-05 0.00045932367514303494
+ 6.1941220211813027e-05 0.00045902709940794936
+ 6.1941237856847508e-05 0.00045872810920820898
+ 6.1941255501881976e-05 0.00045842683951912496
+ 6.1941273146916457e-05 0.00045812341932046545
+ 6.1941290791950925e-05 0.00045781797181237863
+ 6.1941308436985407e-05 0.00045751061462643097
+ 6.1941326082019875e-05 0.00045720146003169808
+ 6.1941343727054342e-05 0.00045689061513585962
+ 6.1941361372088824e-05 0.00045657818208126165
+ 6.1941379017123292e-05 0.00045626425823592343
+ 6.1941396662157773e-05 0.0004559489363794755
+ 6.1941414307192241e-05 0.0004556323048840281
+ 6.1941431952226722e-05 0.00045531444788997848
+ 6.194144959726119e-05 0.00045499544547677518
+ 6.1941467242295671e-05 0.00045467537382866608
+ 6.1941484887330139e-05 0.00045435430539546583
+ 6.1941502532364607e-05 0.00045403230904838535
+ 6.1941520177399088e-05 0.00045370945023097327
+ 6.1941537822433556e-05 0.00045338579110522598
+ 6.1941555467468038e-05 0.00045306139069292836
+ 6.1941573112502506e-05 0.00045273630501229328
+ 6.1941590757536987e-05 0.00045241058720997258
+ 6.1941608402571455e-05 0.00045208428768851668
+ 6.1941626047605923e-05 0.00045175745422936376
+ 6.1941643692640404e-05 0.00045143013211144381
+ 6.1941661337674872e-05 0.00045110236422548483
+ 6.1941682620107584e-05 0.00045070649383213837
+ 6.194170274528168e-05 0.00045033166770387813
+ 6.1941722870455791e-05 0.00044995642757493547
+ 6.1941742995629887e-05 0.00044958082330929242
+ 6.1941763120803997e-05 0.00044920490166811688
+ 6.1941783245978094e-05 0.00044882870648050557
+ 6.1941803371152191e-05 0.00044845227880637947
+ 6.1941823496326301e-05 0.00044807565709178331
+ 6.1941843621500398e-05 0.00044769887731683952
+ 6.1941863746674508e-05 0.00044732197313660687
+ 6.1941888110746127e-05 0.00044686556133260454
+ 6.1941912474817759e-05 0.00044640906499999366
+ 6.1941936838889392e-05 0.00044595253182312878
+ 6.1941961202961011e-05 0.00044549600565976083
+ 6.1941985567032644e-05 0.00044503952681690417
+ 6.1942009931104263e-05 0.00044458313230938829
+ 6.1942034295175895e-05 0.00044412685610195336
+ 6.1942058659247528e-05 0.00044367072933572632
+ 6.1942083023319147e-05 0.00044321478053989036
+ 6.194210738739078e-05 0.00044275903582933563
+ 6.1942136719683573e-05 0.00044221066197735565
+ 6.1942166051976366e-05 0.00044166265618977781
+ 6.1942195384269159e-05 0.00044111505229614979
+ 6.1942224716561952e-05 0.000440567880571222
+ 6.1942254048854759e-05 0.0004400211680723513
+ 6.1942283381147552e-05 0.0004394749389480193
+ 6.1942312713440345e-05 0.0004389292147195882
+ 6.1942342045733138e-05 0.00043838401453830063
+ 6.1942377848029202e-05 0.00043771929099924211
+ 6.1942412335454637e-05 0.00043707976746529866
+ 6.1942446822880071e-05 0.00043644103787377733
+ 6.1942481310305506e-05 0.00043580312030283216
+ 6.194251579773094e-05 0.00043516603032572377
+ 6.1942557828321211e-05 0.00043439073279079223
+ 6.1942599858911496e-05 0.00043361670459320404
+ 6.1942641889501767e-05 0.00043284396248195208
+ 6.1942683920092052e-05 0.00043207252012209858
+ 6.1942725950682323e-05 0.00043130238856505936
+ 6.1942777518503422e-05 0.00043035930871672526
+ 6.1942828186666488e-05 0.00042943462880424378
+ 6.1942878854829539e-05 0.00042851188736760037
+ 6.1942929522992604e-05 0.00042759109050169295
+ 6.1942993215143469e-05 0.00042643637215815307
+ 6.1943056907294333e-05 0.0004252847370223043
+ 6.1943120599445198e-05 0.00042413618616643506
+ 6.1943198945610718e-05 0.00042272760989246018
+ 6.1943278657649703e-05 0.00042129925771114857
+ 6.1943358369688674e-05 0.00041987571829712041
+ 6.194346129237077e-05 0.00041804477075287836
+ 6.1943569508909825e-05 0.00041612824858809757
+ 6.1943701914804437e-05 0.00041379527174881443
+ 6.1943847065030192e-05 0.00041125276249577136
+ 6.1944034315235686e-05 0.00040799587225246868
+ 6.1944255865010428e-05 0.00040417569543334638
+ 6.1944554034092504e-05 0.00039909077578923559
+ 6.1944998769870887e-05 0.00039162496079868337
+ 6.1945805003988996e-05 0.00037844492463713218
+ 6.1946711764368316e-05 0.00036415075183872955
+ 6.1947737475686443e-05 0.00034863113834200367
+ 6.1948801143402348e-05 0.00033323544260725887
+ 6.1949944764949554e-05 0.00031744009309453978
+ 6.195223164627892e-05 0.00028806442739914481
+ 6.1954182681216667e-05 0.00026516169925578173
+ 6.1956291228517255e-05 0.00024245284579639417
+ 6.1958581467436163e-05 0.00021998507757767748
+ 6.1960926666850035e-05 0.00019913410083615226
+ 6.1963271866263893e-05 0.00018025945489984468
+ 6.1965590537179629e-05 0.00016335772611693962
+ 6.1968474569484283e-05 0.00014452917890563918
+ 6.1971358601788936e-05 0.00012787080313841811
+ 6.1974242634093576e-05 0.00011313246567173927
+ 6.1977126666398229e-05 0.00010009286360866482
+ 6.1980010698702882e-05 8.8556201336288662e-05
+ 6.1982894731007536e-05 7.8349250567829904e-05
+ 6.1985778763312175e-05 6.9318749243295542e-05
+ 6.1989342797663592e-05 5.9583601550415324e-05
+ 6.1992906832015023e-05 5.12156620124964e-05
+ 6.199647086636644e-05 4.4022919356413453e-05
+ 6.2000034900717857e-05 3.7840328450154061e-05
+ 6.2003598935069274e-05 3.2526023165760874e-05
+ 6.2007899961127367e-05 2.7096692323683933e-05
+ 6.2012200987185461e-05 2.2573641128908005e-05
+ 6.201650201324354e-05 1.8805590756409222e-05
+ 6.2020803039301633e-05 1.5666514280396347e-05
+ 6.2025104065359726e-05 1.3051421554109079e-05
+ 6.203050250598699e-05 1.0377818664489998e-05
+ 6.2035900946614254e-05 8.251909089995107e-06
+ 6.2041299387241518e-05 6.5614966739560858e-06
+ 6.2046697827868781e-05 5.2173688876777125e-06
+ 6.2053468247657469e-05 3.9138135354349389e-06
+ 6.2060238667446157e-05 2.9359531577328348e-06
+ 6.2067009087234844e-05 2.2024124497970242e-06
+ 6.2075385304343964e-05 1.5432541258101081e-06
+ 6.2083761521453069e-05 1.081378721967762e-06
+ 6.2092137738562188e-05 7.5774041132707628e-07
+ 6.2103043385488654e-05 4.7689837631713853e-07
+ 6.2113949032415133e-05 3.0015113649486665e-07
+ 6.2126156063665132e-05 1.7876217937191045e-07
+ 6.2138363094915131e-05 1.0647330757921957e-07
+ 6.2150570126165129e-05 6.3424252544034479e-08
+ 6.2162777157415142e-05 3.7787934734000867e-08
+ 6.217498418866514e-05 2.2521155841269887e-08
+ 6.2187191219915139e-05 1.3429588576020001e-08
+ 6.2199398251165138e-05 8.015449872567151e-09
+ 6.2211605282415136e-05 4.7912734917149069e-09
+ 6.2223812313665135e-05 2.871251600636248e-09
+ 6.2236019344915134e-05 1.7278727196949598e-09
+ 6.2248226376165146e-05 1.0469960699243559e-09
+ 6.2260433407415144e-05 6.4154623608527275e-10
+ 6.2272640438665143e-05 4.0011708092908531e-10
+ 6.2284847469915142e-05 2.563646256420896e-10
+ 6.229705450116514e-05 1.7078006330613652e-10
+ 6.2309261532415139e-05 1.1983532309874618e-10
+ 6.2321468563665138e-05 8.9519095817165878e-11
+ 6.2333675594915136e-05 7.14874426319846e-11
+ 6.2345882626165135e-05 6.0771426293748156e-11
+ 6.2358089657415147e-05 5.4411972164600532e-11
+ 6.2370296688665146e-05 5.0646908151112081e-11
+ 6.2382503719915144e-05 4.8426835103990855e-11
+ 6.2394710751165143e-05 4.7126820532761082e-11
+ 6.2406917782415142e-05 4.6374708016315066e-11
+ 6.241912481366514e-05 4.594887297816922e-11
+ 6.2431331844915139e-05 4.5717334758833713e-11
+ 6.2443538876165151e-05 4.5601496954841019e-11
+ 6.245574590741515e-05 4.5554554261028926e-11
+ 6.2467952938665149e-05 4.5548633436145208e-11
+ 6.2480159969915147e-05 4.5567135561437956e-11
+ 6.2492367001165146e-05 4.5600175741221697e-11
+ 6.2500000000000001e-05 4.5624752229059989e-11
+ 6.251220703125e-05 4.5669966819297461e-11
+ 6.2524414062499999e-05 4.5718898557805248e-11
+ 6.2536621093749997e-05 4.5770037749483043e-11
+ 6.2548828124999996e-05 4.5822485350610839e-11
+ 6.2561035156249995e-05 4.5875705969269391e-11
+ 6.2573242187500007e-05 4.5929380773488921e-11
+ 6.2585449218750005e-05 4.5983319895906806e-11
+ 6.2597656250000004e-05 4.6037410269464089e-11
+ 6.2609863281250003e-05 4.6091584562801975e-11
+ 6.2622070312500001e-05 4.6145802680837535e-11
+ 6.263427734375e-05 4.6200040748086769e-11
+ 6.2646484374999999e-05 4.6254284548072891e-11
+ 6.2658691406249997e-05 4.6308525616398256e-11
+ 6.2670898437499996e-05 4.6362758914111761e-11
+ 6.2683105468749995e-05 4.641698144216514e-11
+ 6.2695312500000007e-05 4.6471191416301583e-11
+ 6.2707519531250006e-05 4.6525387775689795e-11
+ 6.2719726562500004e-05 4.6579569890308451e-11
+ 6.2731933593750003e-05 4.663373738668933e-11
+ 6.2744140625000002e-05 4.6687890044144897e-11
+ 6.275634765625e-05 4.6742027732970226e-11
+ 6.2768554687499999e-05 4.6796150377641402e-11
+ 6.2780761718749997e-05 4.6850257934899579e-11
+ 6.2792968749999996e-05 4.690435038069982e-11
+ 6.2805175781249995e-05 4.695842770243876e-11
+ 6.2817382812500007e-05 4.7012489894326265e-11
+ 6.2829589843750006e-05 4.7066536954629075e-11
+ 6.2841796875000004e-05 4.7120568884029375e-11
+ 6.2854003906250003e-05 4.7174585684647293e-11
+ 6.2866210937500002e-05 4.7228587359458799e-11
+ 6.287841796875e-05 4.728257391194907e-11
+ 6.2890624999999999e-05 4.7336545345906017e-11
+ 6.2902832031249998e-05 4.7390501665297362e-11
+ 6.2915039062499996e-05 4.7444442874197415e-11
+ 6.2927246093749995e-05 4.7498368976743532e-11
+ 6.2939453125000007e-05 4.7552279977110043e-11
+ 6.2951660156250006e-05 4.7606175879492929e-11
+ 6.2963867187500004e-05 4.76600566881005e-11
+ 6.2976074218750003e-05 4.771392240714795e-11
+ 6.2988281250000002e-05 4.7767773040854128e-11
+ 6.300048828125e-05 4.7821608593439534e-11
+ 6.3012695312499999e-05 4.7875429069125182e-11
+ 6.3024902343749998e-05 4.7929234472131972e-11
+ 6.3037109374999996e-05 4.7983024806680162e-11
+ 6.3049316406249995e-05 4.8036800076989225e-11
+ 6.3061523437500007e-05 4.8090560287277661e-11
+ 6.3073730468750006e-05 4.81443054417629e-11
+ 6.3085937500000005e-05 4.8198035544661283e-11
+ 6.3098144531250003e-05 4.8251750600188019e-11
+ 6.3110351562500002e-05 4.8305450612557161e-11
+ 6.312255859375e-05 4.835913558598157e-11
+ 6.3134765624999999e-05 4.8412805524672993e-11
+ 6.3146972656249998e-05 4.846646043284194e-11
+ 6.3159179687499996e-05 4.8520100314697792e-11
+ 6.3171386718749995e-05 4.8573725174448732e-11
+ 6.3183593750000007e-05 4.8627335016301782e-11
+ 6.3195800781250006e-05 4.8680929844462761e-11
+ 6.3208007812500005e-05 4.8734509663136332e-11
+ 6.3220214843750003e-05 4.8788074476525962e-11
+ 6.3232421875000002e-05 4.8841624288833967e-11
+ 6.3244628906250001e-05 4.8895159104261467e-11
+ 6.3256835937499999e-05 4.894867892700839e-11
+ 6.3269042968749998e-05 4.9002183761273549e-11
+ 6.3281249999999997e-05 4.905567361125451e-11
+ 6.3293457031249995e-05 4.9109148481147716e-11
+ 6.3305664062500007e-05 4.9162608375148381e-11
+ 6.3317871093750006e-05 4.9216053297450589e-11
+ 6.3330078125000005e-05 4.9269483252247235e-11
+ 6.3342285156250003e-05 4.932289824373005e-11
+ 6.3354492187500002e-05 4.9376298276089576e-11
+ 6.3366699218750001e-05 4.9429683353515166e-11
+ 6.3378906249999999e-05 4.9483053480195042e-11
+ 6.3391113281249998e-05 4.9536408660316226e-11
+ 6.3403320312499997e-05 4.9589748898064572e-11
+ 6.3415527343750009e-05 4.9643074197624777e-11
+ 6.3427734375000008e-05 4.9696384563180337e-11
+ 6.3439941406250006e-05 4.9749679998913594e-11
+ 6.3452148437500005e-05 4.980296050900572e-11
+ 6.3464355468750004e-05 4.9856226097636712e-11
+ 6.3476562500000002e-05 4.99094767689854e-11
+ 6.3488769531250001e-05 4.9962712527229435e-11
+ 6.3500976562499999e-05 5.0015933376545304e-11
+ 6.3513183593749998e-05 5.0069139321108297e-11
+ 6.3525390624999997e-05 5.0122330365092602e-11
+ 6.3537597656249995e-05 5.0175506512671175e-11
+ 6.3549804687500008e-05 5.0228667768015851e-11
+ 6.3562011718750006e-05 5.0281814135297241e-11
+ 6.3574218750000005e-05 5.0334945618684835e-11
+ 6.3586425781250004e-05 5.0388062222346936e-11
+ 6.3598632812500002e-05 5.0441163950450669e-11
+ 6.3610839843750001e-05 5.0494250807162017e-11
+ 6.3623046875e-05 5.0547322796645784e-11
+ 6.3635253906249998e-05 5.060037992306559e-11
+ 6.3647460937499997e-05 5.0653422190583924e-11
+ 6.3659667968749996e-05 5.0706449603362099e-11
+ 6.3671875000000008e-05 5.0759462165560252e-11
+ 6.3684082031250006e-05 5.0812459881337356e-11
+ 6.3696289062500005e-05 5.086544275485121e-11
+ 6.3708496093750004e-05 5.0918410790258479e-11
+ 6.3720703125000002e-05 5.0971363991714641e-11
+ 6.3732910156250001e-05 5.1024302363374004e-11
+ 6.37451171875e-05 5.1077225909389738e-11
+ 6.3757324218749998e-05 5.1130134633913832e-11
+ 6.3769531249999997e-05 5.1183028541097097e-11
+ 6.3781738281249996e-05 5.123590763508922e-11
+ 6.3793945312499994e-05 5.1288771920038706e-11
+ 6.3806152343750007e-05 5.1341621400092889e-11
+ 6.3818359375000005e-05 5.1394456079397949e-11
+ 6.3830566406250004e-05 5.1447275962098919e-11
+ 6.3842773437500002e-05 5.1500081052339658e-11
+ 6.3854980468750001e-05 5.1552871354262853e-11
+ 6.38671875e-05 5.1605646872010057e-11
+ 6.3879394531249998e-05 5.1658407609721638e-11
+ 6.3891601562499997e-05 5.171115357153682e-11
+ 6.3903808593749996e-05 5.1763884761593666e-11
+ 6.3916015624999994e-05 5.1816601184029079e-11
+ 6.3928222656249993e-05 5.1869302842978788e-11
+ 6.3940429687500005e-05 5.1921989742577379e-11
+ 6.3952636718750004e-05 5.1974661886958285e-11
+ 6.3964843750000003e-05 5.2027319280253771e-11
+ 6.3977050781250001e-05 5.2079961926594946e-11
+ 6.39892578125e-05 5.2132589830111786e-11
+ 6.4001464843749999e-05 5.2185202994933079e-11
+ 6.4013671874999997e-05 5.2237801425186463e-11
+ 6.4025878906249996e-05 5.2290385124998426e-11
+ 6.4038085937499995e-05 5.2342954098494298e-11
+ 6.4050292968749993e-05 5.2395508349798247e-11
+ 6.4062499999999992e-05 5.2448047883033309e-11
+ 6.4074707031250004e-05 5.2500572702321331e-11
+ 6.4086914062500003e-05 5.2553082811783024e-11
+ 6.4099121093750001e-05 5.260557821553798e-11
+ 6.4111328125e-05 5.265805891770455e-11
+ 6.4123535156249999e-05 5.2710524922400013e-11
+ 6.4135742187499997e-05 5.2762976233740464e-11
+ 6.4147949218749996e-05 5.281541285584085e-11
+ 6.4160156249999995e-05 5.2867834792814952e-11
+ 6.4172363281249993e-05 5.2920242048775429e-11
+ 6.4184570312499992e-05 5.297263462783375e-11
+ 6.4196777343750004e-05 5.3025012534100265e-11
+ 6.4208984375000003e-05 5.3077375771684144e-11
+ 6.4221191406250001e-05 5.3129724344693429e-11
+ 6.42333984375e-05 5.3182058257235008e-11
+ 6.4245605468749999e-05 5.3234377513414598e-11
+ 6.4257812499999997e-05 5.3286682117336819e-11
+ 6.4270019531249996e-05 5.3338972073105086e-11
+ 6.4282226562499995e-05 5.339124738482168e-11
+ 6.4294433593749993e-05 5.3443508056587737e-11
+ 6.4306640624999992e-05 5.349575409250326e-11
+ 6.4318847656249991e-05 5.3547985496667078e-11
+ 6.4331054687500003e-05 5.3600202273176877e-11
+ 6.4343261718750002e-05 5.3652404426129203e-11
+ 6.435546875e-05 5.3704591959619454e-11
+ 6.4367675781249999e-05 5.3756764877741888e-11
+ 6.4379882812499998e-05 5.3808923184589598e-11
+ 6.4392089843749996e-05 5.3861066884254534e-11
+ 6.4404296874999995e-05 5.3913195980827531e-11
+ 6.4416503906249994e-05 5.3965310478398236e-11
+ 6.4428710937499992e-05 5.4017410381055188e-11
+ 6.4440917968749991e-05 5.4069495692885746e-11
+ 6.4453125000000003e-05 5.4121566417976143e-11
+ 6.4465332031250002e-05 5.4173622560411455e-11
+ 6.44775390625e-05 5.4225664124275648e-11
+ 6.4489746093749999e-05 5.4277691113651499e-11
+ 6.4501953124999998e-05 5.4329703532620677e-11
+ 6.4514160156249996e-05 5.4381701385263697e-11
+ 6.4526367187499995e-05 5.4433684675659917e-11
+ 6.4538574218749994e-05 5.4485653407887576e-11
+ 6.4550781249999992e-05 5.4537607586023745e-11
+ 6.4562988281249991e-05 5.4589547214144361e-11
+ 6.457519531249999e-05 5.4641472296324253e-11
+ 6.4587402343750002e-05 5.4693382836637059e-11
+ 6.4599609375e-05 5.4745278839155299e-11
+ 6.4611816406249999e-05 5.4797160307950356e-11
+ 6.4624023437499998e-05 5.4849027247092475e-11
+ 6.4636230468749996e-05 5.4900879660650734e-11
+ 6.4648437499999995e-05 5.4952717552693121e-11
+ 6.4660644531249994e-05 5.5004540927286431e-11
+ 6.4672851562499992e-05 5.5055228596414379e-11
+ 6.4685058593749991e-05 5.510627065877697e-11
+ 6.469726562499999e-05 5.5158092921228189e-11
+ 6.4709472656249988e-05 5.5210849104087091e-11
+ 6.4721679687500001e-05 5.5264521350196526e-11
+ 6.4733886718749999e-05 5.5318219478297029e-11
+ 6.4739990234374999e-05 5.5343709041866146e-11
+ 6.4746093749999998e-05 5.5365175813779936e-11
+ 6.4749145507812491e-05 5.537183500008943e-11
+ 6.4752197265624997e-05 5.5371668509114686e-11
+ 6.475524902343749e-05 5.5354771851498252e-11
+ 6.4756606790774082e-05 5.5334751403020664e-11
+ 6.4756998216660862e-05 5.5326313558461538e-11
+ 6.4757389642547641e-05 5.5316205768572161e-11
+ 6.475836820726457e-05 5.5280832763072969e-11
+ 6.4759409502908181e-05 5.5216998316807767e-11
+ 6.4759970598735316e-05 5.5162661637241072e-11
+ 6.4760339629298369e-05 5.5114439869388932e-11
+ 6.4761110323815837e-05 5.4960015216721681e-11
+ 6.4761741481233847e-05 5.4732817211499076e-11
+ 6.4762113084009009e-05 5.4516300482441227e-11
+ 6.4762434193795787e-05 5.42419953316085e-11
+ 6.4762647097925416e-05 5.400886072195258e-11
+ 6.4762860002055031e-05 5.3774257755821461e-11
+ 6.4764989043351238e-05 5.1549852354822979e-11
+ 6.4777196074601251e-05 4.2855387214314058e-11
+ 6.4789403105851249e-05 4.053247294954365e-11
+ 6.4801610137101248e-05 4.3931039996784842e-11
+ 6.4813817168351247e-05 5.2388572167819672e-11
+ 6.4826024199601245e-05 6.5140225940715896e-11
+ 6.4838231230851244e-05 8.1286621114128428e-11
+ 6.4850438262101243e-05 9.9800201152591339e-11
+ 6.4862645293351241e-05 1.1955731974057662e-10
+ 6.487485232460124e-05 1.3938677731239894e-10
+ 6.4887059355851239e-05 1.581275910662053e-10
+ 6.4899266387101251e-05 1.7469004130247602e-10
+ 6.4911473418351249e-05 1.881149150311095e-10
+ 6.4923680449601248e-05 1.9762660690176225e-10
+ 6.4935887480851247e-05 2.026764694324815e-10
+ 6.4948094512101245e-05 2.0297359093770258e-10
+ 6.4960301543351244e-05 1.9850103705845601e-10
+ 6.4972508574601243e-05 1.8951650785639057e-10
+ 6.4984715605851241e-05 1.7653730627935789e-10
+ 6.499692263710124e-05 1.6031044421422816e-10
+ 6.5009129668351239e-05 1.4176958358946107e-10
+ 6.5021336699601237e-05 1.2198127662112241e-10
+ 6.5033543730851249e-05 1.0208359001036545e-10
+ 6.5045750762101248e-05 8.3220638681385549e-11
+ 6.5057957793351247e-05 6.6476791169901555e-11
+ 6.506100955116374e-05 6.2738216402259133e-11
+ 6.5061314726944992e-05 6.2375524734021021e-11
+ 6.5062077666398115e-05 6.1477937832984702e-11
+ 6.5062459136124677e-05 6.1034090082773124e-11
+ 6.5062482977982594e-05 6.1006459924724939e-11
+ 6.5062487746354178e-05 6.1000935454857881e-11
+ 6.5062497283097331e-05 6.0989888077255491e-11
+ 6.5062498046036793e-05 6.0989004377034889e-11
+ 6.506249957191569e-05 6.0987237016591268e-11
+ 6.5062499693986013e-05 6.0987095630059761e-11
+ 6.5062499938126631e-05 6.0986812858020706e-11
+ 6.5062499957657883e-05 6.0986790236316644e-11
+ 6.5062499996720386e-05 6.098674499293473e-11
+ 6.5062500074845379e-05 6.2330481534674083e-11
+ 6.5062500152970385e-05 6.6608198187672893e-11
+ 6.5062500934220382e-05 2.7075208822833839e-10
+ 6.5062508051845976e-05 1.5641542586395462e-08
+ 6.5062515169471571e-05 5.5354276368357439e-08
+ 6.5062522287097165e-05 1.1939590331347595e-07
+ 6.5062529404722759e-05 2.0774988808958391e-07
+ 6.5062536522348367e-05 3.2039621340029153e-07
+ 6.5062543639973961e-05 4.5731138406416947e-07
+ 6.5062550757599556e-05 6.1846843192454422e-07
+ 6.506255787522515e-05 8.0383692158836119e-07
+ 6.5062564992850744e-05 1.0133829569922963e-06
+ 6.5062572110476338e-05 1.2470691887940203e-06
+ 6.5062579228101933e-05 1.5048548225862434e-06
+ 6.5062587807568578e-05 1.8475543476526228e-06
+ 6.5062596387035197e-05 2.2251205386231599e-06
+ 6.5062604966501842e-05 2.637462112110794e-06
+ 6.5062613545968461e-05 3.0844806091734263e-06
+ 6.5062622125435106e-05 3.5660704276185103e-06
+ 6.5062630704901725e-05 4.0821188567621002e-06
+ 6.506263928436837e-05 4.6325061146258863e-06
+ 6.5062647863834989e-05 5.2171053875545835e-06
+ 6.5062658180770256e-05 5.965211217502911e-06
+ 6.506266849770551e-05 6.7623492313414161e-06
+ 6.5062678814640764e-05 7.6082590651614992e-06
+ 6.5062689131576017e-05 8.5026660760363497e-06
+ 6.5062699448511271e-05 9.4452814742207388e-06
+ 6.5062709765446525e-05 1.0435802462230257e-05
+ 6.5062720082381778e-05 1.147391238070454e-05
+ 6.5062730399317046e-05 1.25592808609545e-05
+ 6.5062742902012255e-05 1.393744004677843e-05
+ 6.5062755404707477e-05 1.538385928477854e-05
+ 6.5062767907402699e-05 1.6897871760843825e-05
+ 6.5062780410097922e-05 1.8478782715895571e-05
+ 6.5062792912793131e-05 2.0125869935940648e-05
+ 6.5062805415488353e-05 2.1838384260846487e-05
+ 6.5062817918183576e-05 2.3615550111329756e-05
+ 6.5062830420878798e-05 2.5456566033633845e-05
+ 6.5062845592253873e-05 2.7775100207116592e-05
+ 6.5062860763628948e-05 3.0184906039223483e-05
+ 6.5062875935004036e-05 3.2684405463249104e-05
+ 6.5062891106379111e-05 3.5271969973378807e-05
+ 6.5062906277754199e-05 3.7945922288216153e-05
+ 6.5062921449129274e-05 4.0704538058428326e-05
+ 6.5062936620504348e-05 4.3546047616054653e-05
+ 6.5062954860519559e-05 4.7069469432613542e-05
+ 6.5062973100534771e-05 5.0706855826657106e-05
+ 6.5062991340549982e-05 5.4454893918205257e-05
+ 6.5063009580565179e-05 5.8310193146384224e-05
+ 6.506302782058039e-05 6.2269290123695639e-05
+ 6.5063046060595601e-05 6.6328653564053143e-05
+ 6.506306819986585e-05 7.1385338233594827e-05
+ 6.5063090339136098e-05 7.6577901326810804e-05
+ 6.5063112478406347e-05 8.189969012601315e-05
+ 6.5063134617676595e-05 8.7343953274172687e-05
+ 6.506316129301132e-05 9.4056657818521804e-05
+ 6.5063187873095807e-05 0.00010090035482762358
+ 6.5063214453180295e-05 0.00010788664307091889
+ 6.506324868848434e-05 0.00011707548567577072
+ 6.5063282923788384e-05 0.00012645461865043843
+ 6.5063315356127046e-05 0.00013549167951766453
+ 6.5063347788465707e-05 0.00014465398332574899
+ 6.5063380220804369e-05 0.00015391958689944246
+ 6.5063412653143044e-05 0.00016326679416820027
+ 6.5063445085481705e-05 0.00017267423453976973
+ 6.5063477517820367e-05 0.00018212093762926101
+ 6.5063509950159028e-05 0.00019158640400330904
+ 6.506354238249769e-05 0.00020105067163597072
+ 6.5063569584998142e-05 0.00020897371829601134
+ 6.5063596787498593e-05 0.00021687121736840308
+ 6.5063623989999059e-05 0.0002247324443841368
+ 6.5063651192499511e-05 0.00023254704172942061
+ 6.5063678394999963e-05 0.00024030503688061725
+ 6.5063705597500414e-05 0.00024799685880477063
+ 6.5063732800000866e-05 0.00025561335251051022
+ 6.5063760002501318e-05 0.00026314579174345146
+ 6.506378720500177e-05 0.00027058588982929906
+ 6.5063814407502235e-05 0.00027792580867665878
+ 6.5063841610002687e-05 0.0002851581659600263
+ 6.5063868812503139e-05 0.00029227604051150784
+ 6.5063896015003591e-05 0.00029927297595749906
+ 6.5063923217504043e-05 0.00030614298264376868
+ 6.5063950420004494e-05 0.00031288053789913813
+ 6.5063977622504946e-05 0.00031948058469418605
+ 6.5064004825005398e-05 0.00032593852875712024
+ 6.506403202750585e-05 0.00033225023421413059
+ 6.5064059230006315e-05 0.00033841201782615327
+ 6.5064086432506767e-05 0.0003444206418985982
+ 6.5064115300883505e-05 0.00035062659892727544
+ 6.5064144169260229e-05 0.0003566540934654631
+ 6.5064173037636966e-05 0.00036250083298786399
+ 6.5064201906013704e-05 0.00036816503744223664
+ 6.5064230774390441e-05 0.00037364542226806104
+ 6.5064259642767179e-05 0.00037894118026981165
+ 6.5064288511143903e-05 0.00038405196247931109
+ 6.506431737952064e-05 0.000388977858140999
+ 6.5064346247897378e-05 0.00039371937395252178
+ 6.506438113516668e-05 0.0003992047348763101
+ 6.5064416022435982e-05 0.00040442447430172904
+ 6.506444998550605e-05 0.00040925368585940502
+ 6.5064483948576118e-05 0.00041383750344981278
+ 6.5064517911646172e-05 0.00041817993390062743
+ 6.506455187471624e-05 0.00042228549548244641
+ 6.5064585837786308e-05 0.00042615916749456922
+ 6.5064627381082821e-05 0.0004305900119691504
+ 6.5064668924379334e-05 0.00043469258490726371
+ 6.5064710467675847e-05 0.0004384781612780042
+ 6.5064752010972359e-05 0.00044195857402361564
+ 6.5064802322523102e-05 0.00044578261210212054
+ 6.506485312517364e-05 0.00044923093231022854
+ 6.5064903927824165e-05 0.00045228765276156626
+ 6.5064971607266253e-05 0.00045579239535176001
+ 6.5065039286708328e-05 0.00045870005395461338
+ 6.5065091919396561e-05 0.00046058369469111949
+ 6.5065144552084808e-05 0.00046216451732223918
+ 6.5065197184773055e-05 0.00046346681282214352
+ 6.5065249817461302e-05 0.00046451393123718372
+ 6.5065297809929103e-05 0.00046526519657479943
+ 6.5065345802396905e-05 0.00046583893527304737
+ 6.5065393794864706e-05 0.00046625041073407677
+ 6.5065441787332508e-05 0.00046651403875466578
+ 6.5065489779800309e-05 0.0004666433740508164
+ 6.5065537261554867e-05 0.00046665162291553914
+ 6.5065584743309411e-05 0.000466552308242554
+ 6.5065632225063956e-05 0.00046635608374731292
+ 6.5065679706818514e-05 0.00046607281339991539
+ 6.5065727188573058e-05 0.00046571159614456351
+ 6.5065774670327616e-05 0.00046528079492301239
+ 6.5065824358583364e-05 0.00046476378468933915
+ 6.5065874046839125e-05 0.00046418694952370777
+ 6.5065923735094873e-05 0.00046355752837163748
+ 6.5065973423350634e-05 0.00046288205221083837
+ 6.5066023111606396e-05 0.00046216639229460844
+ 6.5066072799862144e-05 0.00046141580830294233
+ 6.5066127951386076e-05 0.00046054748419045071
+ 6.5066183102910008e-05 0.00045964758393211987
+ 6.5066238254433926e-05 0.00045872107390199996
+ 6.5066293405957858e-05 0.00045777228079549998
+ 6.5066348557481777e-05 0.00045680495887963081
+ 6.5066411640520542e-05 0.000455679953428722
+ 6.5066474723559294e-05 0.00045453907391423655
+ 6.506653780659806e-05 0.0004533857886546739
+ 6.5066600889636812e-05 0.00045222299034028662
+ 6.506667414014642e-05 0.00045086399130210022
+ 6.5066747390656041e-05 0.00044949844535668453
+ 6.5066820641165648e-05 0.00044812878579885432
+ 6.506690561942158e-05 0.00044653719761490697
+ 6.5066990597677525e-05 0.0004449449586312652
+ 6.5067093836844781e-05 0.00044301214871122791
+ 6.5067198171769419e-05 0.00044106269601017851
+ 6.5067302506694044e-05 0.00043911870626636078
+ 6.5067426664469169e-05 0.00043681393387383496
+ 6.5067550822244281e-05 0.00043451951813961668
+ 6.5067705800806532e-05 0.00043167106196547318
+ 6.5067884937131785e-05 0.00042840086834201771
+ 6.5068098556602394e-05 0.00042453293757745131
+ 6.5068364485722956e-05 0.00041976628303681877
+ 6.5068717982712205e-05 0.00041351261779238365
+ 6.5069242097564147e-05 0.00040441158298440465
+ 6.507013634012048e-05 0.00038934346113524376
+ 6.5072132807185039e-05 0.00035769765454050228
+ 6.5073988816858016e-05 0.00033058981538904275
+ 6.5076421668443081e-05 0.00029814348467284587
+ 6.5078854520028145e-05 0.00026888165874455468
+ 6.5081287371613209e-05 0.00024249178888257299
+ 6.5083720223198274e-05 0.00021869200206866874
+ 6.5086153074783338e-05 0.00019722808975099272
+ 6.5088585926368402e-05 0.00017787079297825666
+ 6.5091018777953467e-05 0.00016041335425741158
+ 6.5093451629538531e-05 0.0001446693086575522
+ 6.5095767705239778e-05 0.00013111903917235234
+ 6.5098819440406717e-05 0.00011518312547724692
+ 6.5101871175573655e-05 0.00010118403045864018
+ 6.5104922910740593e-05 8.8886357108097517e-05
+ 6.5107974645907532e-05 7.8083318131395906e-05
+ 6.511102638107447e-05 6.8593258842393536e-05
+ 6.5114078116241408e-05 6.025660181923537e-05
+ 6.5117773618773595e-05 5.1505809187250614e-05
+ 6.5121134288610914e-05 4.4656271026532631e-05
+ 6.5124494958448219e-05 3.8717628008379948e-05
+ 6.5128620731690282e-05 3.2495702272495222e-05
+ 6.5132746504932332e-05 2.7273646663031209e-05
+ 6.5136872278174395e-05 2.2890780980831938e-05
+ 6.5140998051416458e-05 1.9212246512347876e-05
+ 6.5145123824658521e-05 1.6124856494297113e-05
+ 6.5150251138437098e-05 1.2970141364146993e-05
+ 6.5155378452215674e-05 1.0432633172092827e-05
+ 6.5160505765994264e-05 8.3915781182774641e-06
+ 6.516563307977284e-05 6.7498471833962207e-06
+ 6.5171995979825147e-05 5.1518189724579756e-06
+ 6.5178358879877467e-05 3.9321378049054371e-06
+ 6.5184721779929774e-05 3.0012267671564931e-06
+ 6.5192497256254505e-05 2.15737185496337e-06
+ 6.520027273257925e-05 1.5508026051292012e-06
+ 6.5208048208903994e-05 1.1147960586695601e-06
+ 6.5217983441936064e-05 7.3118840550782522e-07
+ 6.5227918674968147e-05 4.7961075194826108e-07
+ 6.5240125706218145e-05 2.8571159964289929e-07
+ 6.5252332737468144e-05 1.7024209705967684e-07
+ 6.5264539768718143e-05 1.0147848625806179e-07
+ 6.5276746799968141e-05 6.0528851952355526e-08
+ 6.528895383121814e-05 3.6142806128821739e-08
+ 6.5301160862468139e-05 2.1620593980565466e-08
+ 6.5313367893718137e-05 1.2972424953734794e-08
+ 6.5325574924968136e-05 7.8223266739669589e-09
+ 6.5337781956218148e-05 4.7553755500354248e-09
+ 6.5349988987468147e-05 2.9289656540459339e-09
+ 6.5362196018718146e-05 1.8413143839828223e-09
+ 6.5374403049968144e-05 1.1936037658401295e-09
+ 6.5386610081218143e-05 8.078836241498485e-10
+ 6.5398817112468142e-05 5.7818218790680653e-10
+ 6.541102414371814e-05 4.4139192644487092e-10
+ 6.5423231174968139e-05 3.5993152647751398e-10
+ 6.5435438206218137e-05 3.1142080027758294e-10
+ 6.5447645237468136e-05 2.8253202431124535e-10
+ 6.5459852268718135e-05 2.653283707170538e-10
+ 6.5472059299968147e-05 2.5508336753526945e-10
+ 6.5484266331218146e-05 2.4898233649178344e-10
+ 6.5496473362468144e-05 2.4534909287155193e-10
+ 6.5508680393718143e-05 2.4318544696123555e-10
+ 6.5520887424968142e-05 2.4189696683490067e-10
+ 6.553309445621814e-05 2.411296605642883e-10
+ 6.5545301487468139e-05 2.406727199550333e-10
+ 6.5557508518718138e-05 2.4040060549918595e-10
+ 6.5569715549968136e-05 2.4023855751768804e-10
+ 6.5581922581218135e-05 2.4014205601586099e-10
+ 6.5594129612468147e-05 2.4008458822552009e-10
+ 6.5606336643718146e-05 2.4005036536744095e-10
+ 6.5618543674968144e-05 2.4002998505548136e-10
+ 6.5630750706218143e-05 2.4001784836154639e-10
+ 6.5642957737468142e-05 2.4001062082534474e-10
+ 6.565516476871814e-05 2.4000631674323626e-10
+ 6.5667371799968139e-05 2.4000375361391963e-10
+ 6.5679578831218138e-05 2.4000222718017004e-10
+ 6.5691785862468136e-05 2.4000131819356677e-10
+ 6.5703992893718135e-05 2.4000077702242996e-10
+ 6.5716199924968134e-05 2.4000045459933931e-10
+ 6.5728406956218146e-05 2.4000026257884156e-10
+ 6.5740613987468145e-05 2.4000014832025053e-10
+ 6.5752821018718143e-05 2.4000008023582484e-10
+ 6.5765028049968142e-05 2.4000003966625581e-10
+ 6.577723508121814e-05 2.400000155533385e-10
+ 6.5789442112468139e-05 2.4000000121814107e-10
+ 6.5801649143718138e-05 2.3999999261673205e-10
+ 6.5813856174968136e-05 2.3999998758456908e-10
+ 6.5826063206218135e-05 2.3999998453222656e-10
+ 6.5838270237468134e-05 2.3999998265390494e-10
+ 6.5850477268718146e-05 2.3999998161732485e-10
+ 6.5862684299968145e-05 2.3999998104358188e-10
+ 6.5874891331218143e-05 2.3999998057389865e-10
+ 6.5887098362468142e-05 2.3999998026292464e-10
+ 6.5899305393718141e-05 2.3999998019001177e-10
+ 6.5911512424968139e-05 2.3999998019899801e-10
+ 6.5923719456218138e-05 2.3999998020597388e-10
+ 6.5935926487468137e-05 2.3999998012855701e-10
+ 6.5948133518718135e-05 2.3999998005534517e-10
+ 6.5960340549968134e-05 2.3999998008389102e-10
+ 6.5972547581218133e-05 2.3999998009224399e-10
+ 6.5984754612468145e-05 2.3999998012219294e-10
+ 6.5996961643718143e-05 2.3999998013282356e-10
+ 6.6009168674968142e-05 2.3999998009115475e-10
+ 6.6021375706218141e-05 2.3999998009706464e-10
+ 6.6033582737468139e-05 2.3999998010363494e-10
+ 6.6045789768718138e-05 2.3999998011314167e-10
+ 6.6057996799968137e-05 2.3999998013616955e-10
+ 6.6070203831218135e-05 2.3999998011363462e-10
+ 6.6082410862468134e-05 2.3999998009274014e-10
+ 6.6094617893718133e-05 2.399999801011231e-10
+ 6.6106824924968131e-05 2.399999800977465e-10
+ 6.6119031956218143e-05 2.3999998010717031e-10
+ 6.6131238987468142e-05 2.3999998026497155e-10
+ 6.6143446018718141e-05 2.3999998018940695e-10
+ 6.6155653049968139e-05 2.399999801489314e-10
+ 6.6167860081218138e-05 2.3999998016252337e-10
+ 6.6180067112468137e-05 2.3999998017736873e-10
+ 6.6192274143718135e-05 2.3999998008841631e-10
+ 6.6204481174968134e-05 2.399999801406156e-10
+ 6.6216688206218133e-05 2.3999998027111368e-10
+ 6.6228895237468131e-05 2.399999803096209e-10
+ 6.624110226871813e-05 2.399999801745041e-10
+ 6.6253309299968142e-05 2.3999998014351678e-10
+ 6.6265516331218141e-05 2.399999802735929e-10
+ 6.627772336246814e-05 2.3999998026179471e-10
+ 6.6289930393718138e-05 2.3999998016976751e-10
+ 6.6302137424968137e-05 2.3999998022820648e-10
+ 6.6314344456218136e-05 2.3999998018386391e-10
+ 6.6326551487468134e-05 2.3999998024457121e-10
+ 6.6338758518718133e-05 2.399999802712344e-10
+ 6.6350965549968132e-05 2.3999998016906244e-10
+ 6.6363172581218144e-05 2.399999802251944e-10
+ 6.6375379612468142e-05 2.3999998029674961e-10
+ 6.6387586643718141e-05 2.3999998024490881e-10
+ 6.639979367496814e-05 2.3999998022841694e-10
+ 6.6412000706218138e-05 2.3999998027402318e-10
+ 6.6424207737468137e-05 2.3999998031284179e-10
+ 6.6436414768718136e-05 2.3999998024592236e-10
+ 6.6448621799968134e-05 2.3999998028900653e-10
+ 6.6460828831218147e-05 2.3999998029018118e-10
+ 6.6473035862468145e-05 2.3999998020407995e-10
+ 6.6485242893718144e-05 2.3999998030027903e-10
+ 6.6497449924968142e-05 2.3999998034659856e-10
+ 6.6509656956218141e-05 2.3999998035710371e-10
+ 6.652186398746814e-05 2.3999998035781327e-10
+ 6.6534071018718138e-05 2.3999998028429372e-10
+ 6.6546278049968137e-05 2.3999998026462584e-10
+ 6.6558485081218149e-05 2.3999998034401652e-10
+ 6.6570692112468148e-05 2.3999998040748526e-10
+ 6.6582899143718147e-05 2.399999802904164e-10
+ 6.6595106174968145e-05 2.3999998026488739e-10
+ 6.6607313206218144e-05 2.399999803948264e-10
+ 6.6619520237468143e-05 2.399999803901337e-10
+ 6.6631727268718141e-05 2.3999998030809217e-10
+ 6.664393429996814e-05 2.3999998036169063e-10
+ 6.6656141331218152e-05 2.3999998033495331e-10
+ 6.6668348362468151e-05 2.3999998039429674e-10
+ 6.6680555393718149e-05 2.3999998043834603e-10
+ 6.6692762424968148e-05 2.3999998042747548e-10
+ 6.6704969456218147e-05 2.3999998033813589e-10
+ 6.6717176487468145e-05 2.3999998042749197e-10
+ 6.6729383518718144e-05 2.3999998045576412e-10
+ 6.6741590549968143e-05 2.3999998040668088e-10
+ 6.6753797581218155e-05 2.3999998041015307e-10
+ 6.6766004612468154e-05 2.3999998038280188e-10
+ 6.6778211643718152e-05 2.399999804963409e-10
+ 6.6790418674968151e-05 2.3999998050724164e-10
+ 6.680262570621815e-05 2.3999998043757132e-10
+ 6.6814832737468148e-05 2.3999998042873677e-10
+ 6.6827039768718147e-05 2.3999998048062938e-10
+ 6.6839246799968145e-05 2.3999998046244087e-10
+ 6.6851453831218158e-05 2.3999998047367506e-10
+ 6.6863660862468156e-05 2.3999998045481209e-10
+ 6.6875867893718155e-05 2.3999998043752122e-10
+ 6.6888074924968154e-05 2.3999998042446345e-10
+ 6.6900281956218152e-05 2.3999998041722252e-10
+ 6.6912488987468151e-05 2.3999998041674074e-10
+ 6.692469601871815e-05 2.3999998042357827e-10
+ 6.6936903049968148e-05 2.3999998043806778e-10
+ 6.694911008121816e-05 2.3999998047660411e-10
+ 6.6961317112468159e-05 2.3999998051655456e-10
+ 6.6973524143718158e-05 2.3999998052591767e-10
+ 6.6985731174968156e-05 2.3999998048427911e-10
+ 6.6997938206218155e-05 2.3999998054712477e-10
+ 6.7010145237468154e-05 2.3999998057013456e-10
+ 6.7022352268718152e-05 2.3999998051176627e-10
+ 6.7034559299968151e-05 2.3999998057450993e-10
+ 6.7046766331218163e-05 2.3999998053652084e-10
+ 6.7058973362468162e-05 2.3999998056705243e-10
+ 6.7071180393718161e-05 2.399999805326457e-10
+ 6.7083387424968159e-05 2.399999805718764e-10
+ 6.7095594456218158e-05 2.3999998054921403e-10
+ 6.7107801487468157e-05 2.3999998061819825e-10
+ 6.7120008518718155e-05 2.399999805688973e-10
+ 6.7132215549968154e-05 2.3999998054792621e-10
+ 6.7144422581218166e-05 2.39999980627754e-10
+ 6.7156629612468165e-05 2.3999998059474422e-10
+ 6.7168836643718163e-05 2.399999805933057e-10
+ 6.7181043674968162e-05 2.3999998057922352e-10
+ 6.7193250706218161e-05 2.3999998056088616e-10
+ 6.7205457737468159e-05 2.3999998058786213e-10
+ 6.7217664768718158e-05 2.399999806005213e-10
+ 6.7229871799968157e-05 2.3999998060792622e-10
+ 6.7242078831218169e-05 2.3999998061547279e-10
+ 6.7254285862468168e-05 2.3999998062637359e-10
+ 6.7266492893718166e-05 2.3999998064254068e-10
+ 6.7278699924968165e-05 2.399999806651119e-10
+ 6.7290906956218164e-05 2.3999998065019003e-10
+ 6.7303113987468162e-05 2.3999998066078063e-10
+ 6.7315321018718161e-05 2.399999807158811e-10
+ 6.7327528049968159e-05 2.3999998065933043e-10
+ 6.7339735081218172e-05 2.3999998069949765e-10
+ 6.735194211246817e-05 2.3999998071137632e-10
+ 6.7364149143718169e-05 2.3999998066492584e-10
+ 6.7376356174968168e-05 2.3999998067631891e-10
+ 6.7388563206218166e-05 2.3999998068067386e-10
+ 6.7400770237468165e-05 2.3999998072884115e-10
+ 6.7412977268718164e-05 2.3999998071703879e-10
+ 6.7425184299968162e-05 2.399999807620995e-10
+ 6.7437391331218174e-05 2.3999998071038665e-10
+ 6.7449598362468173e-05 2.3999998068359319e-10
+ 6.7461805393718172e-05 2.3999998073934671e-10
+ 6.747401242496817e-05 2.3999998074833904e-10
+ 6.7486219456218169e-05 2.3999998072288318e-10
+ 6.7498426487468168e-05 2.3999998078919143e-10
+ 6.7510633518718166e-05 2.3999998076965073e-10
+ 6.7522840549968165e-05 2.399999807468099e-10
+ 6.7535047581218177e-05 2.3999998076982682e-10
+ 6.7547254612468176e-05 2.3999998077882701e-10
+ 6.7559461643718175e-05 2.3999998078272732e-10
+ 6.7571668674968173e-05 2.3999998077698307e-10
+ 6.7583875706218172e-05 2.3999998078844893e-10
+ 6.7596082737468171e-05 2.3999998080355428e-10
+ 6.7608289768718169e-05 2.3999998082407074e-10
+ 6.7620496799968168e-05 2.3999998085105249e-10
+ 6.763270383121818e-05 2.3999998076975625e-10
+ 6.7644910862468179e-05 2.399999808033618e-10
+ 6.7657117893718177e-05 2.3999998080328762e-10
+ 6.7669324924968176e-05 2.3999998084082399e-10
+ 6.7681531956218175e-05 2.3999998077877215e-10
+ 6.7693738987468173e-05 2.3999998083679345e-10
+ 6.7705946018718172e-05 2.3999998087406507e-10
+ 6.7718153049968171e-05 2.3999998083776306e-10
+ 6.7730360081218183e-05 2.3999998086990843e-10
+ 6.7742567112468182e-05 2.3999998083702247e-10
+ 6.775477414371818e-05 2.399999808776692e-10
+ 6.7766981174968179e-05 2.3999998085631119e-10
+ 6.7779188206218177e-05 2.3999998083949021e-10
+ 6.7791395237468176e-05 2.3999929577393646e-10
+ 6.7803602268718175e-05 2.3999721430085655e-10
+ 6.7815809299968173e-05 2.3999541801853927e-10
+ 6.7828016331218186e-05 2.3999352441667849e-10
+ 6.7840223362468184e-05 2.3998998231508299e-10
+ 6.7852430393718183e-05 2.3998269751518182e-10
+ 6.7864637424968182e-05 2.3996731785187146e-10
+ 6.7870740940593181e-05 2.3994983464395233e-10
+ 6.787684445621818e-05 2.3990674100743305e-10
+ 6.7879896214030687e-05 2.3985615585153402e-10
+ 6.788294797184318e-05 2.3973456609508262e-10
+ 6.7884473850749426e-05 2.3959023649420816e-10
+ 6.7885999729655686e-05 2.3924487360909957e-10
+ 6.7886991106889179e-05 2.3866252493064795e-10
+ 6.7887269733896239e-05 2.3836567845599657e-10
+ 6.7887548360903298e-05 2.3795958755937176e-10
+ 6.7888098835627966e-05 2.3707317678626589e-10
+ 6.7890875273912433e-05 2.3289947932096134e-10
+ 6.7903082305162431e-05 2.1857108082062022e-10
+ 6.791528933641243e-05 2.0744394567167327e-10
+ 6.7927496367662442e-05 1.9657101424192844e-10
+ 6.7939703398912441e-05 1.8444183633608339e-10
+ 6.795191043016244e-05 1.7048236032410772e-10
+ 6.7964117461412438e-05 1.5473832156939622e-10
+ 6.7976324492662437e-05 1.376643966131987e-10
+ 6.7988531523912436e-05 1.1997405552563603e-10
+ 6.8000738555162434e-05 1.0252468847149855e-10
+ 6.8012945586412446e-05 8.622433036431135e-11
+ 6.8025152617662445e-05 7.1953269034585456e-11
+ 6.8037359648912444e-05 6.0497851486217764e-11
+ 6.8049566680162442e-05 5.2496010132610782e-11
+ 6.8061773711412441e-05 4.8395088933560857e-11
+ 6.807398074266244e-05 4.8422873289603413e-11
+ 6.8086187773912438e-05 5.2572582289997926e-11
+ 6.8098394805162437e-05 6.0602144636946106e-11
+ 6.8110601836412436e-05 7.2047475992215135e-11
+ 6.8122808867662448e-05 8.6248800170538565e-11
+ 6.8135015898912446e-05 1.0238838404643464e-10
+ 6.8147222930162445e-05 1.19537446121802e-10
+ 6.8159429961412444e-05 1.367094991032434e-10
+ 6.8171636992662442e-05 1.5291703382970249e-10
+ 6.8183844023912441e-05 1.6722827017382802e-10
+ 6.8186895781724948e-05 1.7041028620342427e-10
+ 6.8187048369615567e-05 1.7056469761267313e-10
+ 6.8187429839342128e-05 1.7094872387604414e-10
+ 6.8187467986314783e-05 1.7098696858623529e-10
+ 6.8187475615709322e-05 1.7099461407315297e-10
+ 6.8187490874498387e-05 1.7100990159048815e-10
+ 6.8187496978014002e-05 1.7101601530675094e-10
+ 6.8187499419420264e-05 1.7101846058671687e-10
+ 6.8187499604455791e-05 1.7101864591102341e-10
+ 6.8187499974526843e-05 1.710190165576025e-10
+ 6.8187500714668949e-05 2.9362295535076986e-10
+ 6.8187501454811055e-05 6.7955376462053112e-10
+ 6.8187508856232151e-05 1.9019685483973129e-08
+ 6.8187516257653234e-05 6.3680162617685321e-08
+ 6.8187523659074331e-05 1.3464578979540883e-07
+ 6.8187531060495414e-05 2.3189729697639808e-07
+ 6.818753846191651e-05 3.5541134357275011e-07
+ 6.8187547512355687e-05 5.4209487018455778e-07
+ 6.8187556562794864e-05 7.6794744751962639e-07
+ 6.8187565613234054e-05 1.032901665904789e-06
+ 6.8187574663673231e-05 1.3368810846168448e-06
+ 6.8187583714112408e-05 1.6798002590529673e-06
+ 6.8187595044533506e-05 2.1638522289015684e-06
+ 6.8187606374954605e-05 2.7085809274094572e-06
+ 6.8187617705375703e-05 3.3137595140903088e-06
+ 6.8187629035796802e-05 3.9791394372703589e-06
+ 6.8187643214653363e-05 4.8961848891924115e-06
+ 6.8187657393509911e-05 5.9065041934527361e-06
+ 6.8187671572366473e-05 7.0094688242501652e-06
+ 6.8187689032396938e-05 8.4939484121898285e-06
+ 6.8187706492427402e-05 1.011650368403691e-05
+ 6.8187723952457867e-05 1.187564441966631e-05
+ 6.818774626847783e-05 1.4320324258348367e-05
+ 6.8187768584497806e-05 1.6981891243476683e-05
+ 6.8187790900517769e-05 1.9856448881756975e-05
+ 6.8187819090217245e-05 2.3785542948120637e-05
+ 6.8187847279916708e-05 2.8038794641957824e-05
+ 6.8187875469616184e-05 3.2606525910010655e-05
+ 6.8187903659315646e-05 3.7478440563006991e-05
+ 6.8187931849015123e-05 4.2643660624918842e-05
+ 6.8187960038714585e-05 4.809076449946518e-05
+ 6.8187988228414061e-05 5.3807826764352856e-05
+ 6.8188019414106477e-05 6.0432058501488789e-05
+ 6.8188050599798879e-05 6.7354141141263776e-05
+ 6.8188081785491294e-05 7.4556149339010216e-05
+ 6.818811297118371e-05 8.2019674226669682e-05
+ 6.8188150418414342e-05 9.1300740447793598e-05
+ 6.8188187865644961e-05 0.00010089852928503813
+ 6.8188225312875594e-05 0.00011077933330704341
+ 6.8188270844195804e-05 0.00012312530862772575
+ 6.8188316375516027e-05 0.00013577798574481139
+ 6.8188361906836237e-05 0.00014867616552750304
+ 6.8188407438156447e-05 0.00016175929991125412
+ 6.8188441084028113e-05 0.00017151113091571656
+ 6.8188474729899778e-05 0.00018130797963939794
+ 6.8188508375771444e-05 0.00019112690048319055
+ 6.8188542021643109e-05 0.000200945563836072
+ 6.8188575667514775e-05 0.0002107423308290232
+ 6.818860931338644e-05 0.00022049632214156449
+ 6.8188642959258106e-05 0.00023018748061678874
+ 6.8188676605129771e-05 0.00023979662749408118
+ 6.8188710251001436e-05 0.0002493055121224335
+ 6.8188736870668153e-05 0.00025674620625396695
+ 6.8188763490334856e-05 0.00026410519322842072
+ 6.8188790110001573e-05 0.00027137476557784006
+ 6.8188816729668276e-05 0.00027854762813939171
+ 6.8188843349334993e-05 0.00028561690431054267
+ 6.8188869969001696e-05 0.0002925761407342706
+ 6.8188896588668413e-05 0.0002994193104460534
+ 6.8188923208335116e-05 0.00030614081452042582
+ 6.8188949828001832e-05 0.00031273548226053464
+ 6.8188976447668549e-05 0.00031919856997935221
+ 6.8189003067335252e-05 0.00032552575842600295
+ 6.8189029687001969e-05 0.00033171314891500655
+ 6.8189056306668672e-05 0.00033775725822013397
+ 6.8189082926335389e-05 0.00034365501229800138
+ 6.8189109546002092e-05 0.00034940373890948994
+ 6.8189136165668808e-05 0.00035500115920957621
+ 6.8189162785335525e-05 0.00036044537837818884
+ 6.8189189405002228e-05 0.00036573487536628151
+ 6.8189216024668945e-05 0.00037086849183281574
+ 6.8189239404935228e-05 0.00037524816041470616
+ 6.8189262785201511e-05 0.00037950661982143294
+ 6.8189286165467808e-05 0.00038364373347733212
+ 6.8189309545734091e-05 0.00038765955240256639
+ 6.8189332926000388e-05 0.00039155430797307712
+ 6.8189356306266671e-05 0.00039532840450424615
+ 6.8189379686532954e-05 0.00039898241168751826
+ 6.8189403066799251e-05 0.00040251705690861332
+ 6.8189426447065534e-05 0.00040593321747524688
+ 6.8189449827331817e-05 0.0004092319127814815
+ 6.8189473207598114e-05 0.00041241429643495774
+ 6.8189496587864397e-05 0.00041548164837231091
+ 6.8189519968130693e-05 0.00041843536698707185
+ 6.8189543348396976e-05 0.00042127696129328835
+ 6.818956672866326e-05 0.00042400804314699181
+ 6.8189590108929556e-05 0.00042663031954648096
+ 6.8189613489195839e-05 0.00042914558503120656
+ 6.8189636869462123e-05 0.00043155571419782471
+ 6.8189660249728419e-05 0.00043386265435075173
+ 6.8189683629994702e-05 0.0004360684183033
+ 6.8189707010260999e-05 0.00043817507734421687
+ 6.8189735591237519e-05 0.00044061881915944171
+ 6.818976417221404e-05 0.00044292160557832261
+ 6.818979275319056e-05 0.00044508748731897325
+ 6.8189821334167094e-05 0.0004471205811035718
+ 6.8189849915143615e-05 0.00044902505354874717
+ 6.8189886199806213e-05 0.00045126415767136695
+ 6.818992545337338e-05 0.00045347065125915753
+ 6.8189946977215265e-05 0.00045458914938144757
+ 6.8189973696714695e-05 0.00045589098737442259
+ 6.8190000416214138e-05 0.00045710004038524538
+ 6.8190027135713567e-05 0.00045821970861944291
+ 6.819005385521301e-05 0.00045925335947318648
+ 6.8190080574712439e-05 0.00046020432082601948
+ 6.8190107294211882e-05 0.00046107587487371744
+ 6.8190134013711311e-05 0.00046187125249194449
+ 6.8190160733210754e-05 0.00046259362811953432
+ 6.8190187452710183e-05 0.00046324611514856153
+ 6.8190214172209626e-05 0.00046383176180687778
+ 6.8190240891709055e-05 0.00046435354751746608
+ 6.8190262548859616e-05 0.00046473161709406521
+ 6.8190284206010162e-05 0.00046507115570231151
+ 6.8190305863160709e-05 0.00046537364255429416
+ 6.8190327520311269e-05 0.00046564052306956875
+ 6.8190349177461816e-05 0.00046587320827894959
+ 6.8190370834612376e-05 0.00046607307433484731
+ 6.8190392491762923e-05 0.00046624146212347479
+ 6.8190414148913469e-05 0.00046637967697419719
+ 6.819043580606403e-05 0.00046648898846127722
+ 6.8190457463214576e-05 0.00046657063029325929
+ 6.8190479120365137e-05 0.0004666258002852115
+ 6.8190496765399604e-05 0.00046665198683365781
+ 6.8190514410434072e-05 0.00046666198405394353
+ 6.8190532055468554e-05 0.00046665638716889121
+ 6.8190549700503021e-05 0.00046663577581361698
+ 6.8190567345537503e-05 0.00046660071413966874
+ 6.8190584990571971e-05 0.00046655175093608377
+ 6.8190602635606452e-05 0.00046648941976632619
+ 6.819062028064092e-05 0.00046641423912008399
+ 6.8190637925675388e-05 0.00046632671257892689
+ 6.8190655570709869e-05 0.00046622732899484812
+ 6.8190673215744337e-05 0.00046611656268073646
+ 6.8190690860778818e-05 0.00046599487361184948
+ 6.8190708505813286e-05 0.00046586270763738396
+ 6.8190726150847768e-05 0.00046572049670126538
+ 6.8190743795882235e-05 0.00046556865907130521
+ 6.8190761440916703e-05 0.00046540759957590188
+ 6.8190779085951185e-05 0.00046523770984748908
+ 6.8190796730985652e-05 0.00046505936857196291
+ 6.8190814376020134e-05 0.00046487294174334804
+ 6.8190832021054602e-05 0.00046467878292299136
+ 6.8190849666089083e-05 0.00046447723350260048
+ 6.8190867311123551e-05 0.00046426862297047311
+ 6.8190884956158032e-05 0.00046405326918029163
+ 6.81909026011925e-05 0.00046383147862188659
+ 6.8190920246226968e-05 0.0004636035466933999
+ 6.8190937891261449e-05 0.00046336975797430831
+ 6.8190955536295917e-05 0.00046313038649879376
+ 6.8190973181330399e-05 0.00046288569602897633
+ 6.8190990826364866e-05 0.00046263594032755121
+ 6.8191008471399348e-05 0.00046238136342939871
+ 6.8191026116433816e-05 0.00046212219991176166
+ 6.8191043761468297e-05 0.00046185867516261082
+ 6.8191061406502765e-05 0.00046159100564684353
+ 6.8191079051537233e-05 0.00046131939916998468
+ 6.8191096696571714e-05 0.00046104405513908457
+ 6.8191114341606182e-05 0.00046076516482052872
+ 6.8191131986640663e-05 0.00046048291159450004
+ 6.8191149631675131e-05 0.00046019747120585279
+ 6.8191167276709613e-05 0.00045990901201118061
+ 6.819118492174408e-05 0.00045961769522188066
+ 6.8191202566778548e-05 0.00045932367514303494
+ 6.819122021181303e-05 0.00045902709940794936
+ 6.8191237856847498e-05 0.00045872810920820898
+ 6.8191255501881979e-05 0.00045842683951912496
+ 6.8191273146916447e-05 0.00045812341932046545
+ 6.8191290791950928e-05 0.00045781797181237863
+ 6.8191308436985396e-05 0.00045751061462643097
+ 6.8191326082019864e-05 0.00045720146003169808
+ 6.8191343727054345e-05 0.00045689061513585962
+ 6.8191361372088813e-05 0.00045657818208126165
+ 6.8191379017123294e-05 0.00045626425823592343
+ 6.8191396662157762e-05 0.0004559489363794755
+ 6.8191414307192244e-05 0.0004556323048840281
+ 6.8191431952226711e-05 0.00045531444788997848
+ 6.8191449597261193e-05 0.00045499544547677518
+ 6.8191467242295661e-05 0.00045467537382866608
+ 6.8191484887330129e-05 0.00045435430539546583
+ 6.819150253236461e-05 0.00045403230904838535
+ 6.8191520177399078e-05 0.00045370945023097327
+ 6.8191537822433559e-05 0.00045338579110522598
+ 6.8191555467468027e-05 0.00045306139069292836
+ 6.8191573112502508e-05 0.00045273630501229328
+ 6.8191590757536976e-05 0.00045241058720997258
+ 6.8191608402571458e-05 0.00045208428768851668
+ 6.8191626047605925e-05 0.00045175745422936376
+ 6.8191643692640393e-05 0.00045143013211144381
+ 6.8191661337674875e-05 0.00045110236422548483
+ 6.8191682620107573e-05 0.00045070649383213837
+ 6.8191702745281683e-05 0.00045033166770387813
+ 6.819172287045578e-05 0.00044995642757493547
+ 6.819174299562989e-05 0.00044958082330929242
+ 6.8191763120803987e-05 0.00044920490166811688
+ 6.8191783245978083e-05 0.00044882870648050557
+ 6.8191803371152194e-05 0.00044845227880637947
+ 6.819182349632629e-05 0.00044807565709178331
+ 6.81918436215004e-05 0.00044769887731683952
+ 6.8191863746674497e-05 0.00044732197313660687
+ 6.819188811074613e-05 0.00044686556133260454
+ 6.8191912474817749e-05 0.00044640906499999366
+ 6.8191936838889381e-05 0.00044595253182312878
+ 6.8191961202961014e-05 0.00044549600565976083
+ 6.8191985567032633e-05 0.00044503952681690417
+ 6.8192009931104266e-05 0.00044458313230938829
+ 6.8192034295175898e-05 0.00044412685610195336
+ 6.8192058659247517e-05 0.00044367072933572632
+ 6.819208302331915e-05 0.00044321478053989036
+ 6.8192107387390769e-05 0.00044275903582933563
+ 6.8192136719683576e-05 0.00044221066197735565
+ 6.8192166051976369e-05 0.00044166265618977781
+ 6.8192195384269162e-05 0.00044111505229614979
+ 6.8192224716561955e-05 0.000440567880571222
+ 6.8192254048854748e-05 0.0004400211680723513
+ 6.8192283381147541e-05 0.0004394749389480193
+ 6.8192312713440334e-05 0.0004389292147195882
+ 6.8192342045733127e-05 0.00043838401453830063
+ 6.8192377848029192e-05 0.00043771929099924211
+ 6.8192412335454626e-05 0.00043707976746529866
+ 6.8192446822880061e-05 0.00043644103787377733
+ 6.8192481310305495e-05 0.00043580312030283216
+ 6.8192515797730929e-05 0.00043516603032572377
+ 6.8192557828321214e-05 0.00043439073279079223
+ 6.8192599858911485e-05 0.00043361670459320404
+ 6.819264188950177e-05 0.00043284396248195208
+ 6.8192683920092041e-05 0.00043207252012209858
+ 6.8192725950682326e-05 0.00043130238856505936
+ 6.8192777518503425e-05 0.00043035930871672526
+ 6.8192828186666477e-05 0.00042943462880424378
+ 6.8192878854829542e-05 0.00042851188736760037
+ 6.8192929522992594e-05 0.00042759109050169295
+ 6.8192993215143458e-05 0.00042643637215815307
+ 6.8193056907294323e-05 0.0004252847370223043
+ 6.8193120599445187e-05 0.00042413618616643506
+ 6.819319894561072e-05 0.00042272760989246018
+ 6.8193278657649692e-05 0.00042129925771114857
+ 6.8193358369688663e-05 0.00041987571829712041
+ 6.8193461292370759e-05 0.00041804477075287836
+ 6.8193569508909815e-05 0.00041612824858809757
+ 6.819370191480444e-05 0.00041379527174881443
+ 6.8193847065030181e-05 0.00041125276249577136
+ 6.8194034315235689e-05 0.00040799587225246868
+ 6.8194255865010431e-05 0.00040417569543334638
+ 6.8194554034092507e-05 0.00039909077578923559
+ 6.819499876987089e-05 0.00039162496079868337
+ 6.8195805003988999e-05 0.00037844492463713218
+ 6.8196711764368319e-05 0.00036415075183872955
+ 6.8197737475686446e-05 0.00034863113834200367
+ 6.8198801143402337e-05 0.00033323544260725887
+ 6.8199944764949543e-05 0.00031744009309453978
+ 6.8202231646278909e-05 0.00028806442739914481
+ 6.8204182681216657e-05 0.00026516169925578173
+ 6.8206291228517244e-05 0.00024245284579639417
+ 6.8208581467436166e-05 0.00021998507757767748
+ 6.8210926666850024e-05 0.00019913410083615226
+ 6.8213271866263882e-05 0.00018025945489984468
+ 6.8215590537179632e-05 0.00016335772611693962
+ 6.8218474569484286e-05 0.00014452917890563918
+ 6.8221358601788925e-05 0.00012787080313841811
+ 6.8224242634093579e-05 0.00011313246567173927
+ 6.8227126666398232e-05 0.00010009286360866482
+ 6.8230010698702872e-05 8.8556201336288662e-05
+ 6.8232894731007525e-05 7.8349250567829904e-05
+ 6.8235778763312178e-05 6.9318749243295542e-05
+ 6.8239342797663595e-05 5.9583601550415324e-05
+ 6.8242906832015012e-05 5.12156620124964e-05
+ 6.8246470866366429e-05 4.4022919356413453e-05
+ 6.8250034900717846e-05 3.7840328450154061e-05
+ 6.8253598935069277e-05 3.2526023165760874e-05
+ 6.8257899961127357e-05 2.7096692323683933e-05
+ 6.826220098718545e-05 2.2573641128908005e-05
+ 6.8266502013243543e-05 1.8805590756409222e-05
+ 6.8270803039301623e-05 1.5666514280396347e-05
+ 6.8275104065359716e-05 1.3051421554109079e-05
+ 6.8280502505986979e-05 1.0377818664489998e-05
+ 6.8285900946614257e-05 8.251909089995107e-06
+ 6.829129938724152e-05 6.5614966739560858e-06
+ 6.8296697827868784e-05 5.2173688876777125e-06
+ 6.8303468247657472e-05 3.9138135354349389e-06
+ 6.8310238667446159e-05 2.9359531577328348e-06
+ 6.8317009087234847e-05 2.2024124497970242e-06
+ 6.8325385304343953e-05 1.5432541258101081e-06
+ 6.8333761521453072e-05 1.081378721967762e-06
+ 6.8342137738562178e-05 7.5774041132707628e-07
+ 6.8353043385488657e-05 4.7689837631713853e-07
+ 6.8363949032415136e-05 3.0015113649486665e-07
+ 6.8376156063665135e-05 1.7876217937191045e-07
+ 6.8388363094915134e-05 1.0647330757921957e-07
+ 6.8400570126165132e-05 6.3424252544034479e-08
+ 6.8412777157415131e-05 3.7787934734000867e-08
+ 6.842498418866513e-05 2.2521155841269887e-08
+ 6.8437191219915128e-05 1.3429588576020001e-08
+ 6.844939825116514e-05 8.015449872567151e-09
+ 6.8461605282415139e-05 4.7912734917149069e-09
+ 6.8473812313665138e-05 2.871251600636248e-09
+ 6.8486019344915136e-05 1.7278727196949598e-09
+ 6.8498226376165135e-05 1.0469960699243559e-09
+ 6.8510433407415134e-05 6.4154623608527275e-10
+ 6.8522640438665132e-05 4.0011708092908531e-10
+ 6.8534847469915131e-05 2.563646256420896e-10
+ 6.854705450116513e-05 1.7078006330613652e-10
+ 6.8559261532415142e-05 1.1983532309874618e-10
+ 6.857146856366514e-05 8.9519095817165878e-11
+ 6.8583675594915139e-05 7.14874426319846e-11
+ 6.8595882626165138e-05 6.0771426293748156e-11
+ 6.8608089657415136e-05 5.4411972164600532e-11
+ 6.8620296688665135e-05 5.0646908151112081e-11
+ 6.8632503719915134e-05 4.8426835103990855e-11
+ 6.8644710751165146e-05 4.7126820532761082e-11
+ 6.8656917782415145e-05 4.6374708016315066e-11
+ 6.8669124813665143e-05 4.594887297816922e-11
+ 6.8681331844915142e-05 4.5717334758833713e-11
+ 6.8693538876165141e-05 4.5601496954841019e-11
+ 6.8705745907415139e-05 4.5554554261028926e-11
+ 6.8717952938665138e-05 4.5548633436145208e-11
+ 6.8730159969915137e-05 4.5567135561437956e-11
+ 6.8742367001165135e-05 4.5600175741221697e-11
+ 6.8750000000000004e-05 4.5624752229059989e-11
+ 6.8762207031250003e-05 4.5669966819297461e-11
+ 6.8774414062500001e-05 4.5718898557805248e-11
+ 6.878662109375e-05 4.5770037749483043e-11
+ 6.8798828124999999e-05 4.5822485350610839e-11
+ 6.8811035156249997e-05 4.5875705969269391e-11
+ 6.882324218750001e-05 4.5929380773488921e-11
+ 6.8835449218750008e-05 4.5983319895906806e-11
+ 6.8847656250000007e-05 4.6037410269464089e-11
+ 6.8859863281250006e-05 4.6091584562801975e-11
+ 6.8872070312500004e-05 4.6145802680837535e-11
+ 6.8884277343750003e-05 4.6200040748086769e-11
+ 6.8896484375000002e-05 4.6254284548072891e-11
+ 6.890869140625e-05 4.6308525616398256e-11
+ 6.8920898437499999e-05 4.6362758914111761e-11
+ 6.8933105468749998e-05 4.641698144216514e-11
+ 6.894531250000001e-05 4.6471191416301583e-11
+ 6.8957519531250008e-05 4.6525387775689795e-11
+ 6.8969726562500007e-05 4.6579569890308451e-11
+ 6.8981933593750006e-05 4.663373738668933e-11
+ 6.8994140625000004e-05 4.6687890044144897e-11
+ 6.9006347656250003e-05 4.6742027732970226e-11
+ 6.9018554687500002e-05 4.6796150377641402e-11
+ 6.903076171875e-05 4.6850257934899579e-11
+ 6.9042968749999999e-05 4.690435038069982e-11
+ 6.9055175781249998e-05 4.695842770243876e-11
+ 6.906738281250001e-05 4.7012489894326265e-11
+ 6.9079589843750009e-05 4.7066536954629075e-11
+ 6.9091796875000007e-05 4.7120568884029375e-11
+ 6.9104003906250006e-05 4.7174585684647293e-11
+ 6.9116210937500004e-05 4.7228587359458799e-11
+ 6.9128417968750003e-05 4.728257391194907e-11
+ 6.9140625000000002e-05 4.7336545345906017e-11
+ 6.915283203125e-05 4.7390501665297362e-11
+ 6.9165039062499999e-05 4.7444442874197415e-11
+ 6.9177246093749998e-05 4.7498368976743532e-11
+ 6.918945312500001e-05 4.7552279977110043e-11
+ 6.9201660156250009e-05 4.7606175879492929e-11
+ 6.9213867187500007e-05 4.76600566881005e-11
+ 6.9226074218750006e-05 4.771392240714795e-11
+ 6.9238281250000005e-05 4.7767773040854128e-11
+ 6.9250488281250003e-05 4.7821608593439534e-11
+ 6.9262695312500002e-05 4.7875429069125182e-11
+ 6.9274902343750001e-05 4.7929234472131972e-11
+ 6.9287109374999999e-05 4.7983024806680162e-11
+ 6.9299316406249998e-05 4.8036800076989225e-11
+ 6.931152343750001e-05 4.8090560287277661e-11
+ 6.9323730468750009e-05 4.81443054417629e-11
+ 6.9335937500000007e-05 4.8198035544661283e-11
+ 6.9348144531250006e-05 4.8251750600188019e-11
+ 6.9360351562500005e-05 4.8305450612557161e-11
+ 6.9372558593750003e-05 4.835913558598157e-11
+ 6.9384765625000002e-05 4.8412805524672993e-11
+ 6.9396972656250001e-05 4.846646043284194e-11
+ 6.9409179687499999e-05 4.8520100314697792e-11
+ 6.9421386718749998e-05 4.8573725174448732e-11
+ 6.943359375000001e-05 4.8627335016301782e-11
+ 6.9445800781250009e-05 4.8680929844462761e-11
+ 6.9458007812500007e-05 4.8734509663136332e-11
+ 6.9470214843750006e-05 4.8788074476525962e-11
+ 6.9482421875000005e-05 4.8841624288833967e-11
+ 6.9494628906250003e-05 4.8895159104261467e-11
+ 6.9506835937500002e-05 4.894867892700839e-11
+ 6.9519042968750001e-05 4.9002183761273549e-11
+ 6.9531249999999999e-05 4.905567361125451e-11
+ 6.9543457031249998e-05 4.9109148481147716e-11
+ 6.955566406250001e-05 4.9162608375148381e-11
+ 6.9567871093750009e-05 4.9216053297450589e-11
+ 6.9580078125000008e-05 4.9269483252247235e-11
+ 6.9592285156250006e-05 4.932289824373005e-11
+ 6.9604492187500005e-05 4.9376298276089576e-11
+ 6.9616699218750004e-05 4.9429683353515166e-11
+ 6.9628906250000002e-05 4.9483053480195042e-11
+ 6.9641113281250001e-05 4.9536408660316226e-11
+ 6.96533203125e-05 4.9589748898064572e-11
+ 6.9665527343749998e-05 4.9643074197624777e-11
+ 6.967773437500001e-05 4.9696384563180337e-11
+ 6.9689941406250009e-05 4.9749679998913594e-11
+ 6.9702148437500008e-05 4.980296050900572e-11
+ 6.9714355468750006e-05 4.9856226097636712e-11
+ 6.9726562500000005e-05 4.99094767689854e-11
+ 6.9738769531250004e-05 4.9962712527229435e-11
+ 6.9750976562500002e-05 5.0015933376545304e-11
+ 6.9763183593750001e-05 5.0069139321108297e-11
+ 6.9775390625e-05 5.0122330365092602e-11
+ 6.9787597656249998e-05 5.0175506512671175e-11
+ 6.979980468750001e-05 5.0228667768015851e-11
+ 6.9812011718750009e-05 5.0281814135297241e-11
+ 6.9824218750000008e-05 5.0334945618684835e-11
+ 6.9836425781250006e-05 5.0388062222346936e-11
+ 6.9848632812500005e-05 5.0441163950450669e-11
+ 6.9860839843750004e-05 5.0494250807162017e-11
+ 6.9873046875000002e-05 5.0547322796645784e-11
+ 6.9885253906250001e-05 5.060037992306559e-11
+ 6.98974609375e-05 5.0653422190583924e-11
+ 6.9909667968749998e-05 5.0706449603362099e-11
+ 6.9921874999999997e-05 5.0759462165560252e-11
+ 6.9934082031250009e-05 5.0812459881337356e-11
+ 6.9946289062500008e-05 5.086544275485121e-11
+ 6.9958496093750007e-05 5.0918410790258479e-11
+ 6.9970703125000005e-05 5.0971363991714641e-11
+ 6.9982910156250004e-05 5.1024302363374004e-11
+ 6.9995117187500003e-05 5.1077225909389738e-11
+ 7.0007324218750001e-05 5.1130134633913832e-11
+ 7.001953125e-05 5.1183028541097097e-11
+ 7.0031738281249999e-05 5.123590763508922e-11
+ 7.0043945312499997e-05 5.1288771920038706e-11
+ 7.0056152343750009e-05 5.1341621400092889e-11
+ 7.0068359375000008e-05 5.1394456079397949e-11
+ 7.0080566406250007e-05 5.1447275962098919e-11
+ 7.0092773437500005e-05 5.1500081052339658e-11
+ 7.0104980468750004e-05 5.1552871354262853e-11
+ 7.0117187500000003e-05 5.1605646872010057e-11
+ 7.0129394531250001e-05 5.1658407609721638e-11
+ 7.01416015625e-05 5.171115357153682e-11
+ 7.0153808593749999e-05 5.1763884761593666e-11
+ 7.0166015624999997e-05 5.1816601184029079e-11
+ 7.0178222656249996e-05 5.1869302842978788e-11
+ 7.0190429687500008e-05 5.1921989742577379e-11
+ 7.0202636718750007e-05 5.1974661886958285e-11
+ 7.0214843750000005e-05 5.2027319280253771e-11
+ 7.0227050781250004e-05 5.2079961926594946e-11
+ 7.0239257812500003e-05 5.2132589830111786e-11
+ 7.0251464843750001e-05 5.2185202994933079e-11
+ 7.0263671875e-05 5.2237801425186463e-11
+ 7.0275878906249999e-05 5.2290385124998426e-11
+ 7.0288085937499997e-05 5.2342954098494298e-11
+ 7.0300292968749996e-05 5.2395508349798247e-11
+ 7.0312500000000008e-05 5.2448047883033309e-11
+ 7.0324707031250007e-05 5.2500572702321331e-11
+ 7.0336914062500006e-05 5.2553082811783024e-11
+ 7.0349121093750004e-05 5.260557821553798e-11
+ 7.0361328125000003e-05 5.265805891770455e-11
+ 7.0373535156250002e-05 5.2710524922400013e-11
+ 7.03857421875e-05 5.2762976233740464e-11
+ 7.0397949218749999e-05 5.281541285584085e-11
+ 7.0410156249999997e-05 5.2867834792814952e-11
+ 7.0422363281249996e-05 5.2920242048775429e-11
+ 7.0434570312499995e-05 5.297263462783375e-11
+ 7.0446777343750007e-05 5.3025012534100265e-11
+ 7.0458984375000006e-05 5.3077375771684144e-11
+ 7.0471191406250004e-05 5.3129724344693429e-11
+ 7.0483398437500003e-05 5.3182058257235008e-11
+ 7.0495605468750002e-05 5.3234377513414598e-11
+ 7.05078125e-05 5.3286682117336819e-11
+ 7.0520019531249999e-05 5.3338972073105086e-11
+ 7.0532226562499998e-05 5.339124738482168e-11
+ 7.0544433593749996e-05 5.3443508056587737e-11
+ 7.0556640624999995e-05 5.349575409250326e-11
+ 7.0568847656249994e-05 5.3547985496667078e-11
+ 7.0581054687500006e-05 5.3600202273176877e-11
+ 7.0593261718750004e-05 5.3652404426129203e-11
+ 7.0605468750000003e-05 5.3704591959619454e-11
+ 7.0617675781250002e-05 5.3756764877741888e-11
+ 7.06298828125e-05 5.3808923184589598e-11
+ 7.0642089843749999e-05 5.3861066884254534e-11
+ 7.0654296874999998e-05 5.3913195980827531e-11
+ 7.0666503906249996e-05 5.3965310478398236e-11
+ 7.0678710937499995e-05 5.4017410381055188e-11
+ 7.0690917968749994e-05 5.4069495692885746e-11
+ 7.0703124999999992e-05 5.4121566417976143e-11
+ 7.0715332031250005e-05 5.4173622560411455e-11
+ 7.0727539062500003e-05 5.4225664124275648e-11
+ 7.0739746093750002e-05 5.4277691113651499e-11
+ 7.0751953125e-05 5.4329703532620677e-11
+ 7.0764160156249999e-05 5.4381701385263697e-11
+ 7.0776367187499998e-05 5.4433684675659917e-11
+ 7.0788574218749996e-05 5.4485653407887576e-11
+ 7.0800781249999995e-05 5.4537607586023745e-11
+ 7.0812988281249994e-05 5.4589547214144361e-11
+ 7.0825195312499992e-05 5.4641472296324253e-11
+ 7.0837402343750005e-05 5.4693382836637059e-11
+ 7.0849609375000003e-05 5.4745278839155299e-11
+ 7.0861816406250002e-05 5.4797160307950356e-11
+ 7.0874023437500001e-05 5.4849027247092475e-11
+ 7.0886230468749999e-05 5.4900879660650734e-11
+ 7.0898437499999998e-05 5.4952717552693121e-11
+ 7.0910644531249997e-05 5.5004540927286431e-11
+ 7.0922851562499995e-05 5.5055228596414379e-11
+ 7.0935058593749994e-05 5.510627065877697e-11
+ 7.0947265624999993e-05 5.5158092921228189e-11
+ 7.0959472656249991e-05 5.5210849104087091e-11
+ 7.0971679687500003e-05 5.5264521350196526e-11
+ 7.0983886718750002e-05 5.5318219478297029e-11
+ 7.0989990234375001e-05 5.5343709041866146e-11
+ 7.0996093750000001e-05 5.5365175813779936e-11
+ 7.0999145507812494e-05 5.537183500008943e-11
+ 7.1002197265625e-05 5.5371668509114686e-11
+ 7.1005249023437493e-05 5.5354771851498252e-11
+ 7.1006606790774085e-05 5.5334751403020664e-11
+ 7.1006998216660864e-05 5.5326313558461538e-11
+ 7.1007389642547644e-05 5.5316205768572161e-11
+ 7.1008368207264573e-05 5.5280832763072969e-11
+ 7.1009409502908183e-05 5.5216998316807767e-11
+ 7.1009970598735333e-05 5.5162661637241072e-11
+ 7.1010339629298371e-05 5.5114439869388932e-11
+ 7.101111032381584e-05 5.4960015216721681e-11
+ 7.101174148123385e-05 5.4732817211499076e-11
+ 7.1012113084009012e-05 5.4516300482441227e-11
+ 7.1012434193795789e-05 5.42419953316085e-11
+ 7.1012647097925418e-05 5.400886072195258e-11
+ 7.1012860002055034e-05 5.3774257755821461e-11
+ 7.1014989043351255e-05 5.1549852354822979e-11
+ 7.1027196074601253e-05 4.2855387214314058e-11
+ 7.1039403105851252e-05 4.053247294954365e-11
+ 7.1051610137101251e-05 4.3931039996784842e-11
+ 7.1063817168351249e-05 5.2388572167819672e-11
+ 7.1076024199601248e-05 6.5140225940715896e-11
+ 7.1088231230851247e-05 8.1286621114128428e-11
+ 7.1100438262101245e-05 9.9800201152591339e-11
+ 7.1112645293351244e-05 1.1955731974057662e-10
+ 7.1124852324601243e-05 1.3938677731239894e-10
+ 7.1137059355851241e-05 1.581275910662053e-10
+ 7.1149266387101254e-05 1.7469004130247602e-10
+ 7.1161473418351252e-05 1.881149150311095e-10
+ 7.1173680449601251e-05 1.9762660690176225e-10
+ 7.118588748085125e-05 2.026764694324815e-10
+ 7.1198094512101248e-05 2.0297359093770258e-10
+ 7.1210301543351247e-05 1.9850103705845601e-10
+ 7.1222508574601246e-05 1.8951650785639057e-10
+ 7.1234715605851244e-05 1.7653730627935789e-10
+ 7.1246922637101243e-05 1.6031044421422816e-10
+ 7.1259129668351241e-05 1.4176958358946107e-10
+ 7.127133669960124e-05 1.2198127662112241e-10
+ 7.1283543730851252e-05 1.0208359001036545e-10
+ 7.1295750762101251e-05 8.3220638681385549e-11
+ 7.130795779335125e-05 6.6476791169901555e-11
+ 7.1311009551163743e-05 6.2738216402259133e-11
+ 7.1311314726944995e-05 6.2375524734021021e-11
+ 7.1312077666398118e-05 6.1477937832984702e-11
+ 7.1312459136124679e-05 6.1034090082773124e-11
+ 7.1312482977982597e-05 6.1006459924724939e-11
+ 7.1312487746354181e-05 6.1000935454857881e-11
+ 7.1312497283097334e-05 6.0989888077255491e-11
+ 7.1312498046036796e-05 6.0989004377034889e-11
+ 7.1312499571915693e-05 6.0987237016591268e-11
+ 7.1312499693986016e-05 6.0987095630059761e-11
+ 7.1312499938126634e-05 6.0986812858020706e-11
+ 7.1312499957657886e-05 6.0986790236316644e-11
+ 7.1312499996720389e-05 6.098674499293473e-11
+ 7.1312500074845382e-05 6.2330481534674083e-11
+ 7.1312500152970388e-05 6.6608198187672893e-11
+ 7.1312500934220385e-05 2.7075208822833839e-10
+ 7.1312508051845979e-05 1.5641542586395462e-08
+ 7.1312515169471574e-05 5.5354276368357439e-08
+ 7.1312522287097168e-05 1.1939590331347595e-07
+ 7.1312529404722762e-05 2.0774988808958391e-07
+ 7.131253652234837e-05 3.2039621340029153e-07
+ 7.1312543639973964e-05 4.5731138406416947e-07
+ 7.1312550757599558e-05 6.1846843192454422e-07
+ 7.1312557875225153e-05 8.0383692158836119e-07
+ 7.1312564992850747e-05 1.0133829569922963e-06
+ 7.1312572110476341e-05 1.2470691887940203e-06
+ 7.1312579228101949e-05 1.5048548225862434e-06
+ 7.1312587807568568e-05 1.8475543476526228e-06
+ 7.1312596387035213e-05 2.2251205386231599e-06
+ 7.1312604966501832e-05 2.637462112110794e-06
+ 7.1312613545968477e-05 3.0844806091734263e-06
+ 7.1312622125435096e-05 3.5660704276185103e-06
+ 7.1312630704901741e-05 4.0821188567621002e-06
+ 7.131263928436836e-05 4.6325061146258863e-06
+ 7.1312647863835005e-05 5.2171053875545835e-06
+ 7.1312658180770259e-05 5.965211217502911e-06
+ 7.1312668497705513e-05 6.7623492313414161e-06
+ 7.1312678814640766e-05 7.6082590651614992e-06
+ 7.131268913157602e-05 8.5026660760363497e-06
+ 7.1312699448511274e-05 9.4452814742207388e-06
+ 7.1312709765446528e-05 1.0435802462230257e-05
+ 7.1312720082381781e-05 1.147391238070454e-05
+ 7.1312730399317035e-05 1.25592808609545e-05
+ 7.1312742902012257e-05 1.393744004677843e-05
+ 7.131275540470748e-05 1.538385928477854e-05
+ 7.1312767907402702e-05 1.6897871760843825e-05
+ 7.1312780410097925e-05 1.8478782715895571e-05
+ 7.1312792912793134e-05 2.0125869935940648e-05
+ 7.1312805415488356e-05 2.1838384260846487e-05
+ 7.1312817918183578e-05 2.3615550111329756e-05
+ 7.1312830420878801e-05 2.5456566033633845e-05
+ 7.1312845592253876e-05 2.7775100207116592e-05
+ 7.1312860763628964e-05 3.0184906039223483e-05
+ 7.1312875935004039e-05 3.2684405463249104e-05
+ 7.1312891106379113e-05 3.5271969973378807e-05
+ 7.1312906277754202e-05 3.7945922288216153e-05
+ 7.1312921449129276e-05 4.0704538058428326e-05
+ 7.1312936620504351e-05 4.3546047616054653e-05
+ 7.1312954860519562e-05 4.7069469432613542e-05
+ 7.1312973100534773e-05 5.0706855826657106e-05
+ 7.1312991340549985e-05 5.4454893918205257e-05
+ 7.1313009580565182e-05 5.8310193146384224e-05
+ 7.1313027820580393e-05 6.2269290123695639e-05
+ 7.1313046060595604e-05 6.6328653564053143e-05
+ 7.1313068199865853e-05 7.1385338233594827e-05
+ 7.1313090339136101e-05 7.6577901326810804e-05
+ 7.1313112478406349e-05 8.189969012601315e-05
+ 7.1313134617676598e-05 8.7343953274172687e-05
+ 7.1313161293011323e-05 9.4056657818521804e-05
+ 7.131318787309581e-05 0.00010090035482762358
+ 7.1313214453180298e-05 0.00010788664307091889
+ 7.1313248688484343e-05 0.00011707548567577072
+ 7.1313282923788387e-05 0.00012645461865043843
+ 7.1313315356127049e-05 0.00013549167951766453
+ 7.131334778846571e-05 0.00014465398332574899
+ 7.1313380220804372e-05 0.00015391958689944246
+ 7.1313412653143047e-05 0.00016326679416820027
+ 7.1313445085481708e-05 0.00017267423453976973
+ 7.131347751782037e-05 0.00018212093762926101
+ 7.1313509950159031e-05 0.00019158640400330904
+ 7.1313542382497693e-05 0.00020105067163597072
+ 7.1313569584998144e-05 0.00020897371829601134
+ 7.131359678749861e-05 0.00021687121736840308
+ 7.1313623989999062e-05 0.0002247324443841368
+ 7.1313651192499514e-05 0.00023254704172942061
+ 7.1313678394999965e-05 0.00024030503688061725
+ 7.1313705597500417e-05 0.00024799685880477063
+ 7.1313732800000869e-05 0.00025561335251051022
+ 7.1313760002501321e-05 0.00026314579174345146
+ 7.1313787205001773e-05 0.00027058588982929906
+ 7.1313814407502225e-05 0.00027792580867665878
+ 7.131384161000269e-05 0.0002851581659600263
+ 7.1313868812503142e-05 0.00029227604051150784
+ 7.1313896015003594e-05 0.00029927297595749906
+ 7.1313923217504045e-05 0.00030614298264376868
+ 7.1313950420004497e-05 0.00031288053789913813
+ 7.1313977622504949e-05 0.00031948058469418605
+ 7.1314004825005401e-05 0.00032593852875712024
+ 7.1314032027505866e-05 0.00033225023421413059
+ 7.1314059230006318e-05 0.00033841201782615327
+ 7.131408643250677e-05 0.0003444206418985982
+ 7.1314115300883508e-05 0.00035062659892727544
+ 7.1314144169260231e-05 0.0003566540934654631
+ 7.1314173037636969e-05 0.00036250083298786399
+ 7.1314201906013706e-05 0.00036816503744223664
+ 7.1314230774390444e-05 0.00037364542226806104
+ 7.1314259642767181e-05 0.00037894118026981165
+ 7.1314288511143905e-05 0.00038405196247931109
+ 7.1314317379520643e-05 0.000388977858140999
+ 7.131434624789738e-05 0.00039371937395252178
+ 7.1314381135166683e-05 0.0003992047348763101
+ 7.1314416022435985e-05 0.00040442447430172904
+ 7.1314449985506053e-05 0.00040925368585940502
+ 7.1314483948576121e-05 0.00041383750344981278
+ 7.1314517911646175e-05 0.00041817993390062743
+ 7.1314551874716243e-05 0.00042228549548244641
+ 7.1314585837786311e-05 0.00042615916749456922
+ 7.1314627381082824e-05 0.0004305900119691504
+ 7.1314668924379337e-05 0.00043469258490726371
+ 7.1314710467675849e-05 0.0004384781612780042
+ 7.1314752010972362e-05 0.00044195857402361564
+ 7.1314802322523105e-05 0.00044578261210212054
+ 7.1314853125173643e-05 0.00044923093231022854
+ 7.1314903927824168e-05 0.00045228765276156626
+ 7.1314971607266256e-05 0.00045579239535176001
+ 7.1315039286708331e-05 0.00045870005395461338
+ 7.1315091919396564e-05 0.00046058369469111949
+ 7.1315144552084811e-05 0.00046216451732223918
+ 7.1315197184773058e-05 0.00046346681282214352
+ 7.1315249817461304e-05 0.00046451393123718372
+ 7.1315297809929106e-05 0.00046526519657479943
+ 7.1315345802396907e-05 0.00046583893527304737
+ 7.1315393794864709e-05 0.00046625041073407677
+ 7.131544178733251e-05 0.00046651403875466578
+ 7.1315489779800312e-05 0.0004666433740508164
+ 7.131553726155487e-05 0.00046665162291553914
+ 7.1315584743309414e-05 0.000466552308242554
+ 7.1315632225063958e-05 0.00046635608374731292
+ 7.1315679706818516e-05 0.00046607281339991539
+ 7.1315727188573061e-05 0.00046571159614456351
+ 7.1315774670327605e-05 0.00046528079492301239
+ 7.1315824358583366e-05 0.00046476378468933915
+ 7.1315874046839128e-05 0.00046418694952370777
+ 7.1315923735094876e-05 0.00046355752837163748
+ 7.1315973423350637e-05 0.00046288205221083837
+ 7.1316023111606399e-05 0.00046216639229460844
+ 7.1316072799862146e-05 0.00046141580830294233
+ 7.1316127951386079e-05 0.00046054748419045071
+ 7.1316183102910011e-05 0.00045964758393211987
+ 7.1316238254433929e-05 0.00045872107390199996
+ 7.1316293405957861e-05 0.00045777228079549998
+ 7.131634855748178e-05 0.00045680495887963081
+ 7.1316411640520545e-05 0.000455679953428722
+ 7.1316474723559297e-05 0.00045453907391423655
+ 7.1316537806598063e-05 0.0004533857886546739
+ 7.1316600889636815e-05 0.00045222299034028662
+ 7.1316674140146436e-05 0.00045086399130210022
+ 7.1316747390656044e-05 0.00044949844535668453
+ 7.1316820641165651e-05 0.00044812878579885432
+ 7.1316905619421583e-05 0.00044653719761490697
+ 7.1316990597677528e-05 0.0004449449586312652
+ 7.1317093836844784e-05 0.00044301214871122791
+ 7.1317198171769422e-05 0.00044106269601017851
+ 7.1317302506694046e-05 0.00043911870626636078
+ 7.1317426664469172e-05 0.00043681393387383496
+ 7.1317550822244284e-05 0.00043451951813961668
+ 7.1317705800806534e-05 0.00043167106196547318
+ 7.1317884937131788e-05 0.00042840086834201771
+ 7.1318098556602397e-05 0.00042453293757745131
+ 7.1318364485722959e-05 0.00041976628303681877
+ 7.1318717982712208e-05 0.00041351261779238365
+ 7.131924209756415e-05 0.00040441158298440465
+ 7.1320136340120483e-05 0.00038934346113524376
+ 7.1322132807185041e-05 0.00035769765454050228
+ 7.1323988816858019e-05 0.00033058981538904275
+ 7.1326421668443084e-05 0.00029814348467284587
+ 7.1328854520028148e-05 0.00026888165874455468
+ 7.1331287371613212e-05 0.00024249178888257299
+ 7.1333720223198276e-05 0.00021869200206866874
+ 7.1336153074783341e-05 0.00019722808975099272
+ 7.1338585926368405e-05 0.00017787079297825666
+ 7.1341018777953469e-05 0.00016041335425741158
+ 7.1343451629538534e-05 0.0001446693086575522
+ 7.1345767705239781e-05 0.00013111903917235234
+ 7.134881944040672e-05 0.00011518312547724692
+ 7.1351871175573658e-05 0.00010118403045864018
+ 7.1354922910740596e-05 8.8886357108097517e-05
+ 7.1357974645907534e-05 7.8083318131395906e-05
+ 7.1361026381074473e-05 6.8593258842393536e-05
+ 7.1364078116241411e-05 6.025660181923537e-05
+ 7.1367773618773598e-05 5.1505809187250614e-05
+ 7.1371134288610917e-05 4.4656271026532631e-05
+ 7.1374494958448222e-05 3.8717628008379948e-05
+ 7.1378620731690285e-05 3.2495702272495222e-05
+ 7.1382746504932335e-05 2.7273646663031209e-05
+ 7.1386872278174398e-05 2.2890780980831938e-05
+ 7.1390998051416461e-05 1.9212246512347876e-05
+ 7.1395123824658524e-05 1.6124856494297113e-05
+ 7.1400251138437101e-05 1.2970141364146993e-05
+ 7.1405378452215677e-05 1.0432633172092827e-05
+ 7.1410505765994266e-05 8.3915781182774641e-06
+ 7.1415633079772843e-05 6.7498471833962207e-06
+ 7.142199597982515e-05 5.1518189724579756e-06
+ 7.142835887987747e-05 3.9321378049054371e-06
+ 7.1434721779929777e-05 3.0012267671564931e-06
+ 7.1442497256254508e-05 2.15737185496337e-06
+ 7.1450272732579253e-05 1.5508026051292012e-06
+ 7.1458048208903997e-05 1.1147960586695601e-06
+ 7.1467983441936067e-05 7.3118840550782522e-07
+ 7.147791867496815e-05 4.7961075194826108e-07
+ 7.1490125706218148e-05 2.8571159964289929e-07
+ 7.1502332737468147e-05 1.7024209705967684e-07
+ 7.1514539768718146e-05 1.0147848625806179e-07
+ 7.1526746799968144e-05 6.0528851952355526e-08
+ 7.1538953831218143e-05 3.6142806128821739e-08
+ 7.1551160862468142e-05 2.1620593980565466e-08
+ 7.156336789371814e-05 1.2972424953734794e-08
+ 7.1575574924968139e-05 7.8223266739669589e-09
+ 7.1587781956218151e-05 4.7553755500354248e-09
+ 7.159998898746815e-05 2.9289656540459339e-09
+ 7.1612196018718148e-05 1.8413143839828223e-09
+ 7.1624403049968147e-05 1.1936037658401295e-09
+ 7.1636610081218146e-05 8.078836241498485e-10
+ 7.1648817112468144e-05 5.7818218790680653e-10
+ 7.1661024143718143e-05 4.4139192644487092e-10
+ 7.1673231174968142e-05 3.5993152647751398e-10
+ 7.168543820621814e-05 3.1142080027758294e-10
+ 7.1697645237468139e-05 2.8253202431124535e-10
+ 7.1709852268718151e-05 2.653283707170538e-10
+ 7.172205929996815e-05 2.5508336753526945e-10
+ 7.1734266331218148e-05 2.4898233649178344e-10
+ 7.1746473362468147e-05 2.4534909287155193e-10
+ 7.1758680393718146e-05 2.4318544696123555e-10
+ 7.1770887424968144e-05 2.4189696683490067e-10
+ 7.1783094456218143e-05 2.411296605642883e-10
+ 7.1795301487468142e-05 2.406727199550333e-10
+ 7.180750851871814e-05 2.4040060549918595e-10
+ 7.1819715549968139e-05 2.4023855751768804e-10
+ 7.1831922581218138e-05 2.4014205601586099e-10
+ 7.184412961246815e-05 2.4008458822552009e-10
+ 7.1856336643718149e-05 2.4005036536744095e-10
+ 7.1868543674968147e-05 2.4002998505548136e-10
+ 7.1880750706218146e-05 2.4001784836154639e-10
+ 7.1892957737468145e-05 2.4001062082534474e-10
+ 7.1905164768718143e-05 2.4000631674323626e-10
+ 7.1917371799968142e-05 2.4000375361391963e-10
+ 7.1929578831218141e-05 2.4000222718017004e-10
+ 7.1941785862468139e-05 2.4000131819356677e-10
+ 7.1953992893718138e-05 2.4000077702242996e-10
+ 7.1966199924968136e-05 2.4000045459933931e-10
+ 7.1978406956218149e-05 2.4000026257884156e-10
+ 7.1990613987468147e-05 2.4000014832025053e-10
+ 7.2002821018718146e-05 2.4000008023582484e-10
+ 7.2015028049968145e-05 2.4000003966625581e-10
+ 7.2027235081218143e-05 2.400000155533385e-10
+ 7.2039442112468142e-05 2.4000000121814107e-10
+ 7.2051649143718141e-05 2.3999999261673205e-10
+ 7.2063856174968139e-05 2.3999998758456908e-10
+ 7.2076063206218138e-05 2.3999998453222656e-10
+ 7.2088270237468137e-05 2.3999998265390494e-10
+ 7.2100477268718135e-05 2.3999998161732485e-10
+ 7.2112684299968147e-05 2.3999998104358188e-10
+ 7.2124891331218146e-05 2.3999998057389865e-10
+ 7.2137098362468145e-05 2.3999998026292464e-10
+ 7.2149305393718143e-05 2.3999998019001177e-10
+ 7.2161512424968142e-05 2.3999998019899801e-10
+ 7.2173719456218141e-05 2.3999998020597388e-10
+ 7.2185926487468139e-05 2.3999998012855701e-10
+ 7.2198133518718138e-05 2.3999998005534517e-10
+ 7.2210340549968137e-05 2.3999998008389102e-10
+ 7.2222547581218135e-05 2.3999998009224399e-10
+ 7.2234754612468148e-05 2.3999998012219294e-10
+ 7.2246961643718146e-05 2.3999998013282356e-10
+ 7.2259168674968145e-05 2.3999998009115475e-10
+ 7.2271375706218144e-05 2.3999998009706464e-10
+ 7.2283582737468142e-05 2.3999998010363494e-10
+ 7.2295789768718141e-05 2.3999998011314167e-10
+ 7.230799679996814e-05 2.3999998013616955e-10
+ 7.2320203831218138e-05 2.3999998011363462e-10
+ 7.2332410862468137e-05 2.3999998009274014e-10
+ 7.2344617893718135e-05 2.399999801011231e-10
+ 7.2356824924968134e-05 2.399999800977465e-10
+ 7.2369031956218146e-05 2.3999998010717031e-10
+ 7.2381238987468145e-05 2.3999998026497155e-10
+ 7.2393446018718144e-05 2.3999998018940695e-10
+ 7.2405653049968142e-05 2.399999801489314e-10
+ 7.2417860081218141e-05 2.3999998016252337e-10
+ 7.243006711246814e-05 2.3999998017736873e-10
+ 7.2442274143718138e-05 2.3999998008841631e-10
+ 7.2454481174968137e-05 2.399999801406156e-10
+ 7.2466688206218136e-05 2.3999998027111368e-10
+ 7.2478895237468134e-05 2.399999803096209e-10
+ 7.2491102268718146e-05 2.399999801745041e-10
+ 7.2503309299968145e-05 2.3999998014351678e-10
+ 7.2515516331218144e-05 2.399999802735929e-10
+ 7.2527723362468142e-05 2.3999998026179471e-10
+ 7.2539930393718141e-05 2.3999998016976751e-10
+ 7.255213742496814e-05 2.3999998022820648e-10
+ 7.2564344456218138e-05 2.3999998018386391e-10
+ 7.2576551487468137e-05 2.3999998024457121e-10
+ 7.2588758518718136e-05 2.399999802712344e-10
+ 7.2600965549968134e-05 2.3999998016906244e-10
+ 7.2613172581218147e-05 2.399999802251944e-10
+ 7.2625379612468145e-05 2.3999998029674961e-10
+ 7.2637586643718144e-05 2.3999998024490881e-10
+ 7.2649793674968143e-05 2.3999998022841694e-10
+ 7.2662000706218141e-05 2.3999998027402318e-10
+ 7.267420773746814e-05 2.3999998031284179e-10
+ 7.2686414768718138e-05 2.3999998024592236e-10
+ 7.2698621799968137e-05 2.3999998028900653e-10
+ 7.2710828831218149e-05 2.3999998029018118e-10
+ 7.2723035862468148e-05 2.3999998020407995e-10
+ 7.2735242893718147e-05 2.3999998030027903e-10
+ 7.2747449924968145e-05 2.3999998034659856e-10
+ 7.2759656956218144e-05 2.3999998035710371e-10
+ 7.2771863987468143e-05 2.3999998035781327e-10
+ 7.2784071018718141e-05 2.3999998028429372e-10
+ 7.279627804996814e-05 2.3999998026462584e-10
+ 7.2808485081218152e-05 2.3999998034401652e-10
+ 7.2820692112468151e-05 2.3999998040748526e-10
+ 7.2832899143718149e-05 2.399999802904164e-10
+ 7.2845106174968148e-05 2.3999998026488739e-10
+ 7.2857313206218147e-05 2.399999803948264e-10
+ 7.2869520237468145e-05 2.399999803901337e-10
+ 7.2881727268718144e-05 2.3999998030809217e-10
+ 7.2893934299968143e-05 2.3999998036169063e-10
+ 7.2906141331218155e-05 2.3999998033495331e-10
+ 7.2918348362468154e-05 2.3999998039429674e-10
+ 7.2930555393718152e-05 2.3999998043834603e-10
+ 7.2942762424968151e-05 2.3999998042747548e-10
+ 7.295496945621815e-05 2.3999998033813589e-10
+ 7.2967176487468148e-05 2.3999998042749197e-10
+ 7.2979383518718147e-05 2.3999998045576412e-10
+ 7.2991590549968146e-05 2.3999998040668088e-10
+ 7.3003797581218158e-05 2.3999998041015307e-10
+ 7.3016004612468156e-05 2.3999998038280188e-10
+ 7.3028211643718155e-05 2.399999804963409e-10
+ 7.3040418674968154e-05 2.3999998050724164e-10
+ 7.3052625706218152e-05 2.3999998043757132e-10
+ 7.3064832737468151e-05 2.3999998042873677e-10
+ 7.307703976871815e-05 2.3999998048062938e-10
+ 7.3089246799968148e-05 2.3999998046244087e-10
+ 7.3101453831218161e-05 2.3999998047367506e-10
+ 7.3113660862468159e-05 2.3999998045481209e-10
+ 7.3125867893718158e-05 2.3999998043752122e-10
+ 7.3138074924968157e-05 2.3999998042446345e-10
+ 7.3150281956218155e-05 2.3999998041722252e-10
+ 7.3162488987468154e-05 2.3999998041674074e-10
+ 7.3174696018718152e-05 2.3999998042357827e-10
+ 7.3186903049968151e-05 2.3999998043806778e-10
+ 7.3199110081218163e-05 2.3999998047660411e-10
+ 7.3211317112468162e-05 2.3999998051655456e-10
+ 7.3223524143718161e-05 2.3999998052591767e-10
+ 7.3235731174968159e-05 2.3999998048427911e-10
+ 7.3247938206218158e-05 2.3999998054712477e-10
+ 7.3260145237468157e-05 2.3999998057013456e-10
+ 7.3272352268718155e-05 2.3999998051176627e-10
+ 7.3284559299968154e-05 2.3999998057450993e-10
+ 7.3296766331218166e-05 2.3999998053652084e-10
+ 7.3308973362468165e-05 2.3999998056705243e-10
+ 7.3321180393718163e-05 2.399999805326457e-10
+ 7.3333387424968162e-05 2.399999805718764e-10
+ 7.3345594456218161e-05 2.3999998054921403e-10
+ 7.3357801487468159e-05 2.3999998061819825e-10
+ 7.3370008518718158e-05 2.399999805688973e-10
+ 7.3382215549968157e-05 2.3999998054792621e-10
+ 7.3394422581218169e-05 2.39999980627754e-10
+ 7.3406629612468168e-05 2.3999998059474422e-10
+ 7.3418836643718166e-05 2.399999805933057e-10
+ 7.3431043674968165e-05 2.3999998057922352e-10
+ 7.3443250706218164e-05 2.3999998056088616e-10
+ 7.3455457737468162e-05 2.3999998058786213e-10
+ 7.3467664768718161e-05 2.399999806005213e-10
+ 7.347987179996816e-05 2.3999998060792622e-10
+ 7.3492078831218172e-05 2.3999998061547279e-10
+ 7.350428586246817e-05 2.3999998062637359e-10
+ 7.3516492893718169e-05 2.3999998064254068e-10
+ 7.3528699924968168e-05 2.399999806651119e-10
+ 7.3540906956218166e-05 2.3999998065019003e-10
+ 7.3553113987468165e-05 2.3999998066078063e-10
+ 7.3565321018718164e-05 2.399999807158811e-10
+ 7.3577528049968162e-05 2.3999998065933043e-10
+ 7.3589735081218175e-05 2.3999998069949765e-10
+ 7.3601942112468173e-05 2.3999998071137632e-10
+ 7.3614149143718172e-05 2.3999998066492584e-10
+ 7.362635617496817e-05 2.3999998067631891e-10
+ 7.3638563206218169e-05 2.3999998068067386e-10
+ 7.3650770237468168e-05 2.3999998072884115e-10
+ 7.3662977268718166e-05 2.3999998071703879e-10
+ 7.3675184299968165e-05 2.399999807620995e-10
+ 7.3687391331218177e-05 2.3999998071038665e-10
+ 7.3699598362468176e-05 2.3999998068359319e-10
+ 7.3711805393718175e-05 2.3999998073934671e-10
+ 7.3724012424968173e-05 2.3999998074833904e-10
+ 7.3736219456218172e-05 2.3999998072288318e-10
+ 7.3748426487468171e-05 2.3999998078919143e-10
+ 7.3760633518718169e-05 2.3999998076965073e-10
+ 7.3772840549968168e-05 2.399999807468099e-10
+ 7.378504758121818e-05 2.3999998076982682e-10
+ 7.3797254612468179e-05 2.3999998077882701e-10
+ 7.3809461643718177e-05 2.3999998078272732e-10
+ 7.3821668674968176e-05 2.3999998077698307e-10
+ 7.3833875706218175e-05 2.3999998078844893e-10
+ 7.3846082737468173e-05 2.3999998080355428e-10
+ 7.3858289768718172e-05 2.3999998082407074e-10
+ 7.3870496799968171e-05 2.3999998085105249e-10
+ 7.3882703831218183e-05 2.3999998076975625e-10
+ 7.3894910862468182e-05 2.399999808033618e-10
+ 7.390711789371818e-05 2.3999998080328762e-10
+ 7.3919324924968179e-05 2.3999998084082399e-10
+ 7.3931531956218178e-05 2.3999998077877215e-10
+ 7.3943738987468176e-05 2.3999998083679345e-10
+ 7.3955946018718175e-05 2.3999998087406507e-10
+ 7.3968153049968174e-05 2.3999998083776306e-10
+ 7.3980360081218186e-05 2.3999998086990843e-10
+ 7.3992567112468184e-05 2.3999998083702247e-10
+ 7.4004774143718183e-05 2.399999808776692e-10
+ 7.4016981174968182e-05 2.3999998085631119e-10
+ 7.402918820621818e-05 2.3999998083949021e-10
+ 7.4041395237468179e-05 2.3999929577393646e-10
+ 7.4053602268718178e-05 2.3999721430085655e-10
+ 7.4065809299968176e-05 2.3999541801853927e-10
+ 7.4078016331218189e-05 2.3999352441667849e-10
+ 7.4090223362468187e-05 2.3998998231508299e-10
+ 7.4102430393718186e-05 2.3998269751518182e-10
+ 7.4114637424968184e-05 2.3996731785187146e-10
+ 7.4120740940593184e-05 2.3994983464395233e-10
+ 7.4126844456218183e-05 2.3990674100743305e-10
+ 7.412989621403069e-05 2.3985615585153402e-10
+ 7.4132947971843182e-05 2.3973456609508262e-10
+ 7.4134473850749429e-05 2.3959023649420816e-10
+ 7.4135999729655689e-05 2.3924487360909957e-10
+ 7.4136991106889196e-05 2.3866252493064795e-10
+ 7.4137269733896242e-05 2.3836567845599657e-10
+ 7.4137548360903301e-05 2.3795958755937176e-10
+ 7.4138098835627969e-05 2.3707317678626589e-10
+ 7.4140875273912436e-05 2.3289947932096134e-10
+ 7.4153082305162434e-05 2.1857108082062022e-10
+ 7.4165289336412446e-05 2.0744394567167327e-10
+ 7.4177496367662445e-05 1.9657101424192844e-10
+ 7.4189703398912444e-05 1.8444183633608339e-10
+ 7.4201910430162442e-05 1.7048236032410772e-10
+ 7.4214117461412441e-05 1.5473832156939622e-10
+ 7.422632449266244e-05 1.376643966131987e-10
+ 7.4238531523912438e-05 1.1997405552563603e-10
+ 7.4250738555162437e-05 1.0252468847149855e-10
+ 7.4262945586412436e-05 8.622433036431135e-11
+ 7.4275152617662448e-05 7.1953269034585456e-11
+ 7.4287359648912447e-05 6.0497851486217764e-11
+ 7.4299566680162445e-05 5.2496010132610782e-11
+ 7.4311773711412444e-05 4.8395088933560857e-11
+ 7.4323980742662442e-05 4.8422873289603413e-11
+ 7.4336187773912441e-05 5.2572582289997926e-11
+ 7.434839480516244e-05 6.0602144636946106e-11
+ 7.4360601836412452e-05 7.2047475992215135e-11
+ 7.4372808867662451e-05 8.6248800170538565e-11
+ 7.4385015898912449e-05 1.0238838404643464e-10
+ 7.4397222930162448e-05 1.19537446121802e-10
+ 7.4409429961412447e-05 1.367094991032434e-10
+ 7.4421636992662445e-05 1.5291703382970249e-10
+ 7.4433844023912444e-05 1.6722827017382802e-10
+ 7.443689578172495e-05 1.7041028620342427e-10
+ 7.443704836961557e-05 1.7056469761267313e-10
+ 7.4437429839342131e-05 1.7094872387604414e-10
+ 7.4437467986314786e-05 1.7098696858623529e-10
+ 7.4437475615709325e-05 1.7099461407315297e-10
+ 7.443749087449839e-05 1.7100990159048815e-10
+ 7.4437496978014005e-05 1.7101601530675094e-10
+ 7.4437499419420267e-05 1.7101846058671687e-10
+ 7.4437499604455793e-05 1.7101864591102341e-10
+ 7.4437499974526846e-05 1.710190165576025e-10
+ 7.4437500714668952e-05 2.9362295535076986e-10
+ 7.4437501454811057e-05 6.7955376462053112e-10
+ 7.4437508856232154e-05 1.9019685483973129e-08
+ 7.4437516257653237e-05 6.3680162617685321e-08
+ 7.4437523659074334e-05 1.3464578979540883e-07
+ 7.4437531060495417e-05 2.3189729697639808e-07
+ 7.4437538461916513e-05 3.5541134357275011e-07
+ 7.443754751235569e-05 5.4209487018455778e-07
+ 7.4437556562794867e-05 7.6794744751962639e-07
+ 7.4437565613234057e-05 1.032901665904789e-06
+ 7.4437574663673234e-05 1.3368810846168448e-06
+ 7.4437583714112411e-05 1.6798002590529673e-06
+ 7.4437595044533509e-05 2.1638522289015684e-06
+ 7.4437606374954608e-05 2.7085809274094572e-06
+ 7.4437617705375706e-05 3.3137595140903088e-06
+ 7.4437629035796805e-05 3.9791394372703589e-06
+ 7.4437643214653366e-05 4.8961848891924115e-06
+ 7.4437657393509914e-05 5.9065041934527361e-06
+ 7.4437671572366476e-05 7.0094688242501652e-06
+ 7.4437689032396941e-05 8.4939484121898285e-06
+ 7.4437706492427405e-05 1.011650368403691e-05
+ 7.443772395245787e-05 1.187564441966631e-05
+ 7.4437746268477833e-05 1.4320324258348367e-05
+ 7.4437768584497809e-05 1.6981891243476683e-05
+ 7.4437790900517772e-05 1.9856448881756975e-05
+ 7.4437819090217248e-05 2.3785542948120637e-05
+ 7.4437847279916711e-05 2.8038794641957824e-05
+ 7.4437875469616187e-05 3.2606525910010655e-05
+ 7.4437903659315649e-05 3.7478440563006991e-05
+ 7.4437931849015125e-05 4.2643660624918842e-05
+ 7.4437960038714601e-05 4.809076449946518e-05
+ 7.4437988228414064e-05 5.3807826764352856e-05
+ 7.4438019414106479e-05 6.0432058501488789e-05
+ 7.4438050599798881e-05 6.7354141141263776e-05
+ 7.4438081785491297e-05 7.4556149339010216e-05
+ 7.4438112971183712e-05 8.2019674226669682e-05
+ 7.4438150418414345e-05 9.1300740447793598e-05
+ 7.4438187865644964e-05 0.00010089852928503813
+ 7.4438225312875597e-05 0.00011077933330704341
+ 7.4438270844195807e-05 0.00012312530862772575
+ 7.443831637551603e-05 0.00013577798574481139
+ 7.443836190683624e-05 0.00014867616552750304
+ 7.443840743815645e-05 0.00016175929991125412
+ 7.4438441084028115e-05 0.00017151113091571656
+ 7.4438474729899781e-05 0.00018130797963939794
+ 7.4438508375771446e-05 0.00019112690048319055
+ 7.4438542021643112e-05 0.000200945563836072
+ 7.4438575667514777e-05 0.0002107423308290232
+ 7.4438609313386443e-05 0.00022049632214156449
+ 7.4438642959258108e-05 0.00023018748061678874
+ 7.4438676605129774e-05 0.00023979662749408118
+ 7.4438710251001439e-05 0.0002493055121224335
+ 7.4438736870668156e-05 0.00025674620625396695
+ 7.4438763490334859e-05 0.00026410519322842072
+ 7.4438790110001576e-05 0.00027137476557784006
+ 7.4438816729668279e-05 0.00027854762813939171
+ 7.4438843349334996e-05 0.00028561690431054267
+ 7.4438869969001699e-05 0.0002925761407342706
+ 7.4438896588668415e-05 0.0002994193104460534
+ 7.4438923208335132e-05 0.00030614081452042582
+ 7.4438949828001835e-05 0.00031273548226053464
+ 7.4438976447668552e-05 0.00031919856997935221
+ 7.4439003067335255e-05 0.00032552575842600295
+ 7.4439029687001972e-05 0.00033171314891500655
+ 7.4439056306668675e-05 0.00033775725822013397
+ 7.4439082926335391e-05 0.00034365501229800138
+ 7.4439109546002095e-05 0.00034940373890948994
+ 7.4439136165668811e-05 0.00035500115920957621
+ 7.4439162785335528e-05 0.00036044537837818884
+ 7.4439189405002231e-05 0.00036573487536628151
+ 7.4439216024668948e-05 0.00037086849183281574
+ 7.4439239404935231e-05 0.00037524816041470616
+ 7.4439262785201514e-05 0.00037950661982143294
+ 7.4439286165467811e-05 0.00038364373347733212
+ 7.4439309545734094e-05 0.00038765955240256639
+ 7.443933292600039e-05 0.00039155430797307712
+ 7.4439356306266674e-05 0.00039532840450424615
+ 7.4439379686532957e-05 0.00039898241168751826
+ 7.4439403066799253e-05 0.00040251705690861332
+ 7.4439426447065537e-05 0.00040593321747524688
+ 7.443944982733182e-05 0.0004092319127814815
+ 7.4439473207598116e-05 0.00041241429643495774
+ 7.4439496587864399e-05 0.00041548164837231091
+ 7.4439519968130696e-05 0.00041843536698707185
+ 7.4439543348396979e-05 0.00042127696129328835
+ 7.4439566728663262e-05 0.00042400804314699181
+ 7.4439590108929559e-05 0.00042663031954648096
+ 7.4439613489195842e-05 0.00042914558503120656
+ 7.4439636869462125e-05 0.00043155571419782471
+ 7.4439660249728422e-05 0.00043386265435075173
+ 7.4439683629994705e-05 0.0004360684183033
+ 7.4439707010261002e-05 0.00043817507734421687
+ 7.4439735591237522e-05 0.00044061881915944171
+ 7.4439764172214043e-05 0.00044292160557832261
+ 7.4439792753190563e-05 0.00044508748731897325
+ 7.4439821334167097e-05 0.0004471205811035718
+ 7.4439849915143618e-05 0.00044902505354874717
+ 7.4439886199806216e-05 0.00045126415767136695
+ 7.4439925453373382e-05 0.00045347065125915753
+ 7.4439946977215268e-05 0.00045458914938144757
+ 7.4439973696714698e-05 0.00045589098737442259
+ 7.444000041621414e-05 0.00045710004038524538
+ 7.444002713571357e-05 0.00045821970861944291
+ 7.4440053855213013e-05 0.00045925335947318648
+ 7.4440080574712442e-05 0.00046020432082601948
+ 7.4440107294211885e-05 0.00046107587487371744
+ 7.4440134013711314e-05 0.00046187125249194449
+ 7.4440160733210757e-05 0.00046259362811953432
+ 7.4440187452710186e-05 0.00046324611514856153
+ 7.4440214172209629e-05 0.00046383176180687778
+ 7.4440240891709058e-05 0.00046435354751746608
+ 7.4440262548859619e-05 0.00046473161709406521
+ 7.4440284206010165e-05 0.00046507115570231151
+ 7.4440305863160725e-05 0.00046537364255429416
+ 7.4440327520311272e-05 0.00046564052306956875
+ 7.4440349177461819e-05 0.00046587320827894959
+ 7.4440370834612379e-05 0.00046607307433484731
+ 7.4440392491762926e-05 0.00046624146212347479
+ 7.4440414148913472e-05 0.00046637967697419719
+ 7.4440435806064032e-05 0.00046648898846127722
+ 7.4440457463214579e-05 0.00046657063029325929
+ 7.4440479120365126e-05 0.0004666258002852115
+ 7.4440496765399607e-05 0.00046665198683365781
+ 7.4440514410434075e-05 0.00046666198405394353
+ 7.4440532055468556e-05 0.00046665638716889121
+ 7.4440549700503024e-05 0.00046663577581361698
+ 7.4440567345537506e-05 0.00046660071413966874
+ 7.4440584990571973e-05 0.00046655175093608377
+ 7.4440602635606455e-05 0.00046648941976632619
+ 7.4440620280640923e-05 0.00046641423912008399
+ 7.4440637925675391e-05 0.00046632671257892689
+ 7.4440655570709872e-05 0.00046622732899484812
+ 7.444067321574434e-05 0.00046611656268073646
+ 7.4440690860778821e-05 0.00046599487361184948
+ 7.4440708505813289e-05 0.00046586270763738396
+ 7.444072615084777e-05 0.00046572049670126538
+ 7.4440743795882238e-05 0.00046556865907130521
+ 7.444076144091672e-05 0.00046540759957590188
+ 7.4440779085951187e-05 0.00046523770984748908
+ 7.4440796730985655e-05 0.00046505936857196291
+ 7.4440814376020137e-05 0.00046487294174334804
+ 7.4440832021054605e-05 0.00046467878292299136
+ 7.4440849666089086e-05 0.00046447723350260048
+ 7.4440867311123554e-05 0.00046426862297047311
+ 7.4440884956158035e-05 0.00046405326918029163
+ 7.4440902601192503e-05 0.00046383147862188659
+ 7.4440920246226971e-05 0.0004636035466933999
+ 7.4440937891261452e-05 0.00046336975797430831
+ 7.444095553629592e-05 0.00046313038649879376
+ 7.4440973181330401e-05 0.00046288569602897633
+ 7.4440990826364869e-05 0.00046263594032755121
+ 7.4441008471399351e-05 0.00046238136342939871
+ 7.4441026116433819e-05 0.00046212219991176166
+ 7.4441043761468286e-05 0.00046185867516261082
+ 7.4441061406502768e-05 0.00046159100564684353
+ 7.4441079051537236e-05 0.00046131939916998468
+ 7.4441096696571717e-05 0.00046104405513908457
+ 7.4441114341606185e-05 0.00046076516482052872
+ 7.4441131986640666e-05 0.00046048291159450004
+ 7.4441149631675134e-05 0.00046019747120585279
+ 7.4441167276709615e-05 0.00045990901201118061
+ 7.4441184921744083e-05 0.00045961769522188066
+ 7.4441202566778551e-05 0.00045932367514303494
+ 7.4441220211813033e-05 0.00045902709940794936
+ 7.44412378568475e-05 0.00045872810920820898
+ 7.4441255501881982e-05 0.00045842683951912496
+ 7.444127314691645e-05 0.00045812341932046545
+ 7.4441290791950931e-05 0.00045781797181237863
+ 7.4441308436985399e-05 0.00045751061462643097
+ 7.444132608201988e-05 0.00045720146003169808
+ 7.4441343727054348e-05 0.00045689061513585962
+ 7.4441361372088816e-05 0.00045657818208126165
+ 7.4441379017123297e-05 0.00045626425823592343
+ 7.4441396662157765e-05 0.0004559489363794755
+ 7.4441414307192246e-05 0.0004556323048840281
+ 7.4441431952226714e-05 0.00045531444788997848
+ 7.4441449597261196e-05 0.00045499544547677518
+ 7.4441467242295664e-05 0.00045467537382866608
+ 7.4441484887330131e-05 0.00045435430539546583
+ 7.4441502532364613e-05 0.00045403230904838535
+ 7.4441520177399081e-05 0.00045370945023097327
+ 7.4441537822433562e-05 0.00045338579110522598
+ 7.444155546746803e-05 0.00045306139069292836
+ 7.4441573112502511e-05 0.00045273630501229328
+ 7.4441590757536979e-05 0.00045241058720997258
+ 7.4441608402571447e-05 0.00045208428768851668
+ 7.4441626047605928e-05 0.00045175745422936376
+ 7.4441643692640396e-05 0.00045143013211144381
+ 7.4441661337674878e-05 0.00045110236422548483
+ 7.4441682620107576e-05 0.00045070649383213837
+ 7.4441702745281686e-05 0.00045033166770387813
+ 7.4441722870455783e-05 0.00044995642757493547
+ 7.4441742995629893e-05 0.00044958082330929242
+ 7.444176312080399e-05 0.00044920490166811688
+ 7.4441783245978086e-05 0.00044882870648050557
+ 7.4441803371152196e-05 0.00044845227880637947
+ 7.4441823496326293e-05 0.00044807565709178331
+ 7.4441843621500403e-05 0.00044769887731683952
+ 7.44418637466745e-05 0.00044732197313660687
+ 7.4441888110746133e-05 0.00044686556133260454
+ 7.4441912474817752e-05 0.00044640906499999366
+ 7.4441936838889384e-05 0.00044595253182312878
+ 7.4441961202961017e-05 0.00044549600565976083
+ 7.4441985567032636e-05 0.00044503952681690417
+ 7.4442009931104268e-05 0.00044458313230938829
+ 7.4442034295175901e-05 0.00044412685610195336
+ 7.444205865924752e-05 0.00044367072933572632
+ 7.4442083023319153e-05 0.00044321478053989036
+ 7.4442107387390772e-05 0.00044275903582933563
+ 7.4442136719683578e-05 0.00044221066197735565
+ 7.4442166051976371e-05 0.00044166265618977781
+ 7.4442195384269165e-05 0.00044111505229614979
+ 7.4442224716561958e-05 0.000440567880571222
+ 7.4442254048854751e-05 0.0004400211680723513
+ 7.4442283381147544e-05 0.0004394749389480193
+ 7.4442312713440337e-05 0.0004389292147195882
+ 7.444234204573313e-05 0.00043838401453830063
+ 7.4442377848029195e-05 0.00043771929099924211
+ 7.4442412335454629e-05 0.00043707976746529866
+ 7.4442446822880063e-05 0.00043644103787377733
+ 7.4442481310305498e-05 0.00043580312030283216
+ 7.4442515797730932e-05 0.00043516603032572377
+ 7.4442557828321217e-05 0.00043439073279079223
+ 7.4442599858911488e-05 0.00043361670459320404
+ 7.4442641889501773e-05 0.00043284396248195208
+ 7.4442683920092044e-05 0.00043207252012209858
+ 7.4442725950682329e-05 0.00043130238856505936
+ 7.4442777518503428e-05 0.00043035930871672526
+ 7.444282818666648e-05 0.00042943462880424378
+ 7.4442878854829545e-05 0.00042851188736760037
+ 7.4442929522992597e-05 0.00042759109050169295
+ 7.4442993215143461e-05 0.00042643637215815307
+ 7.4443056907294325e-05 0.0004252847370223043
+ 7.444312059944519e-05 0.00042413618616643506
+ 7.4443198945610723e-05 0.00042272760989246018
+ 7.4443278657649695e-05 0.00042129925771114857
+ 7.4443358369688666e-05 0.00041987571829712041
+ 7.4443461292370762e-05 0.00041804477075287836
+ 7.4443569508909817e-05 0.00041612824858809757
+ 7.4443701914804443e-05 0.00041379527174881443
+ 7.4443847065030184e-05 0.00041125276249577136
+ 7.4444034315235692e-05 0.00040799587225246868
+ 7.4444255865010434e-05 0.00040417569543334638
+ 7.444455403409251e-05 0.00039909077578923559
+ 7.4444998769870893e-05 0.00039162496079868337
+ 7.4445805003989002e-05 0.00037844492463713218
+ 7.4446711764368322e-05 0.00036415075183872955
+ 7.4447737475686449e-05 0.00034863113834200367
+ 7.444880114340234e-05 0.00033323544260725887
+ 7.4449944764949546e-05 0.00031744009309453978
+ 7.4452231646278912e-05 0.00028806442739914481
+ 7.445418268121666e-05 0.00026516169925578173
+ 7.4456291228517247e-05 0.00024245284579639417
+ 7.4458581467436169e-05 0.00021998507757767748
+ 7.4460926666850027e-05 0.00019913410083615226
+ 7.4463271866263885e-05 0.00018025945489984468
+ 7.4465590537179635e-05 0.00016335772611693962
+ 7.4468474569484288e-05 0.00014452917890563918
+ 7.4471358601788928e-05 0.00012787080313841811
+ 7.4474242634093581e-05 0.00011313246567173927
+ 7.4477126666398235e-05 0.00010009286360866482
+ 7.4480010698702874e-05 8.8556201336288662e-05
+ 7.4482894731007528e-05 7.8349250567829904e-05
+ 7.4485778763312181e-05 6.9318749243295542e-05
+ 7.4489342797663598e-05 5.9583601550415324e-05
+ 7.4492906832015015e-05 5.12156620124964e-05
+ 7.4496470866366432e-05 4.4022919356413453e-05
+ 7.4500034900717863e-05 3.7840328450154061e-05
+ 7.450359893506928e-05 3.2526023165760874e-05
+ 7.4507899961127359e-05 2.7096692323683933e-05
+ 7.4512200987185453e-05 2.2573641128908005e-05
+ 7.4516502013243546e-05 1.8805590756409222e-05
+ 7.4520803039301625e-05 1.5666514280396347e-05
+ 7.4525104065359719e-05 1.3051421554109079e-05
+ 7.4530502505986982e-05 1.0377818664489998e-05
+ 7.4535900946614246e-05 8.251909089995107e-06
+ 7.4541299387241523e-05 6.5614966739560858e-06
+ 7.4546697827868787e-05 5.2173688876777125e-06
+ 7.4553468247657475e-05 3.9138135354349389e-06
+ 7.4560238667446162e-05 2.9359531577328348e-06
+ 7.456700908723485e-05 2.2024124497970242e-06
+ 7.4575385304343956e-05 1.5432541258101081e-06
+ 7.4583761521453075e-05 1.081378721967762e-06
+ 7.4592137738562181e-05 7.5774041132707628e-07
+ 7.460304338548866e-05 4.7689837631713853e-07
+ 7.4613949032415139e-05 3.0015113649486665e-07
+ 7.4626156063665138e-05 1.7876217937191045e-07
+ 7.4638363094915136e-05 1.0647330757921957e-07
+ 7.4650570126165135e-05 6.3424252544034479e-08
+ 7.4662777157415134e-05 3.7787934734000867e-08
+ 7.4674984188665132e-05 2.2521155841269887e-08
+ 7.4687191219915131e-05 1.3429588576020001e-08
+ 7.469939825116513e-05 8.015449872567151e-09
+ 7.4711605282415142e-05 4.7912734917149069e-09
+ 7.4723812313665141e-05 2.871251600636248e-09
+ 7.4736019344915139e-05 1.7278727196949598e-09
+ 7.4748226376165138e-05 1.0469960699243559e-09
+ 7.4760433407415137e-05 6.4154623608527275e-10
+ 7.4772640438665135e-05 4.0011708092908531e-10
+ 7.4784847469915134e-05 2.563646256420896e-10
+ 7.4797054501165146e-05 1.7078006330613652e-10
+ 7.4809261532415145e-05 1.1983532309874618e-10
+ 7.4821468563665143e-05 8.9519095817165878e-11
+ 7.4833675594915142e-05 7.14874426319846e-11
+ 7.4845882626165141e-05 6.0771426293748156e-11
+ 7.4858089657415139e-05 5.4411972164600532e-11
+ 7.4870296688665138e-05 5.0646908151112081e-11
+ 7.4882503719915137e-05 4.8426835103990855e-11
+ 7.4894710751165135e-05 4.7126820532761082e-11
+ 7.4906917782415147e-05 4.6374708016315066e-11
+ 7.4919124813665146e-05 4.594887297816922e-11
+ 7.4931331844915145e-05 4.5717334758833713e-11
+ 7.4943538876165143e-05 4.5601496954841019e-11
+ 7.4955745907415142e-05 4.5554554261028926e-11
+ 7.4967952938665141e-05 4.5548633436145208e-11
+ 7.4980159969915139e-05 4.5567135561437956e-11
+ 7.4992367001165152e-05 4.5600175741221697e-11
+ 7.5000000000000007e-05 4.5624752229059989e-11
+ 7.5012207031250006e-05 4.5669966819297461e-11
+ 7.5024414062500004e-05 4.5718898557805248e-11
+ 7.5036621093750003e-05 4.5770037749483043e-11
+ 7.5048828125000002e-05 4.5822485350610839e-11
+ 7.506103515625e-05 4.5875705969269391e-11
+ 7.5073242187500012e-05 4.5929380773488921e-11
+ 7.5085449218750011e-05 4.5983319895906806e-11
+ 7.509765625000001e-05 4.6037410269464089e-11
+ 7.5109863281250008e-05 4.6091584562801975e-11
+ 7.5122070312500007e-05 4.6145802680837535e-11
+ 7.5134277343750006e-05 4.6200040748086769e-11
+ 7.5146484375000004e-05 4.6254284548072891e-11
+ 7.5158691406250003e-05 4.6308525616398256e-11
+ 7.5170898437500002e-05 4.6362758914111761e-11
+ 7.518310546875e-05 4.641698144216514e-11
+ 7.5195312500000013e-05 4.6471191416301583e-11
+ 7.5207519531250011e-05 4.6525387775689795e-11
+ 7.521972656250001e-05 4.6579569890308451e-11
+ 7.5231933593750009e-05 4.663373738668933e-11
+ 7.5244140625000007e-05 4.6687890044144897e-11
+ 7.5256347656250006e-05 4.6742027732970226e-11
+ 7.5268554687500005e-05 4.6796150377641402e-11
+ 7.5280761718750003e-05 4.6850257934899579e-11
+ 7.5292968750000002e-05 4.690435038069982e-11
+ 7.530517578125e-05 4.695842770243876e-11
+ 7.5317382812500013e-05 4.7012489894326265e-11
+ 7.5329589843750011e-05 4.7066536954629075e-11
+ 7.534179687500001e-05 4.7120568884029375e-11
+ 7.5354003906250009e-05 4.7174585684647293e-11
+ 7.5366210937500007e-05 4.7228587359458799e-11
+ 7.5378417968750006e-05 4.728257391194907e-11
+ 7.5390625000000005e-05 4.7336545345906017e-11
+ 7.5402832031250003e-05 4.7390501665297362e-11
+ 7.5415039062500002e-05 4.7444442874197415e-11
+ 7.5427246093750001e-05 4.7498368976743532e-11
+ 7.5439453125000013e-05 4.7552279977110043e-11
+ 7.5451660156250011e-05 4.7606175879492929e-11
+ 7.546386718750001e-05 4.76600566881005e-11
+ 7.5476074218750009e-05 4.771392240714795e-11
+ 7.5488281250000007e-05 4.7767773040854128e-11
+ 7.5500488281250006e-05 4.7821608593439534e-11
+ 7.5512695312500005e-05 4.7875429069125182e-11
+ 7.5524902343750003e-05 4.7929234472131972e-11
+ 7.5537109375000002e-05 4.7983024806680162e-11
+ 7.5549316406250001e-05 4.8036800076989225e-11
+ 7.5561523437500013e-05 4.8090560287277661e-11
+ 7.5573730468750012e-05 4.81443054417629e-11
+ 7.558593750000001e-05 4.8198035544661283e-11
+ 7.5598144531250009e-05 4.8251750600188019e-11
+ 7.5610351562500008e-05 4.8305450612557161e-11
+ 7.5622558593750006e-05 4.835913558598157e-11
+ 7.5634765625000005e-05 4.8412805524672993e-11
+ 7.5646972656250003e-05 4.846646043284194e-11
+ 7.5659179687500002e-05 4.8520100314697792e-11
+ 7.5671386718750001e-05 4.8573725174448732e-11
+ 7.5683593750000013e-05 4.8627335016301782e-11
+ 7.5695800781250012e-05 4.8680929844462761e-11
+ 7.570800781250001e-05 4.8734509663136332e-11
+ 7.5720214843750009e-05 4.8788074476525962e-11
+ 7.5732421875000008e-05 4.8841624288833967e-11
+ 7.5744628906250006e-05 4.8895159104261467e-11
+ 7.5756835937500005e-05 4.894867892700839e-11
+ 7.5769042968750004e-05 4.9002183761273549e-11
+ 7.5781250000000002e-05 4.905567361125451e-11
+ 7.5793457031250001e-05 4.9109148481147716e-11
+ 7.5805664062500013e-05 4.9162608375148381e-11
+ 7.5817871093750012e-05 4.9216053297450589e-11
+ 7.583007812500001e-05 4.9269483252247235e-11
+ 7.5842285156250009e-05 4.932289824373005e-11
+ 7.5854492187500008e-05 4.9376298276089576e-11
+ 7.5866699218750006e-05 4.9429683353515166e-11
+ 7.5878906250000005e-05 4.9483053480195042e-11
+ 7.5891113281250004e-05 4.9536408660316226e-11
+ 7.5903320312500002e-05 4.9589748898064572e-11
+ 7.5915527343750015e-05 4.9643074197624777e-11
+ 7.5927734375000013e-05 4.9696384563180337e-11
+ 7.5939941406250012e-05 4.9749679998913594e-11
+ 7.5952148437500011e-05 4.980296050900572e-11
+ 7.5964355468750009e-05 4.9856226097636712e-11
+ 7.5976562500000008e-05 4.99094767689854e-11
+ 7.5988769531250007e-05 4.9962712527229435e-11
+ 7.6000976562500005e-05 5.0015933376545304e-11
+ 7.6013183593750004e-05 5.0069139321108297e-11
+ 7.6025390625000002e-05 5.0122330365092602e-11
+ 7.6037597656250001e-05 5.0175506512671175e-11
+ 7.6049804687500013e-05 5.0228667768015851e-11
+ 7.6062011718750012e-05 5.0281814135297241e-11
+ 7.6074218750000011e-05 5.0334945618684835e-11
+ 7.6086425781250009e-05 5.0388062222346936e-11
+ 7.6098632812500008e-05 5.0441163950450669e-11
+ 7.6110839843750007e-05 5.0494250807162017e-11
+ 7.6123046875000005e-05 5.0547322796645784e-11
+ 7.6135253906250004e-05 5.060037992306559e-11
+ 7.6147460937500003e-05 5.0653422190583924e-11
+ 7.6159667968750001e-05 5.0706449603362099e-11
+ 7.6171875000000013e-05 5.0759462165560252e-11
+ 7.6184082031250012e-05 5.0812459881337356e-11
+ 7.6196289062500011e-05 5.086544275485121e-11
+ 7.6208496093750009e-05 5.0918410790258479e-11
+ 7.6220703125000008e-05 5.0971363991714641e-11
+ 7.6232910156250007e-05 5.1024302363374004e-11
+ 7.6245117187500005e-05 5.1077225909389738e-11
+ 7.6257324218750004e-05 5.1130134633913832e-11
+ 7.6269531250000003e-05 5.1183028541097097e-11
+ 7.6281738281250001e-05 5.123590763508922e-11
+ 7.62939453125e-05 5.1288771920038706e-11
+ 7.6306152343750012e-05 5.1341621400092889e-11
+ 7.6318359375000011e-05 5.1394456079397949e-11
+ 7.633056640625001e-05 5.1447275962098919e-11
+ 7.6342773437500008e-05 5.1500081052339658e-11
+ 7.6354980468750007e-05 5.1552871354262853e-11
+ 7.6367187500000005e-05 5.1605646872010057e-11
+ 7.6379394531250004e-05 5.1658407609721638e-11
+ 7.6391601562500003e-05 5.171115357153682e-11
+ 7.6403808593750001e-05 5.1763884761593666e-11
+ 7.6416015625e-05 5.1816601184029079e-11
+ 7.6428222656249999e-05 5.1869302842978788e-11
+ 7.6440429687500011e-05 5.1921989742577379e-11
+ 7.645263671875001e-05 5.1974661886958285e-11
+ 7.6464843750000008e-05 5.2027319280253771e-11
+ 7.6477050781250007e-05 5.2079961926594946e-11
+ 7.6489257812500006e-05 5.2132589830111786e-11
+ 7.6501464843750004e-05 5.2185202994933079e-11
+ 7.6513671875000003e-05 5.2237801425186463e-11
+ 7.6525878906250002e-05 5.2290385124998426e-11
+ 7.65380859375e-05 5.2342954098494298e-11
+ 7.6550292968749999e-05 5.2395508349798247e-11
+ 7.6562499999999998e-05 5.2448047883033309e-11
+ 7.657470703125001e-05 5.2500572702321331e-11
+ 7.6586914062500008e-05 5.2553082811783024e-11
+ 7.6599121093750007e-05 5.260557821553798e-11
+ 7.6611328125000006e-05 5.265805891770455e-11
+ 7.6623535156250004e-05 5.2710524922400013e-11
+ 7.6635742187500003e-05 5.2762976233740464e-11
+ 7.6647949218750002e-05 5.281541285584085e-11
+ 7.666015625e-05 5.2867834792814952e-11
+ 7.6672363281249999e-05 5.2920242048775429e-11
+ 7.6684570312499998e-05 5.297263462783375e-11
+ 7.669677734375001e-05 5.3025012534100265e-11
+ 7.6708984375000009e-05 5.3077375771684144e-11
+ 7.6721191406250007e-05 5.3129724344693429e-11
+ 7.6733398437500006e-05 5.3182058257235008e-11
+ 7.6745605468750004e-05 5.3234377513414598e-11
+ 7.6757812500000003e-05 5.3286682117336819e-11
+ 7.6770019531250002e-05 5.3338972073105086e-11
+ 7.67822265625e-05 5.339124738482168e-11
+ 7.6794433593749999e-05 5.3443508056587737e-11
+ 7.6806640624999998e-05 5.349575409250326e-11
+ 7.6818847656249996e-05 5.3547985496667078e-11
+ 7.6831054687500009e-05 5.3600202273176877e-11
+ 7.6843261718750007e-05 5.3652404426129203e-11
+ 7.6855468750000006e-05 5.3704591959619454e-11
+ 7.6867675781250005e-05 5.3756764877741888e-11
+ 7.6879882812500003e-05 5.3808923184589598e-11
+ 7.6892089843750002e-05 5.3861066884254534e-11
+ 7.6904296875000001e-05 5.3913195980827531e-11
+ 7.6916503906249999e-05 5.3965310478398236e-11
+ 7.6928710937499998e-05 5.4017410381055188e-11
+ 7.6940917968749997e-05 5.4069495692885746e-11
+ 7.6953125000000009e-05 5.4121566417976143e-11
+ 7.6965332031250007e-05 5.4173622560411455e-11
+ 7.6977539062500006e-05 5.4225664124275648e-11
+ 7.6989746093750005e-05 5.4277691113651499e-11
+ 7.7001953125000003e-05 5.4329703532620677e-11
+ 7.7014160156250002e-05 5.4381701385263697e-11
+ 7.7026367187500001e-05 5.4433684675659917e-11
+ 7.7038574218749999e-05 5.4485653407887576e-11
+ 7.7050781249999998e-05 5.4537607586023745e-11
+ 7.7062988281249997e-05 5.4589547214144361e-11
+ 7.7075195312499995e-05 5.4641472296324253e-11
+ 7.7087402343750007e-05 5.4693382836637059e-11
+ 7.7099609375000006e-05 5.4745278839155299e-11
+ 7.7111816406250005e-05 5.4797160307950356e-11
+ 7.7124023437500003e-05 5.4849027247092475e-11
+ 7.7136230468750002e-05 5.4900879660650734e-11
+ 7.7148437500000001e-05 5.4952717552693121e-11
+ 7.7160644531249999e-05 5.5004540927286431e-11
+ 7.7172851562499998e-05 5.5055228596414379e-11
+ 7.7185058593749997e-05 5.510627065877697e-11
+ 7.7197265624999995e-05 5.5158092921228189e-11
+ 7.7209472656249994e-05 5.5210849104087091e-11
+ 7.7221679687500006e-05 5.5264521350196526e-11
+ 7.7233886718750005e-05 5.5318219478297029e-11
+ 7.7239990234375004e-05 5.5343709041866146e-11
+ 7.7246093750000004e-05 5.5365175813779936e-11
+ 7.7249145507812496e-05 5.537183500008943e-11
+ 7.7252197265625003e-05 5.5371668509114686e-11
+ 7.7255249023437496e-05 5.5354771851498252e-11
+ 7.7256606790774088e-05 5.5334751403020664e-11
+ 7.7256998216660867e-05 5.5326313558461538e-11
+ 7.7257389642547647e-05 5.5316205768572161e-11
+ 7.7258368207264576e-05 5.5280832763072969e-11
+ 7.7259409502908186e-05 5.5216998316807767e-11
+ 7.7259970598735322e-05 5.5162661637241072e-11
+ 7.7260339629298374e-05 5.5114439869388932e-11
+ 7.7261110323815843e-05 5.4960015216721681e-11
+ 7.7261741481233852e-05 5.4732817211499076e-11
+ 7.7262113084009015e-05 5.4516300482441227e-11
+ 7.7262434193795792e-05 5.42419953316085e-11
+ 7.7262647097925421e-05 5.400886072195258e-11
+ 7.7262860002055037e-05 5.3774257755821461e-11
+ 7.7264989043351244e-05 5.1549852354822979e-11
+ 7.7277196074601256e-05 4.2855387214314058e-11
+ 7.7289403105851255e-05 4.053247294954365e-11
+ 7.7301610137101254e-05 4.3931039996784842e-11
+ 7.7313817168351252e-05 5.2388572167819672e-11
+ 7.7326024199601251e-05 6.5140225940715896e-11
+ 7.733823123085125e-05 8.1286621114128428e-11
+ 7.7350438262101248e-05 9.9800201152591339e-11
+ 7.7362645293351247e-05 1.1955731974057662e-10
+ 7.7374852324601246e-05 1.3938677731239894e-10
+ 7.7387059355851244e-05 1.581275910662053e-10
+ 7.7399266387101256e-05 1.7469004130247602e-10
+ 7.7411473418351255e-05 1.881149150311095e-10
+ 7.7423680449601254e-05 1.9762660690176225e-10
+ 7.7435887480851252e-05 2.026764694324815e-10
+ 7.7448094512101251e-05 2.0297359093770258e-10
+ 7.746030154335125e-05 1.9850103705845601e-10
+ 7.7472508574601248e-05 1.8951650785639057e-10
+ 7.7484715605851247e-05 1.7653730627935789e-10
+ 7.7496922637101246e-05 1.6031044421422816e-10
+ 7.7509129668351244e-05 1.4176958358946107e-10
+ 7.7521336699601243e-05 1.2198127662112241e-10
+ 7.7533543730851255e-05 1.0208359001036545e-10
+ 7.7545750762101254e-05 8.3220638681385549e-11
+ 7.7557957793351252e-05 6.6476791169901555e-11
+ 7.7561009551163745e-05 6.2738216402259133e-11
+ 7.7561314726944997e-05 6.2375524734021021e-11
+ 7.7562077666398121e-05 6.1477937832984702e-11
+ 7.7562459136124682e-05 6.1034090082773124e-11
+ 7.75624829779826e-05 6.1006459924724939e-11
+ 7.7562487746354183e-05 6.1000935454857881e-11
+ 7.7562497283097337e-05 6.0989888077255491e-11
+ 7.7562498046036799e-05 6.0989004377034889e-11
+ 7.7562499571915696e-05 6.0987237016591268e-11
+ 7.7562499693986019e-05 6.0987095630059761e-11
+ 7.7562499938126637e-05 6.0986812858020706e-11
+ 7.7562499957657888e-05 6.0986790236316644e-11
+ 7.7562499996720392e-05 6.098674499293473e-11
+ 7.7562500074845384e-05 6.2330481534674083e-11
+ 7.7562500152970391e-05 6.6608198187672893e-11
+ 7.7562500934220388e-05 2.7075208822833839e-10
+ 7.7562508051845982e-05 1.5641542586395462e-08
+ 7.7562515169471576e-05 5.5354276368357439e-08
+ 7.7562522287097171e-05 1.1939590331347595e-07
+ 7.7562529404722765e-05 2.0774988808958391e-07
+ 7.7562536522348373e-05 3.2039621340029153e-07
+ 7.7562543639973967e-05 4.5731138406416947e-07
+ 7.7562550757599561e-05 6.1846843192454422e-07
+ 7.7562557875225156e-05 8.0383692158836119e-07
+ 7.756256499285075e-05 1.0133829569922963e-06
+ 7.7562572110476344e-05 1.2470691887940203e-06
+ 7.7562579228101938e-05 1.5048548225862434e-06
+ 7.7562587807568584e-05 1.8475543476526228e-06
+ 7.7562596387035202e-05 2.2251205386231599e-06
+ 7.7562604966501848e-05 2.637462112110794e-06
+ 7.7562613545968466e-05 3.0844806091734263e-06
+ 7.7562622125435112e-05 3.5660704276185103e-06
+ 7.7562630704901731e-05 4.0821188567621002e-06
+ 7.7562639284368376e-05 4.6325061146258863e-06
+ 7.7562647863834995e-05 5.2171053875545835e-06
+ 7.7562658180770262e-05 5.965211217502911e-06
+ 7.7562668497705516e-05 6.7623492313414161e-06
+ 7.7562678814640769e-05 7.6082590651614992e-06
+ 7.7562689131576023e-05 8.5026660760363497e-06
+ 7.7562699448511277e-05 9.4452814742207388e-06
+ 7.756270976544653e-05 1.0435802462230257e-05
+ 7.7562720082381784e-05 1.147391238070454e-05
+ 7.7562730399317051e-05 1.25592808609545e-05
+ 7.756274290201226e-05 1.393744004677843e-05
+ 7.7562755404707483e-05 1.538385928477854e-05
+ 7.7562767907402705e-05 1.6897871760843825e-05
+ 7.7562780410097928e-05 1.8478782715895571e-05
+ 7.7562792912793136e-05 2.0125869935940648e-05
+ 7.7562805415488359e-05 2.1838384260846487e-05
+ 7.7562817918183581e-05 2.3615550111329756e-05
+ 7.7562830420878804e-05 2.5456566033633845e-05
+ 7.7562845592253878e-05 2.7775100207116592e-05
+ 7.7562860763628953e-05 3.0184906039223483e-05
+ 7.7562875935004042e-05 3.2684405463249104e-05
+ 7.7562891106379116e-05 3.5271969973378807e-05
+ 7.7562906277754205e-05 3.7945922288216153e-05
+ 7.7562921449129279e-05 4.0704538058428326e-05
+ 7.7562936620504354e-05 4.3546047616054653e-05
+ 7.7562954860519565e-05 4.7069469432613542e-05
+ 7.7562973100534776e-05 5.0706855826657106e-05
+ 7.7562991340549987e-05 5.4454893918205257e-05
+ 7.7563009580565185e-05 5.8310193146384224e-05
+ 7.7563027820580396e-05 6.2269290123695639e-05
+ 7.7563046060595607e-05 6.6328653564053143e-05
+ 7.7563068199865856e-05 7.1385338233594827e-05
+ 7.7563090339136104e-05 7.6577901326810804e-05
+ 7.7563112478406352e-05 8.189969012601315e-05
+ 7.7563134617676601e-05 8.7343953274172687e-05
+ 7.7563161293011325e-05 9.4056657818521804e-05
+ 7.7563187873095813e-05 0.00010090035482762358
+ 7.7563214453180301e-05 0.00010788664307091889
+ 7.7563248688484345e-05 0.00011707548567577072
+ 7.756328292378839e-05 0.00012645461865043843
+ 7.7563315356127052e-05 0.00013549167951766453
+ 7.7563347788465713e-05 0.00014465398332574899
+ 7.7563380220804375e-05 0.00015391958689944246
+ 7.756341265314305e-05 0.00016326679416820027
+ 7.7563445085481711e-05 0.00017267423453976973
+ 7.7563477517820373e-05 0.00018212093762926101
+ 7.7563509950159034e-05 0.00019158640400330904
+ 7.7563542382497695e-05 0.00020105067163597072
+ 7.7563569584998147e-05 0.00020897371829601134
+ 7.7563596787498599e-05 0.00021687121736840308
+ 7.7563623989999065e-05 0.0002247324443841368
+ 7.7563651192499516e-05 0.00023254704172942061
+ 7.7563678394999968e-05 0.00024030503688061725
+ 7.756370559750042e-05 0.00024799685880477063
+ 7.7563732800000872e-05 0.00025561335251051022
+ 7.7563760002501324e-05 0.00026314579174345146
+ 7.7563787205001776e-05 0.00027058588982929906
+ 7.7563814407502241e-05 0.00027792580867665878
+ 7.7563841610002693e-05 0.0002851581659600263
+ 7.7563868812503145e-05 0.00029227604051150784
+ 7.7563896015003596e-05 0.00029927297595749906
+ 7.7563923217504048e-05 0.00030614298264376868
+ 7.75639504200045e-05 0.00031288053789913813
+ 7.7563977622504952e-05 0.00031948058469418605
+ 7.7564004825005404e-05 0.00032593852875712024
+ 7.7564032027505856e-05 0.00033225023421413059
+ 7.7564059230006321e-05 0.00033841201782615327
+ 7.7564086432506773e-05 0.0003444206418985982
+ 7.756411530088351e-05 0.00035062659892727544
+ 7.7564144169260234e-05 0.0003566540934654631
+ 7.7564173037636972e-05 0.00036250083298786399
+ 7.7564201906013709e-05 0.00036816503744223664
+ 7.7564230774390447e-05 0.00037364542226806104
+ 7.7564259642767184e-05 0.00037894118026981165
+ 7.7564288511143908e-05 0.00038405196247931109
+ 7.7564317379520646e-05 0.000388977858140999
+ 7.7564346247897383e-05 0.00039371937395252178
+ 7.7564381135166686e-05 0.0003992047348763101
+ 7.7564416022435988e-05 0.00040442447430172904
+ 7.7564449985506056e-05 0.00040925368585940502
+ 7.7564483948576124e-05 0.00041383750344981278
+ 7.7564517911646178e-05 0.00041817993390062743
+ 7.7564551874716246e-05 0.00042228549548244641
+ 7.7564585837786314e-05 0.00042615916749456922
+ 7.7564627381082827e-05 0.0004305900119691504
+ 7.7564668924379339e-05 0.00043469258490726371
+ 7.7564710467675852e-05 0.0004384781612780042
+ 7.7564752010972365e-05 0.00044195857402361564
+ 7.7564802322523108e-05 0.00044578261210212054
+ 7.7564853125173646e-05 0.00044923093231022854
+ 7.7564903927824171e-05 0.00045228765276156626
+ 7.7564971607266259e-05 0.00045579239535176001
+ 7.7565039286708334e-05 0.00045870005395461338
+ 7.7565091919396567e-05 0.00046058369469111949
+ 7.7565144552084814e-05 0.00046216451732223918
+ 7.756519718477306e-05 0.00046346681282214352
+ 7.7565249817461307e-05 0.00046451393123718372
+ 7.7565297809929109e-05 0.00046526519657479943
+ 7.756534580239691e-05 0.00046583893527304737
+ 7.7565393794864712e-05 0.00046625041073407677
+ 7.7565441787332513e-05 0.00046651403875466578
+ 7.7565489779800315e-05 0.0004666433740508164
+ 7.7565537261554873e-05 0.00046665162291553914
+ 7.7565584743309417e-05 0.000466552308242554
+ 7.7565632225063961e-05 0.00046635608374731292
+ 7.7565679706818519e-05 0.00046607281339991539
+ 7.7565727188573064e-05 0.00046571159614456351
+ 7.7565774670327621e-05 0.00046528079492301239
+ 7.7565824358583369e-05 0.00046476378468933915
+ 7.7565874046839131e-05 0.00046418694952370777
+ 7.7565923735094879e-05 0.00046355752837163748
+ 7.756597342335064e-05 0.00046288205221083837
+ 7.7566023111606401e-05 0.00046216639229460844
+ 7.7566072799862149e-05 0.00046141580830294233
+ 7.7566127951386081e-05 0.00046054748419045071
+ 7.7566183102910013e-05 0.00045964758393211987
+ 7.7566238254433932e-05 0.00045872107390199996
+ 7.7566293405957864e-05 0.00045777228079549998
+ 7.7566348557481783e-05 0.00045680495887963081
+ 7.7566411640520548e-05 0.000455679953428722
+ 7.75664747235593e-05 0.00045453907391423655
+ 7.7566537806598066e-05 0.0004533857886546739
+ 7.7566600889636818e-05 0.00045222299034028662
+ 7.7566674140146425e-05 0.00045086399130210022
+ 7.7566747390656046e-05 0.00044949844535668453
+ 7.7566820641165654e-05 0.00044812878579885432
+ 7.7566905619421586e-05 0.00044653719761490697
+ 7.7566990597677531e-05 0.0004449449586312652
+ 7.7567093836844786e-05 0.00044301214871122791
+ 7.7567198171769425e-05 0.00044106269601017851
+ 7.7567302506694049e-05 0.00043911870626636078
+ 7.7567426664469175e-05 0.00043681393387383496
+ 7.7567550822244287e-05 0.00043451951813961668
+ 7.7567705800806537e-05 0.00043167106196547318
+ 7.756788493713179e-05 0.00042840086834201771
+ 7.75680985566024e-05 0.00042453293757745131
+ 7.7568364485722962e-05 0.00041976628303681877
+ 7.7568717982712211e-05 0.00041351261779238365
+ 7.7569242097564153e-05 0.00040441158298440465
+ 7.7570136340120486e-05 0.00038934346113524376
+ 7.7572132807185044e-05 0.00035769765454050228
+ 7.7573988816858022e-05 0.00033058981538904275
+ 7.7576421668443086e-05 0.00029814348467284587
+ 7.7578854520028151e-05 0.00026888165874455468
+ 7.7581287371613215e-05 0.00024249178888257299
+ 7.7583720223198279e-05 0.00021869200206866874
+ 7.7586153074783344e-05 0.00019722808975099272
+ 7.7588585926368408e-05 0.00017787079297825666
+ 7.7591018777953472e-05 0.00016041335425741158
+ 7.7593451629538537e-05 0.0001446693086575522
+ 7.7595767705239784e-05 0.00013111903917235234
+ 7.7598819440406722e-05 0.00011518312547724692
+ 7.7601871175573661e-05 0.00010118403045864018
+ 7.7604922910740599e-05 8.8886357108097517e-05
+ 7.7607974645907537e-05 7.8083318131395906e-05
+ 7.7611026381074476e-05 6.8593258842393536e-05
+ 7.7614078116241414e-05 6.025660181923537e-05
+ 7.7617773618773601e-05 5.1505809187250614e-05
+ 7.7621134288610919e-05 4.4656271026532631e-05
+ 7.7624494958448224e-05 3.8717628008379948e-05
+ 7.7628620731690288e-05 3.2495702272495222e-05
+ 7.7632746504932337e-05 2.7273646663031209e-05
+ 7.7636872278174401e-05 2.2890780980831938e-05
+ 7.7640998051416464e-05 1.9212246512347876e-05
+ 7.7645123824658527e-05 1.6124856494297113e-05
+ 7.7650251138437103e-05 1.2970141364146993e-05
+ 7.765537845221568e-05 1.0432633172092827e-05
+ 7.7660505765994269e-05 8.3915781182774641e-06
+ 7.7665633079772846e-05 6.7498471833962207e-06
+ 7.7671995979825153e-05 5.1518189724579756e-06
+ 7.7678358879877473e-05 3.9321378049054371e-06
+ 7.768472177992978e-05 3.0012267671564931e-06
+ 7.7692497256254511e-05 2.15737185496337e-06
+ 7.7700272732579256e-05 1.5508026051292012e-06
+ 7.7708048208904e-05 1.1147960586695601e-06
+ 7.7717983441936069e-05 7.3118840550782522e-07
+ 7.7727918674968152e-05 4.7961075194826108e-07
+ 7.7740125706218151e-05 2.8571159964289929e-07
+ 7.775233273746815e-05 1.7024209705967684e-07
+ 7.7764539768718148e-05 1.0147848625806179e-07
+ 7.7776746799968147e-05 6.0528851952355526e-08
+ 7.7788953831218146e-05 3.6142806128821739e-08
+ 7.7801160862468144e-05 2.1620593980565466e-08
+ 7.7813367893718143e-05 1.2972424953734794e-08
+ 7.7825574924968142e-05 7.8223266739669589e-09
+ 7.7837781956218154e-05 4.7553755500354248e-09
+ 7.7849988987468153e-05 2.9289656540459339e-09
+ 7.7862196018718151e-05 1.8413143839828223e-09
+ 7.787440304996815e-05 1.1936037658401295e-09
+ 7.7886610081218149e-05 8.078836241498485e-10
+ 7.7898817112468147e-05 5.7818218790680653e-10
+ 7.7911024143718146e-05 4.4139192644487092e-10
+ 7.7923231174968144e-05 3.5993152647751398e-10
+ 7.7935438206218143e-05 3.1142080027758294e-10
+ 7.7947645237468142e-05 2.8253202431124535e-10
+ 7.795985226871814e-05 2.653283707170538e-10
+ 7.7972059299968153e-05 2.5508336753526945e-10
+ 7.7984266331218151e-05 2.4898233649178344e-10
+ 7.799647336246815e-05 2.4534909287155193e-10
+ 7.8008680393718149e-05 2.4318544696123555e-10
+ 7.8020887424968147e-05 2.4189696683490067e-10
+ 7.8033094456218146e-05 2.411296605642883e-10
+ 7.8045301487468145e-05 2.406727199550333e-10
+ 7.8057508518718143e-05 2.4040060549918595e-10
+ 7.8069715549968142e-05 2.4023855751768804e-10
+ 7.8081922581218141e-05 2.4014205601586099e-10
+ 7.8094129612468153e-05 2.4008458822552009e-10
+ 7.8106336643718151e-05 2.4005036536744095e-10
+ 7.811854367496815e-05 2.4002998505548136e-10
+ 7.8130750706218149e-05 2.4001784836154639e-10
+ 7.8142957737468147e-05 2.4001062082534474e-10
+ 7.8155164768718146e-05 2.4000631674323626e-10
+ 7.8167371799968145e-05 2.4000375361391963e-10
+ 7.8179578831218143e-05 2.4000222718017004e-10
+ 7.8191785862468142e-05 2.4000131819356677e-10
+ 7.8203992893718141e-05 2.4000077702242996e-10
+ 7.8216199924968139e-05 2.4000045459933931e-10
+ 7.8228406956218152e-05 2.4000026257884156e-10
+ 7.824061398746815e-05 2.4000014832025053e-10
+ 7.8252821018718149e-05 2.4000008023582484e-10
+ 7.8265028049968148e-05 2.4000003966625581e-10
+ 7.8277235081218146e-05 2.400000155533385e-10
+ 7.8289442112468145e-05 2.4000000121814107e-10
+ 7.8301649143718143e-05 2.3999999261673205e-10
+ 7.8313856174968142e-05 2.3999998758456908e-10
+ 7.8326063206218141e-05 2.3999998453222656e-10
+ 7.8338270237468139e-05 2.3999998265390494e-10
+ 7.8350477268718152e-05 2.3999998161732485e-10
+ 7.836268429996815e-05 2.3999998104358188e-10
+ 7.8374891331218149e-05 2.3999998057389865e-10
+ 7.8387098362468148e-05 2.3999998026292464e-10
+ 7.8399305393718146e-05 2.3999998019001177e-10
+ 7.8411512424968145e-05 2.3999998019899801e-10
+ 7.8423719456218144e-05 2.3999998020597388e-10
+ 7.8435926487468142e-05 2.3999998012855701e-10
+ 7.8448133518718141e-05 2.3999998005534517e-10
+ 7.846034054996814e-05 2.3999998008389102e-10
+ 7.8472547581218138e-05 2.3999998009224399e-10
+ 7.848475461246815e-05 2.3999998012219294e-10
+ 7.8496961643718149e-05 2.3999998013282356e-10
+ 7.8509168674968148e-05 2.3999998009115475e-10
+ 7.8521375706218146e-05 2.3999998009706464e-10
+ 7.8533582737468145e-05 2.3999998010363494e-10
+ 7.8545789768718144e-05 2.3999998011314167e-10
+ 7.8557996799968142e-05 2.3999998013616955e-10
+ 7.8570203831218141e-05 2.3999998011363462e-10
+ 7.858241086246814e-05 2.3999998009274014e-10
+ 7.8594617893718138e-05 2.399999801011231e-10
+ 7.8606824924968137e-05 2.399999800977465e-10
+ 7.8619031956218149e-05 2.3999998010717031e-10
+ 7.8631238987468148e-05 2.3999998026497155e-10
+ 7.8643446018718146e-05 2.3999998018940695e-10
+ 7.8655653049968145e-05 2.399999801489314e-10
+ 7.8667860081218144e-05 2.3999998016252337e-10
+ 7.8680067112468142e-05 2.3999998017736873e-10
+ 7.8692274143718141e-05 2.3999998008841631e-10
+ 7.870448117496814e-05 2.399999801406156e-10
+ 7.8716688206218138e-05 2.3999998027111368e-10
+ 7.8728895237468137e-05 2.399999803096209e-10
+ 7.8741102268718136e-05 2.399999801745041e-10
+ 7.8753309299968148e-05 2.3999998014351678e-10
+ 7.8765516331218147e-05 2.399999802735929e-10
+ 7.8777723362468145e-05 2.3999998026179471e-10
+ 7.8789930393718144e-05 2.3999998016976751e-10
+ 7.8802137424968143e-05 2.3999998022820648e-10
+ 7.8814344456218141e-05 2.3999998018386391e-10
+ 7.882655148746814e-05 2.3999998024457121e-10
+ 7.8838758518718139e-05 2.399999802712344e-10
+ 7.8850965549968137e-05 2.3999998016906244e-10
+ 7.8863172581218149e-05 2.399999802251944e-10
+ 7.8875379612468148e-05 2.3999998029674961e-10
+ 7.8887586643718147e-05 2.3999998024490881e-10
+ 7.8899793674968145e-05 2.3999998022841694e-10
+ 7.8912000706218144e-05 2.3999998027402318e-10
+ 7.8924207737468143e-05 2.3999998031284179e-10
+ 7.8936414768718141e-05 2.3999998024592236e-10
+ 7.894862179996814e-05 2.3999998028900653e-10
+ 7.8960828831218152e-05 2.3999998029018118e-10
+ 7.8973035862468151e-05 2.3999998020407995e-10
+ 7.898524289371815e-05 2.3999998030027903e-10
+ 7.8997449924968148e-05 2.3999998034659856e-10
+ 7.9009656956218147e-05 2.3999998035710371e-10
+ 7.9021863987468145e-05 2.3999998035781327e-10
+ 7.9034071018718144e-05 2.3999998028429372e-10
+ 7.9046278049968143e-05 2.3999998026462584e-10
+ 7.9058485081218155e-05 2.3999998034401652e-10
+ 7.9070692112468154e-05 2.3999998040748526e-10
+ 7.9082899143718152e-05 2.399999802904164e-10
+ 7.9095106174968151e-05 2.3999998026488739e-10
+ 7.910731320621815e-05 2.399999803948264e-10
+ 7.9119520237468148e-05 2.399999803901337e-10
+ 7.9131727268718147e-05 2.3999998030809217e-10
+ 7.9143934299968146e-05 2.3999998036169063e-10
+ 7.9156141331218158e-05 2.3999998033495331e-10
+ 7.9168348362468156e-05 2.3999998039429674e-10
+ 7.9180555393718155e-05 2.3999998043834603e-10
+ 7.9192762424968154e-05 2.3999998042747548e-10
+ 7.9204969456218152e-05 2.3999998033813589e-10
+ 7.9217176487468151e-05 2.3999998042749197e-10
+ 7.922938351871815e-05 2.3999998045576412e-10
+ 7.9241590549968148e-05 2.3999998040668088e-10
+ 7.9253797581218161e-05 2.3999998041015307e-10
+ 7.9266004612468159e-05 2.3999998038280188e-10
+ 7.9278211643718158e-05 2.399999804963409e-10
+ 7.9290418674968157e-05 2.3999998050724164e-10
+ 7.9302625706218155e-05 2.3999998043757132e-10
+ 7.9314832737468154e-05 2.3999998042873677e-10
+ 7.9327039768718153e-05 2.3999998048062938e-10
+ 7.9339246799968151e-05 2.3999998046244087e-10
+ 7.9351453831218163e-05 2.3999998047367506e-10
+ 7.9363660862468162e-05 2.3999998045481209e-10
+ 7.9375867893718161e-05 2.3999998043752122e-10
+ 7.9388074924968159e-05 2.3999998042446345e-10
+ 7.9400281956218158e-05 2.3999998041722252e-10
+ 7.9412488987468157e-05 2.3999998041674074e-10
+ 7.9424696018718155e-05 2.3999998042357827e-10
+ 7.9436903049968154e-05 2.3999998043806778e-10
+ 7.9449110081218166e-05 2.3999998047660411e-10
+ 7.9461317112468165e-05 2.3999998051655456e-10
+ 7.9473524143718163e-05 2.3999998052591767e-10
+ 7.9485731174968162e-05 2.3999998048427911e-10
+ 7.9497938206218161e-05 2.3999998054712477e-10
+ 7.9510145237468159e-05 2.3999998057013456e-10
+ 7.9522352268718158e-05 2.3999998051176627e-10
+ 7.9534559299968157e-05 2.3999998057450993e-10
+ 7.9546766331218169e-05 2.3999998053652084e-10
+ 7.9558973362468168e-05 2.3999998056705243e-10
+ 7.9571180393718166e-05 2.399999805326457e-10
+ 7.9583387424968165e-05 2.399999805718764e-10
+ 7.9595594456218164e-05 2.3999998054921403e-10
+ 7.9607801487468162e-05 2.3999998061819825e-10
+ 7.9620008518718161e-05 2.399999805688973e-10
+ 7.963221554996816e-05 2.3999998054792621e-10
+ 7.9644422581218172e-05 2.39999980627754e-10
+ 7.965662961246817e-05 2.3999998059474422e-10
+ 7.9668836643718169e-05 2.399999805933057e-10
+ 7.9681043674968168e-05 2.3999998057922352e-10
+ 7.9693250706218166e-05 2.3999998056088616e-10
+ 7.9705457737468165e-05 2.3999998058786213e-10
+ 7.9717664768718164e-05 2.399999806005213e-10
+ 7.9729871799968162e-05 2.3999998060792622e-10
+ 7.9742078831218175e-05 2.3999998061547279e-10
+ 7.9754285862468173e-05 2.3999998062637359e-10
+ 7.9766492893718172e-05 2.3999998064254068e-10
+ 7.9778699924968171e-05 2.399999806651119e-10
+ 7.9790906956218169e-05 2.3999998065019003e-10
+ 7.9803113987468168e-05 2.3999998066078063e-10
+ 7.9815321018718167e-05 2.399999807158811e-10
+ 7.9827528049968165e-05 2.3999998065933043e-10
+ 7.9839735081218177e-05 2.3999998069949765e-10
+ 7.9851942112468176e-05 2.3999998071137632e-10
+ 7.9864149143718175e-05 2.3999998066492584e-10
+ 7.9876356174968173e-05 2.3999998067631891e-10
+ 7.9888563206218172e-05 2.3999998068067386e-10
+ 7.9900770237468171e-05 2.3999998072884115e-10
+ 7.9912977268718169e-05 2.3999998071703879e-10
+ 7.9925184299968168e-05 2.399999807620995e-10
+ 7.993739133121818e-05 2.3999998071038665e-10
+ 7.9949598362468179e-05 2.3999998068359319e-10
+ 7.9961805393718177e-05 2.3999998073934671e-10
+ 7.9974012424968176e-05 2.3999998074833904e-10
+ 7.9986219456218175e-05 2.3999998072288318e-10
+ 7.9998426487468173e-05 2.3999998078919143e-10
+ 8.0010633518718172e-05 2.3999998076965073e-10
+ 8.0022840549968171e-05 2.399999807468099e-10
+ 8.0035047581218183e-05 2.3999998076982682e-10
+ 8.0047254612468182e-05 2.3999998077882701e-10
+ 8.005946164371818e-05 2.3999998078272732e-10
+ 8.0071668674968179e-05 2.3999998077698307e-10
+ 8.0083875706218178e-05 2.3999998078844893e-10
+ 8.0096082737468176e-05 2.3999998080355428e-10
+ 8.0108289768718175e-05 2.3999998082407074e-10
+ 8.0120496799968174e-05 2.3999998085105249e-10
+ 8.0132703831218186e-05 2.3999998076975625e-10
+ 8.0144910862468184e-05 2.399999808033618e-10
+ 8.0157117893718183e-05 2.3999998080328762e-10
+ 8.0169324924968182e-05 2.3999998084082399e-10
+ 8.018153195621818e-05 2.3999998077877215e-10
+ 8.0193738987468179e-05 2.3999998083679345e-10
+ 8.0205946018718178e-05 2.3999998087406507e-10
+ 8.0218153049968176e-05 2.3999998083776306e-10
+ 8.0230360081218189e-05 2.3999998086990843e-10
+ 8.0242567112468187e-05 2.3999998083702247e-10
+ 8.0254774143718186e-05 2.399999808776692e-10
+ 8.0266981174968185e-05 2.3999998085631119e-10
+ 8.0279188206218183e-05 2.3999998083949021e-10
+ 8.0291395237468182e-05 2.3999929577393646e-10
+ 8.030360226871818e-05 2.3999721430085655e-10
+ 8.0315809299968179e-05 2.3999541801853927e-10
+ 8.0328016331218191e-05 2.3999352441667849e-10
+ 8.034022336246819e-05 2.3998998231508299e-10
+ 8.0352430393718189e-05 2.3998269751518182e-10
+ 8.0364637424968187e-05 2.3996731785187146e-10
+ 8.0370740940593187e-05 2.3994983464395233e-10
+ 8.0376844456218186e-05 2.3990674100743305e-10
+ 8.0379896214030692e-05 2.3985615585153402e-10
+ 8.0382947971843185e-05 2.3973456609508262e-10
+ 8.0384473850749432e-05 2.3959023649420816e-10
+ 8.0385999729655692e-05 2.3924487360909957e-10
+ 8.0386991106889185e-05 2.3866252493064795e-10
+ 8.0387269733896244e-05 2.3836567845599657e-10
+ 8.0387548360903304e-05 2.3795958755937176e-10
+ 8.0388098835627972e-05 2.3707317678626589e-10
+ 8.0390875273912438e-05 2.3289947932096134e-10
+ 8.0403082305162437e-05 2.1857108082062022e-10
+ 8.0415289336412436e-05 2.0744394567167327e-10
+ 8.0427496367662448e-05 1.9657101424192844e-10
+ 8.0439703398912447e-05 1.8444183633608339e-10
+ 8.0451910430162445e-05 1.7048236032410772e-10
+ 8.0464117461412444e-05 1.5473832156939622e-10
+ 8.0476324492662443e-05 1.376643966131987e-10
+ 8.0488531523912441e-05 1.1997405552563603e-10
+ 8.050073855516244e-05 1.0252468847149855e-10
+ 8.0512945586412452e-05 8.622433036431135e-11
+ 8.0525152617662451e-05 7.1953269034585456e-11
+ 8.0537359648912449e-05 6.0497851486217764e-11
+ 8.0549566680162448e-05 5.2496010132610782e-11
+ 8.0561773711412447e-05 4.8395088933560857e-11
+ 8.0573980742662445e-05 4.8422873289603413e-11
+ 8.0586187773912444e-05 5.2572582289997926e-11
+ 8.0598394805162443e-05 6.0602144636946106e-11
+ 8.0610601836412441e-05 7.2047475992215135e-11
+ 8.0622808867662454e-05 8.6248800170538565e-11
+ 8.0635015898912452e-05 1.0238838404643464e-10
+ 8.0647222930162451e-05 1.19537446121802e-10
+ 8.0659429961412449e-05 1.367094991032434e-10
+ 8.0671636992662448e-05 1.5291703382970249e-10
+ 8.0683844023912447e-05 1.6722827017382802e-10
+ 8.0686895781724953e-05 1.7041028620342427e-10
+ 8.0687048369615572e-05 1.7056469761267313e-10
+ 8.0687429839342134e-05 1.7094872387604414e-10
+ 8.0687467986314789e-05 1.7098696858623529e-10
+ 8.0687475615709328e-05 1.7099461407315297e-10
+ 8.0687490874498393e-05 1.7100990159048815e-10
+ 8.0687496978014008e-05 1.7101601530675094e-10
+ 8.068749941942027e-05 1.7101846058671687e-10
+ 8.0687499604455796e-05 1.7101864591102341e-10
+ 8.0687499974526849e-05 1.710190165576025e-10
+ 8.0687500714668955e-05 2.9362295535076986e-10
+ 8.068750145481106e-05 6.7955376462053112e-10
+ 8.0687508856232157e-05 1.9019685483973129e-08
+ 8.068751625765324e-05 6.3680162617685321e-08
+ 8.0687523659074336e-05 1.3464578979540883e-07
+ 8.0687531060495419e-05 2.3189729697639808e-07
+ 8.0687538461916516e-05 3.5541134357275011e-07
+ 8.0687547512355693e-05 5.4209487018455778e-07
+ 8.068755656279487e-05 7.6794744751962639e-07
+ 8.068756561323406e-05 1.032901665904789e-06
+ 8.0687574663673237e-05 1.3368810846168448e-06
+ 8.0687583714112414e-05 1.6798002590529673e-06
+ 8.0687595044533512e-05 2.1638522289015684e-06
+ 8.0687606374954611e-05 2.7085809274094572e-06
+ 8.0687617705375709e-05 3.3137595140903088e-06
+ 8.0687629035796807e-05 3.9791394372703589e-06
+ 8.0687643214653369e-05 4.8961848891924115e-06
+ 8.0687657393509917e-05 5.9065041934527361e-06
+ 8.0687671572366479e-05 7.0094688242501652e-06
+ 8.0687689032396943e-05 8.4939484121898285e-06
+ 8.0687706492427408e-05 1.011650368403691e-05
+ 8.0687723952457873e-05 1.187564441966631e-05
+ 8.0687746268477836e-05 1.4320324258348367e-05
+ 8.0687768584497812e-05 1.6981891243476683e-05
+ 8.0687790900517775e-05 1.9856448881756975e-05
+ 8.0687819090217251e-05 2.3785542948120637e-05
+ 8.0687847279916714e-05 2.8038794641957824e-05
+ 8.068787546961619e-05 3.2606525910010655e-05
+ 8.0687903659315652e-05 3.7478440563006991e-05
+ 8.0687931849015128e-05 4.2643660624918842e-05
+ 8.0687960038714591e-05 4.809076449946518e-05
+ 8.0687988228414067e-05 5.3807826764352856e-05
+ 8.0688019414106482e-05 6.0432058501488789e-05
+ 8.0688050599798884e-05 6.7354141141263776e-05
+ 8.06880817854913e-05 7.4556149339010216e-05
+ 8.0688112971183715e-05 8.2019674226669682e-05
+ 8.0688150418414348e-05 9.1300740447793598e-05
+ 8.0688187865644967e-05 0.00010089852928503813
+ 8.06882253128756e-05 0.00011077933330704341
+ 8.068827084419581e-05 0.00012312530862772575
+ 8.0688316375516033e-05 0.00013577798574481139
+ 8.0688361906836243e-05 0.00014867616552750304
+ 8.0688407438156453e-05 0.00016175929991125412
+ 8.0688441084028118e-05 0.00017151113091571656
+ 8.0688474729899784e-05 0.00018130797963939794
+ 8.0688508375771449e-05 0.00019112690048319055
+ 8.0688542021643115e-05 0.000200945563836072
+ 8.068857566751478e-05 0.0002107423308290232
+ 8.0688609313386446e-05 0.00022049632214156449
+ 8.0688642959258111e-05 0.00023018748061678874
+ 8.0688676605129777e-05 0.00023979662749408118
+ 8.0688710251001442e-05 0.0002493055121224335
+ 8.0688736870668159e-05 0.00025674620625396695
+ 8.0688763490334862e-05 0.00026410519322842072
+ 8.0688790110001579e-05 0.00027137476557784006
+ 8.0688816729668282e-05 0.00027854762813939171
+ 8.0688843349334998e-05 0.00028561690431054267
+ 8.0688869969001702e-05 0.0002925761407342706
+ 8.0688896588668418e-05 0.0002994193104460534
+ 8.0688923208335121e-05 0.00030614081452042582
+ 8.0688949828001838e-05 0.00031273548226053464
+ 8.0688976447668555e-05 0.00031919856997935221
+ 8.0689003067335258e-05 0.00032552575842600295
+ 8.0689029687001975e-05 0.00033171314891500655
+ 8.0689056306668678e-05 0.00033775725822013397
+ 8.0689082926335394e-05 0.00034365501229800138
+ 8.0689109546002097e-05 0.00034940373890948994
+ 8.0689136165668814e-05 0.00035500115920957621
+ 8.0689162785335531e-05 0.00036044537837818884
+ 8.0689189405002234e-05 0.00036573487536628151
+ 8.0689216024668951e-05 0.00037086849183281574
+ 8.0689239404935234e-05 0.00037524816041470616
+ 8.0689262785201517e-05 0.00037950661982143294
+ 8.0689286165467814e-05 0.00038364373347733212
+ 8.0689309545734097e-05 0.00038765955240256639
+ 8.0689332926000393e-05 0.00039155430797307712
+ 8.0689356306266676e-05 0.00039532840450424615
+ 8.068937968653296e-05 0.00039898241168751826
+ 8.0689403066799256e-05 0.00040251705690861332
+ 8.0689426447065539e-05 0.00040593321747524688
+ 8.0689449827331823e-05 0.0004092319127814815
+ 8.0689473207598119e-05 0.00041241429643495774
+ 8.0689496587864402e-05 0.00041548164837231091
+ 8.0689519968130699e-05 0.00041843536698707185
+ 8.0689543348396982e-05 0.00042127696129328835
+ 8.0689566728663265e-05 0.00042400804314699181
+ 8.0689590108929562e-05 0.00042663031954648096
+ 8.0689613489195845e-05 0.00042914558503120656
+ 8.0689636869462128e-05 0.00043155571419782471
+ 8.0689660249728425e-05 0.00043386265435075173
+ 8.0689683629994708e-05 0.0004360684183033
+ 8.0689707010261005e-05 0.00043817507734421687
+ 8.0689735591237525e-05 0.00044061881915944171
+ 8.0689764172214046e-05 0.00044292160557832261
+ 8.0689792753190566e-05 0.00044508748731897325
+ 8.06898213341671e-05 0.0004471205811035718
+ 8.0689849915143621e-05 0.00044902505354874717
+ 8.0689886199806219e-05 0.00045126415767136695
+ 8.0689925453373385e-05 0.00045347065125915753
+ 8.0689946977215271e-05 0.00045458914938144757
+ 8.06899736967147e-05 0.00045589098737442259
+ 8.0690000416214143e-05 0.00045710004038524538
+ 8.0690027135713573e-05 0.00045821970861944291
+ 8.0690053855213015e-05 0.00045925335947318648
+ 8.0690080574712445e-05 0.00046020432082601948
+ 8.0690107294211888e-05 0.00046107587487371744
+ 8.0690134013711317e-05 0.00046187125249194449
+ 8.069016073321076e-05 0.00046259362811953432
+ 8.0690187452710189e-05 0.00046324611514856153
+ 8.0690214172209632e-05 0.00046383176180687778
+ 8.0690240891709061e-05 0.00046435354751746608
+ 8.0690262548859621e-05 0.00046473161709406521
+ 8.0690284206010168e-05 0.00046507115570231151
+ 8.0690305863160715e-05 0.00046537364255429416
+ 8.0690327520311275e-05 0.00046564052306956875
+ 8.0690349177461822e-05 0.00046587320827894959
+ 8.0690370834612382e-05 0.00046607307433484731
+ 8.0690392491762928e-05 0.00046624146212347479
+ 8.0690414148913475e-05 0.00046637967697419719
+ 8.0690435806064035e-05 0.00046648898846127722
+ 8.0690457463214582e-05 0.00046657063029325929
+ 8.0690479120365142e-05 0.0004666258002852115
+ 8.069049676539961e-05 0.00046665198683365781
+ 8.0690514410434078e-05 0.00046666198405394353
+ 8.0690532055468559e-05 0.00046665638716889121
+ 8.0690549700503027e-05 0.00046663577581361698
+ 8.0690567345537508e-05 0.00046660071413966874
+ 8.0690584990571976e-05 0.00046655175093608377
+ 8.0690602635606458e-05 0.00046648941976632619
+ 8.0690620280640926e-05 0.00046641423912008399
+ 8.0690637925675393e-05 0.00046632671257892689
+ 8.0690655570709875e-05 0.00046622732899484812
+ 8.0690673215744343e-05 0.00046611656268073646
+ 8.0690690860778824e-05 0.00046599487361184948
+ 8.0690708505813292e-05 0.00046586270763738396
+ 8.0690726150847773e-05 0.00046572049670126538
+ 8.0690743795882241e-05 0.00046556865907130521
+ 8.0690761440916709e-05 0.00046540759957590188
+ 8.069077908595119e-05 0.00046523770984748908
+ 8.0690796730985658e-05 0.00046505936857196291
+ 8.069081437602014e-05 0.00046487294174334804
+ 8.0690832021054607e-05 0.00046467878292299136
+ 8.0690849666089089e-05 0.00046447723350260048
+ 8.0690867311123557e-05 0.00046426862297047311
+ 8.0690884956158038e-05 0.00046405326918029163
+ 8.0690902601192506e-05 0.00046383147862188659
+ 8.0690920246226974e-05 0.0004636035466933999
+ 8.0690937891261455e-05 0.00046336975797430831
+ 8.0690955536295923e-05 0.00046313038649879376
+ 8.0690973181330404e-05 0.00046288569602897633
+ 8.0690990826364872e-05 0.00046263594032755121
+ 8.0691008471399354e-05 0.00046238136342939871
+ 8.0691026116433821e-05 0.00046212219991176166
+ 8.0691043761468303e-05 0.00046185867516261082
+ 8.0691061406502771e-05 0.00046159100564684353
+ 8.0691079051537238e-05 0.00046131939916998468
+ 8.069109669657172e-05 0.00046104405513908457
+ 8.0691114341606188e-05 0.00046076516482052872
+ 8.0691131986640669e-05 0.00046048291159450004
+ 8.0691149631675137e-05 0.00046019747120585279
+ 8.0691167276709618e-05 0.00045990901201118061
+ 8.0691184921744086e-05 0.00045961769522188066
+ 8.0691202566778554e-05 0.00045932367514303494
+ 8.0691220211813035e-05 0.00045902709940794936
+ 8.0691237856847503e-05 0.00045872810920820898
+ 8.0691255501881985e-05 0.00045842683951912496
+ 8.0691273146916452e-05 0.00045812341932046545
+ 8.0691290791950934e-05 0.00045781797181237863
+ 8.0691308436985402e-05 0.00045751061462643097
+ 8.0691326082019869e-05 0.00045720146003169808
+ 8.0691343727054351e-05 0.00045689061513585962
+ 8.0691361372088819e-05 0.00045657818208126165
+ 8.06913790171233e-05 0.00045626425823592343
+ 8.0691396662157768e-05 0.0004559489363794755
+ 8.0691414307192249e-05 0.0004556323048840281
+ 8.0691431952226717e-05 0.00045531444788997848
+ 8.0691449597261199e-05 0.00045499544547677518
+ 8.0691467242295666e-05 0.00045467537382866608
+ 8.0691484887330134e-05 0.00045435430539546583
+ 8.0691502532364616e-05 0.00045403230904838535
+ 8.0691520177399083e-05 0.00045370945023097327
+ 8.0691537822433565e-05 0.00045338579110522598
+ 8.0691555467468033e-05 0.00045306139069292836
+ 8.0691573112502514e-05 0.00045273630501229328
+ 8.0691590757536982e-05 0.00045241058720997258
+ 8.0691608402571463e-05 0.00045208428768851668
+ 8.0691626047605931e-05 0.00045175745422936376
+ 8.0691643692640399e-05 0.00045143013211144381
+ 8.069166133767488e-05 0.00045110236422548483
+ 8.0691682620107579e-05 0.00045070649383213837
+ 8.0691702745281689e-05 0.00045033166770387813
+ 8.0691722870455785e-05 0.00044995642757493547
+ 8.0691742995629896e-05 0.00044958082330929242
+ 8.0691763120803992e-05 0.00044920490166811688
+ 8.0691783245978089e-05 0.00044882870648050557
+ 8.0691803371152199e-05 0.00044845227880637947
+ 8.0691823496326296e-05 0.00044807565709178331
+ 8.0691843621500406e-05 0.00044769887731683952
+ 8.0691863746674503e-05 0.00044732197313660687
+ 8.0691888110746135e-05 0.00044686556133260454
+ 8.0691912474817754e-05 0.00044640906499999366
+ 8.0691936838889387e-05 0.00044595253182312878
+ 8.069196120296102e-05 0.00044549600565976083
+ 8.0691985567032639e-05 0.00044503952681690417
+ 8.0692009931104271e-05 0.00044458313230938829
+ 8.0692034295175904e-05 0.00044412685610195336
+ 8.0692058659247523e-05 0.00044367072933572632
+ 8.0692083023319155e-05 0.00044321478053989036
+ 8.0692107387390775e-05 0.00044275903582933563
+ 8.0692136719683581e-05 0.00044221066197735565
+ 8.0692166051976374e-05 0.00044166265618977781
+ 8.0692195384269167e-05 0.00044111505229614979
+ 8.0692224716561961e-05 0.000440567880571222
+ 8.0692254048854754e-05 0.0004400211680723513
+ 8.0692283381147547e-05 0.0004394749389480193
+ 8.069231271344034e-05 0.0004389292147195882
+ 8.0692342045733133e-05 0.00043838401453830063
+ 8.0692377848029197e-05 0.00043771929099924211
+ 8.0692412335454632e-05 0.00043707976746529866
+ 8.0692446822880066e-05 0.00043644103787377733
+ 8.0692481310305501e-05 0.00043580312030283216
+ 8.0692515797730935e-05 0.00043516603032572377
+ 8.069255782832122e-05 0.00043439073279079223
+ 8.0692599858911491e-05 0.00043361670459320404
+ 8.0692641889501776e-05 0.00043284396248195208
+ 8.0692683920092047e-05 0.00043207252012209858
+ 8.0692725950682332e-05 0.00043130238856505936
+ 8.0692777518503431e-05 0.00043035930871672526
+ 8.0692828186666482e-05 0.00042943462880424378
+ 8.0692878854829548e-05 0.00042851188736760037
+ 8.0692929522992599e-05 0.00042759109050169295
+ 8.0692993215143464e-05 0.00042643637215815307
+ 8.0693056907294328e-05 0.0004252847370223043
+ 8.0693120599445193e-05 0.00042413618616643506
+ 8.0693198945610726e-05 0.00042272760989246018
+ 8.0693278657649698e-05 0.00042129925771114857
+ 8.0693358369688669e-05 0.00041987571829712041
+ 8.0693461292370765e-05 0.00041804477075287836
+ 8.069356950890982e-05 0.00041612824858809757
+ 8.0693701914804445e-05 0.00041379527174881443
+ 8.0693847065030187e-05 0.00041125276249577136
+ 8.0694034315235695e-05 0.00040799587225246868
+ 8.0694255865010437e-05 0.00040417569543334638
+ 8.0694554034092513e-05 0.00039909077578923559
+ 8.0694998769870896e-05 0.00039162496079868337
+ 8.0695805003989005e-05 0.00037844492463713218
+ 8.0696711764368325e-05 0.00036415075183872955
+ 8.0697737475686452e-05 0.00034863113834200367
+ 8.0698801143402343e-05 0.00033323544260725887
+ 8.0699944764949549e-05 0.00031744009309453978
+ 8.0702231646278915e-05 0.00028806442739914481
+ 8.0704182681216662e-05 0.00026516169925578173
+ 8.070629122851725e-05 0.00024245284579639417
+ 8.0708581467436172e-05 0.00021998507757767748
+ 8.071092666685003e-05 0.00019913410083615226
+ 8.0713271866263888e-05 0.00018025945489984468
+ 8.0715590537179638e-05 0.00016335772611693962
+ 8.0718474569484291e-05 0.00014452917890563918
+ 8.0721358601788931e-05 0.00012787080313841811
+ 8.0724242634093584e-05 0.00011313246567173927
+ 8.0727126666398238e-05 0.00010009286360866482
+ 8.0730010698702877e-05 8.8556201336288662e-05
+ 8.0732894731007531e-05 7.8349250567829904e-05
+ 8.0735778763312184e-05 6.9318749243295542e-05
+ 8.0739342797663601e-05 5.9583601550415324e-05
+ 8.0742906832015018e-05 5.12156620124964e-05
+ 8.0746470866366435e-05 4.4022919356413453e-05
+ 8.0750034900717852e-05 3.7840328450154061e-05
+ 8.0753598935069283e-05 3.2526023165760874e-05
+ 8.0757899961127362e-05 2.7096692323683933e-05
+ 8.0762200987185455e-05 2.2573641128908005e-05
+ 8.0766502013243549e-05 1.8805590756409222e-05
+ 8.0770803039301628e-05 1.5666514280396347e-05
+ 8.0775104065359721e-05 1.3051421554109079e-05
+ 8.0780502505986985e-05 1.0377818664489998e-05
+ 8.0785900946614262e-05 8.251909089995107e-06
+ 8.0791299387241526e-05 6.5614966739560858e-06
+ 8.079669782786879e-05 5.2173688876777125e-06
+ 8.0803468247657477e-05 3.9138135354349389e-06
+ 8.0810238667446165e-05 2.9359531577328348e-06
+ 8.0817009087234853e-05 2.2024124497970242e-06
+ 8.0825385304343958e-05 1.5432541258101081e-06
+ 8.0833761521453078e-05 1.081378721967762e-06
+ 8.0842137738562183e-05 7.5774041132707628e-07
+ 8.0853043385488663e-05 4.7689837631713853e-07
+ 8.0863949032415142e-05 3.0015113649486665e-07
+ 8.0876156063665141e-05 1.7876217937191045e-07
+ 8.0888363094915139e-05 1.0647330757921957e-07
+ 8.0900570126165138e-05 6.3424252544034479e-08
+ 8.0912777157415137e-05 3.7787934734000867e-08
+ 8.0924984188665135e-05 2.2521155841269887e-08
+ 8.0937191219915134e-05 1.3429588576020001e-08
+ 8.0949398251165146e-05 8.015449872567151e-09
+ 8.0961605282415145e-05 4.7912734917149069e-09
+ 8.0973812313665143e-05 2.871251600636248e-09
+ 8.0986019344915142e-05 1.7278727196949598e-09
+ 8.0998226376165141e-05 1.0469960699243559e-09
+ 8.1010433407415139e-05 6.4154623608527275e-10
+ 8.1022640438665138e-05 4.0011708092908531e-10
+ 8.1034847469915137e-05 2.563646256420896e-10
+ 8.1047054501165135e-05 1.7078006330613652e-10
+ 8.1059261532415148e-05 1.1983532309874618e-10
+ 8.1071468563665146e-05 8.9519095817165878e-11
+ 8.1083675594915145e-05 7.14874426319846e-11
+ 8.1095882626165143e-05 6.0771426293748156e-11
+ 8.1108089657415142e-05 5.4411972164600532e-11
+ 8.1120296688665141e-05 5.0646908151112081e-11
+ 8.1132503719915139e-05 4.8426835103990855e-11
+ 8.1144710751165152e-05 4.7126820532761082e-11
+ 8.115691778241515e-05 4.6374708016315066e-11
+ 8.1169124813665149e-05 4.594887297816922e-11
+ 8.1181331844915148e-05 4.5717334758833713e-11
+ 8.1193538876165146e-05 4.5601496954841019e-11
+ 8.1205745907415145e-05 4.5554554261028926e-11
+ 8.1217952938665144e-05 4.5548633436145208e-11
+ 8.1230159969915142e-05 4.5567135561437956e-11
+ 8.1242367001165141e-05 4.5600175741221697e-11
+ 8.125000000000001e-05 4.5624752229059989e-11
+ 8.1262207031250008e-05 4.5669966819297461e-11
+ 8.1274414062500007e-05 4.5718898557805248e-11
+ 8.1286621093750006e-05 4.5770037749483043e-11
+ 8.1298828125000004e-05 4.5822485350610839e-11
+ 8.1311035156250003e-05 4.5875705969269391e-11
+ 8.1323242187500015e-05 4.5929380773488921e-11
+ 8.1335449218750014e-05 4.5983319895906806e-11
+ 8.1347656250000013e-05 4.6037410269464089e-11
+ 8.1359863281250011e-05 4.6091584562801975e-11
+ 8.137207031250001e-05 4.6145802680837535e-11
+ 8.1384277343750009e-05 4.6200040748086769e-11
+ 8.1396484375000007e-05 4.6254284548072891e-11
+ 8.1408691406250006e-05 4.6308525616398256e-11
+ 8.1420898437500005e-05 4.6362758914111761e-11
+ 8.1433105468750003e-05 4.641698144216514e-11
+ 8.1445312500000015e-05 4.6471191416301583e-11
+ 8.1457519531250014e-05 4.6525387775689795e-11
+ 8.1469726562500013e-05 4.6579569890308451e-11
+ 8.1481933593750011e-05 4.663373738668933e-11
+ 8.149414062500001e-05 4.6687890044144897e-11
+ 8.1506347656250009e-05 4.6742027732970226e-11
+ 8.1518554687500007e-05 4.6796150377641402e-11
+ 8.1530761718750006e-05 4.6850257934899579e-11
+ 8.1542968750000005e-05 4.690435038069982e-11
+ 8.1555175781250003e-05 4.695842770243876e-11
+ 8.1567382812500016e-05 4.7012489894326265e-11
+ 8.1579589843750014e-05 4.7066536954629075e-11
+ 8.1591796875000013e-05 4.7120568884029375e-11
+ 8.1604003906250011e-05 4.7174585684647293e-11
+ 8.161621093750001e-05 4.7228587359458799e-11
+ 8.1628417968750009e-05 4.728257391194907e-11
+ 8.1640625000000007e-05 4.7336545345906017e-11
+ 8.1652832031250006e-05 4.7390501665297362e-11
+ 8.1665039062500005e-05 4.7444442874197415e-11
+ 8.1677246093750003e-05 4.7498368976743532e-11
+ 8.1689453125000016e-05 4.7552279977110043e-11
+ 8.1701660156250014e-05 4.7606175879492929e-11
+ 8.1713867187500013e-05 4.76600566881005e-11
+ 8.1726074218750012e-05 4.771392240714795e-11
+ 8.173828125000001e-05 4.7767773040854128e-11
+ 8.1750488281250009e-05 4.7821608593439534e-11
+ 8.1762695312500008e-05 4.7875429069125182e-11
+ 8.1774902343750006e-05 4.7929234472131972e-11
+ 8.1787109375000005e-05 4.7983024806680162e-11
+ 8.1799316406250004e-05 4.8036800076989225e-11
+ 8.1811523437500016e-05 4.8090560287277661e-11
+ 8.1823730468750014e-05 4.81443054417629e-11
+ 8.1835937500000013e-05 4.8198035544661283e-11
+ 8.1848144531250012e-05 4.8251750600188019e-11
+ 8.186035156250001e-05 4.8305450612557161e-11
+ 8.1872558593750009e-05 4.835913558598157e-11
+ 8.1884765625000008e-05 4.8412805524672993e-11
+ 8.1896972656250006e-05 4.846646043284194e-11
+ 8.1909179687500005e-05 4.8520100314697792e-11
+ 8.1921386718750004e-05 4.8573725174448732e-11
+ 8.1933593750000016e-05 4.8627335016301782e-11
+ 8.1945800781250015e-05 4.8680929844462761e-11
+ 8.1958007812500013e-05 4.8734509663136332e-11
+ 8.1970214843750012e-05 4.8788074476525962e-11
+ 8.198242187500001e-05 4.8841624288833967e-11
+ 8.1994628906250009e-05 4.8895159104261467e-11
+ 8.2006835937500008e-05 4.894867892700839e-11
+ 8.2019042968750006e-05 4.9002183761273549e-11
+ 8.2031250000000005e-05 4.905567361125451e-11
+ 8.2043457031250004e-05 4.9109148481147716e-11
+ 8.2055664062500016e-05 4.9162608375148381e-11
+ 8.2067871093750015e-05 4.9216053297450589e-11
+ 8.2080078125000013e-05 4.9269483252247235e-11
+ 8.2092285156250012e-05 4.932289824373005e-11
+ 8.2104492187500011e-05 4.9376298276089576e-11
+ 8.2116699218750009e-05 4.9429683353515166e-11
+ 8.2128906250000008e-05 4.9483053480195042e-11
+ 8.2141113281250007e-05 4.9536408660316226e-11
+ 8.2153320312500005e-05 4.9589748898064572e-11
+ 8.2165527343750004e-05 4.9643074197624777e-11
+ 8.2177734375000016e-05 4.9696384563180337e-11
+ 8.2189941406250015e-05 4.9749679998913594e-11
+ 8.2202148437500013e-05 4.980296050900572e-11
+ 8.2214355468750012e-05 4.9856226097636712e-11
+ 8.2226562500000011e-05 4.99094767689854e-11
+ 8.2238769531250009e-05 4.9962712527229435e-11
+ 8.2250976562500008e-05 5.0015933376545304e-11
+ 8.2263183593750007e-05 5.0069139321108297e-11
+ 8.2275390625000005e-05 5.0122330365092602e-11
+ 8.2287597656250004e-05 5.0175506512671175e-11
+ 8.2299804687500016e-05 5.0228667768015851e-11
+ 8.2312011718750015e-05 5.0281814135297241e-11
+ 8.2324218750000013e-05 5.0334945618684835e-11
+ 8.2336425781250012e-05 5.0388062222346936e-11
+ 8.2348632812500011e-05 5.0441163950450669e-11
+ 8.2360839843750009e-05 5.0494250807162017e-11
+ 8.2373046875000008e-05 5.0547322796645784e-11
+ 8.2385253906250007e-05 5.060037992306559e-11
+ 8.2397460937500005e-05 5.0653422190583924e-11
+ 8.2409667968750004e-05 5.0706449603362099e-11
+ 8.2421875000000003e-05 5.0759462165560252e-11
+ 8.2434082031250015e-05 5.0812459881337356e-11
+ 8.2446289062500014e-05 5.086544275485121e-11
+ 8.2458496093750012e-05 5.0918410790258479e-11
+ 8.2470703125000011e-05 5.0971363991714641e-11
+ 8.248291015625001e-05 5.1024302363374004e-11
+ 8.2495117187500008e-05 5.1077225909389738e-11
+ 8.2507324218750007e-05 5.1130134633913832e-11
+ 8.2519531250000006e-05 5.1183028541097097e-11
+ 8.2531738281250004e-05 5.123590763508922e-11
+ 8.2543945312500003e-05 5.1288771920038706e-11
+ 8.2556152343750015e-05 5.1341621400092889e-11
+ 8.2568359375000014e-05 5.1394456079397949e-11
+ 8.2580566406250012e-05 5.1447275962098919e-11
+ 8.2592773437500011e-05 5.1500081052339658e-11
+ 8.260498046875001e-05 5.1552871354262853e-11
+ 8.2617187500000008e-05 5.1605646872010057e-11
+ 8.2629394531250007e-05 5.1658407609721638e-11
+ 8.2641601562500006e-05 5.171115357153682e-11
+ 8.2653808593750004e-05 5.1763884761593666e-11
+ 8.2666015625000003e-05 5.1816601184029079e-11
+ 8.2678222656250002e-05 5.1869302842978788e-11
+ 8.2690429687500014e-05 5.1921989742577379e-11
+ 8.2702636718750012e-05 5.1974661886958285e-11
+ 8.2714843750000011e-05 5.2027319280253771e-11
+ 8.272705078125001e-05 5.2079961926594946e-11
+ 8.2739257812500008e-05 5.2132589830111786e-11
+ 8.2751464843750007e-05 5.2185202994933079e-11
+ 8.2763671875000006e-05 5.2237801425186463e-11
+ 8.2775878906250004e-05 5.2290385124998426e-11
+ 8.2788085937500003e-05 5.2342954098494298e-11
+ 8.2800292968750002e-05 5.2395508349798247e-11
+ 8.2812500000000014e-05 5.2448047883033309e-11
+ 8.2824707031250013e-05 5.2500572702321331e-11
+ 8.2836914062500011e-05 5.2553082811783024e-11
+ 8.284912109375001e-05 5.260557821553798e-11
+ 8.2861328125000009e-05 5.265805891770455e-11
+ 8.2873535156250007e-05 5.2710524922400013e-11
+ 8.2885742187500006e-05 5.2762976233740464e-11
+ 8.2897949218750005e-05 5.281541285584085e-11
+ 8.2910156250000003e-05 5.2867834792814952e-11
+ 8.2922363281250002e-05 5.2920242048775429e-11
+ 8.29345703125e-05 5.297263462783375e-11
+ 8.2946777343750013e-05 5.3025012534100265e-11
+ 8.2958984375000011e-05 5.3077375771684144e-11
+ 8.297119140625001e-05 5.3129724344693429e-11
+ 8.2983398437500009e-05 5.3182058257235008e-11
+ 8.2995605468750007e-05 5.3234377513414598e-11
+ 8.3007812500000006e-05 5.3286682117336819e-11
+ 8.3020019531250005e-05 5.3338972073105086e-11
+ 8.3032226562500003e-05 5.339124738482168e-11
+ 8.3044433593750002e-05 5.3443508056587737e-11
+ 8.3056640625000001e-05 5.349575409250326e-11
+ 8.3068847656249999e-05 5.3547985496667078e-11
+ 8.3081054687500011e-05 5.3600202273176877e-11
+ 8.309326171875001e-05 5.3652404426129203e-11
+ 8.3105468750000009e-05 5.3704591959619454e-11
+ 8.3117675781250007e-05 5.3756764877741888e-11
+ 8.3129882812500006e-05 5.3808923184589598e-11
+ 8.3142089843750005e-05 5.3861066884254534e-11
+ 8.3154296875000003e-05 5.3913195980827531e-11
+ 8.3166503906250002e-05 5.3965310478398236e-11
+ 8.3178710937500001e-05 5.4017410381055188e-11
+ 8.3190917968749999e-05 5.4069495692885746e-11
+ 8.3203124999999998e-05 5.4121566417976143e-11
+ 8.321533203125001e-05 5.4173622560411455e-11
+ 8.3227539062500009e-05 5.4225664124275648e-11
+ 8.3239746093750008e-05 5.4277691113651499e-11
+ 8.3251953125000006e-05 5.4329703532620677e-11
+ 8.3264160156250005e-05 5.4381701385263697e-11
+ 8.3276367187500003e-05 5.4433684675659917e-11
+ 8.3288574218750002e-05 5.4485653407887576e-11
+ 8.3300781250000001e-05 5.4537607586023745e-11
+ 8.3312988281249999e-05 5.4589547214144361e-11
+ 8.3325195312499998e-05 5.4641472296324253e-11
+ 8.333740234375001e-05 5.4693382836637059e-11
+ 8.3349609375000009e-05 5.4745278839155299e-11
+ 8.3361816406250008e-05 5.4797160307950356e-11
+ 8.3374023437500006e-05 5.4849027247092475e-11
+ 8.3386230468750005e-05 5.4900879660650734e-11
+ 8.3398437500000004e-05 5.4952717552693121e-11
+ 8.3410644531250002e-05 5.5004540927286431e-11
+ 8.3422851562500001e-05 5.5055228596414379e-11
+ 8.343505859375e-05 5.510627065877697e-11
+ 8.3447265624999998e-05 5.5158092921228189e-11
+ 8.3459472656249997e-05 5.5210849104087091e-11
+ 8.3471679687500009e-05 5.5264521350196526e-11
+ 8.3483886718750008e-05 5.5318219478297029e-11
+ 8.3489990234375007e-05 5.5343709041866146e-11
+ 8.3496093750000006e-05 5.5365175813779936e-11
+ 8.3499145507812499e-05 5.537183500008943e-11
+ 8.3502197265625006e-05 5.5371668509114686e-11
+ 8.3505249023437499e-05 5.5354771851498252e-11
+ 8.350660679077409e-05 5.5334751403020664e-11
+ 8.350699821666087e-05 5.5326313558461538e-11
+ 8.350738964254765e-05 5.5316205768572161e-11
+ 8.3508368207264579e-05 5.5280832763072969e-11
+ 8.3509409502908189e-05 5.5216998316807767e-11
+ 8.3509970598735338e-05 5.5162661637241072e-11
+ 8.3510339629298377e-05 5.5114439869388932e-11
+ 8.3511110323815845e-05 5.4960015216721681e-11
+ 8.3511741481233855e-05 5.4732817211499076e-11
+ 8.3512113084009018e-05 5.4516300482441227e-11
+ 8.3512434193795795e-05 5.42419953316085e-11
+ 8.3512647097925424e-05 5.400886072195258e-11
+ 8.3512860002055039e-05 5.3774257755821461e-11
+ 8.351498904335126e-05 5.1549852354822979e-11
+ 8.3527196074601259e-05 4.2855387214314058e-11
+ 8.3539403105851258e-05 4.053247294954365e-11
+ 8.3551610137101256e-05 4.3931039996784842e-11
+ 8.3563817168351255e-05 5.2388572167819672e-11
+ 8.3576024199601254e-05 6.5140225940715896e-11
+ 8.3588231230851252e-05 8.1286621114128428e-11
+ 8.3600438262101251e-05 9.9800201152591339e-11
+ 8.361264529335125e-05 1.1955731974057662e-10
+ 8.3624852324601248e-05 1.3938677731239894e-10
+ 8.3637059355851247e-05 1.581275910662053e-10
+ 8.3649266387101259e-05 1.7469004130247602e-10
+ 8.3661473418351258e-05 1.881149150311095e-10
+ 8.3673680449601257e-05 1.9762660690176225e-10
+ 8.3685887480851255e-05 2.026764694324815e-10
+ 8.3698094512101254e-05 2.0297359093770258e-10
+ 8.3710301543351253e-05 1.9850103705845601e-10
+ 8.3722508574601251e-05 1.8951650785639057e-10
+ 8.373471560585125e-05 1.7653730627935789e-10
+ 8.3746922637101249e-05 1.6031044421422816e-10
+ 8.3759129668351247e-05 1.4176958358946107e-10
+ 8.3771336699601246e-05 1.2198127662112241e-10
+ 8.3783543730851258e-05 1.0208359001036545e-10
+ 8.3795750762101257e-05 8.3220638681385549e-11
+ 8.3807957793351255e-05 6.6476791169901555e-11
+ 8.3811009551163748e-05 6.2738216402259133e-11
+ 8.3811314726945e-05 6.2375524734021021e-11
+ 8.3812077666398123e-05 6.1477937832984702e-11
+ 8.3812459136124685e-05 6.1034090082773124e-11
+ 8.3812482977982603e-05 6.1006459924724939e-11
+ 8.3812487746354186e-05 6.1000935454857881e-11
+ 8.381249728309734e-05 6.0989888077255491e-11
+ 8.3812498046036802e-05 6.0989004377034889e-11
+ 8.3812499571915699e-05 6.0987237016591268e-11
+ 8.3812499693986021e-05 6.0987095630059761e-11
+ 8.381249993812664e-05 6.0986812858020706e-11
+ 8.3812499957657891e-05 6.0986790236316644e-11
+ 8.3812499996720394e-05 6.098674499293473e-11
+ 8.3812500074845387e-05 6.2330481534674083e-11
+ 8.3812500152970394e-05 6.6608198187672893e-11
+ 8.3812500934220391e-05 2.7075208822833839e-10
+ 8.3812508051845985e-05 1.5641542586395462e-08
+ 8.3812515169471579e-05 5.5354276368357439e-08
+ 8.3812522287097173e-05 1.1939590331347595e-07
+ 8.3812529404722768e-05 2.0774988808958391e-07
+ 8.3812536522348376e-05 3.2039621340029153e-07
+ 8.381254363997397e-05 4.5731138406416947e-07
+ 8.3812550757599564e-05 6.1846843192454422e-07
+ 8.3812557875225158e-05 8.0383692158836119e-07
+ 8.3812564992850753e-05 1.0133829569922963e-06
+ 8.3812572110476347e-05 1.2470691887940203e-06
+ 8.3812579228101955e-05 1.5048548225862434e-06
+ 8.3812587807568573e-05 1.8475543476526228e-06
+ 8.3812596387035219e-05 2.2251205386231599e-06
+ 8.3812604966501837e-05 2.637462112110794e-06
+ 8.3812613545968483e-05 3.0844806091734263e-06
+ 8.3812622125435101e-05 3.5660704276185103e-06
+ 8.3812630704901747e-05 4.0821188567621002e-06
+ 8.3812639284368365e-05 4.6325061146258863e-06
+ 8.3812647863835011e-05 5.2171053875545835e-06
+ 8.3812658180770265e-05 5.965211217502911e-06
+ 8.3812668497705518e-05 6.7623492313414161e-06
+ 8.3812678814640772e-05 7.6082590651614992e-06
+ 8.3812689131576026e-05 8.5026660760363497e-06
+ 8.3812699448511279e-05 9.4452814742207388e-06
+ 8.3812709765446533e-05 1.0435802462230257e-05
+ 8.3812720082381787e-05 1.147391238070454e-05
+ 8.3812730399317041e-05 1.25592808609545e-05
+ 8.3812742902012263e-05 1.393744004677843e-05
+ 8.3812755404707485e-05 1.538385928477854e-05
+ 8.3812767907402708e-05 1.6897871760843825e-05
+ 8.381278041009793e-05 1.8478782715895571e-05
+ 8.3812792912793139e-05 2.0125869935940648e-05
+ 8.3812805415488362e-05 2.1838384260846487e-05
+ 8.3812817918183584e-05 2.3615550111329756e-05
+ 8.3812830420878807e-05 2.5456566033633845e-05
+ 8.3812845592253881e-05 2.7775100207116592e-05
+ 8.381286076362897e-05 3.0184906039223483e-05
+ 8.3812875935004044e-05 3.2684405463249104e-05
+ 8.3812891106379119e-05 3.5271969973378807e-05
+ 8.3812906277754207e-05 3.7945922288216153e-05
+ 8.3812921449129282e-05 4.0704538058428326e-05
+ 8.3812936620504357e-05 4.3546047616054653e-05
+ 8.3812954860519568e-05 4.7069469432613542e-05
+ 8.3812973100534779e-05 5.0706855826657106e-05
+ 8.381299134054999e-05 5.4454893918205257e-05
+ 8.3813009580565188e-05 5.8310193146384224e-05
+ 8.3813027820580399e-05 6.2269290123695639e-05
+ 8.381304606059561e-05 6.6328653564053143e-05
+ 8.3813068199865858e-05 7.1385338233594827e-05
+ 8.3813090339136107e-05 7.6577901326810804e-05
+ 8.3813112478406355e-05 8.189969012601315e-05
+ 8.3813134617676603e-05 8.7343953274172687e-05
+ 8.3813161293011328e-05 9.4056657818521804e-05
+ 8.3813187873095816e-05 0.00010090035482762358
+ 8.3813214453180303e-05 0.00010788664307091889
+ 8.3813248688484348e-05 0.00011707548567577072
+ 8.3813282923788393e-05 0.00012645461865043843
+ 8.3813315356127054e-05 0.00013549167951766453
+ 8.3813347788465716e-05 0.00014465398332574899
+ 8.3813380220804377e-05 0.00015391958689944246
+ 8.3813412653143052e-05 0.00016326679416820027
+ 8.3813445085481714e-05 0.00017267423453976973
+ 8.3813477517820375e-05 0.00018212093762926101
+ 8.3813509950159037e-05 0.00019158640400330904
+ 8.3813542382497698e-05 0.00020105067163597072
+ 8.381356958499815e-05 0.00020897371829601134
+ 8.3813596787498616e-05 0.00021687121736840308
+ 8.3813623989999067e-05 0.0002247324443841368
+ 8.3813651192499519e-05 0.00023254704172942061
+ 8.3813678394999971e-05 0.00024030503688061725
+ 8.3813705597500423e-05 0.00024799685880477063
+ 8.3813732800000875e-05 0.00025561335251051022
+ 8.3813760002501327e-05 0.00026314579174345146
+ 8.3813787205001778e-05 0.00027058588982929906
+ 8.381381440750223e-05 0.00027792580867665878
+ 8.3813841610002696e-05 0.0002851581659600263
+ 8.3813868812503147e-05 0.00029227604051150784
+ 8.3813896015003599e-05 0.00029927297595749906
+ 8.3813923217504051e-05 0.00030614298264376868
+ 8.3813950420004503e-05 0.00031288053789913813
+ 8.3813977622504955e-05 0.00031948058469418605
+ 8.3814004825005407e-05 0.00032593852875712024
+ 8.3814032027505872e-05 0.00033225023421413059
+ 8.3814059230006324e-05 0.00033841201782615327
+ 8.3814086432506776e-05 0.0003444206418985982
+ 8.3814115300883513e-05 0.00035062659892727544
+ 8.3814144169260237e-05 0.0003566540934654631
+ 8.3814173037636975e-05 0.00036250083298786399
+ 8.3814201906013712e-05 0.00036816503744223664
+ 8.381423077439045e-05 0.00037364542226806104
+ 8.3814259642767187e-05 0.00037894118026981165
+ 8.3814288511143911e-05 0.00038405196247931109
+ 8.3814317379520649e-05 0.000388977858140999
+ 8.3814346247897386e-05 0.00039371937395252178
+ 8.3814381135166688e-05 0.0003992047348763101
+ 8.3814416022435991e-05 0.00040442447430172904
+ 8.3814449985506059e-05 0.00040925368585940502
+ 8.3814483948576126e-05 0.00041383750344981278
+ 8.3814517911646181e-05 0.00041817993390062743
+ 8.3814551874716249e-05 0.00042228549548244641
+ 8.3814585837786317e-05 0.00042615916749456922
+ 8.3814627381082829e-05 0.0004305900119691504
+ 8.3814668924379342e-05 0.00043469258490726371
+ 8.3814710467675855e-05 0.0004384781612780042
+ 8.3814752010972368e-05 0.00044195857402361564
+ 8.381480232252311e-05 0.00044578261210212054
+ 8.3814853125173649e-05 0.00044923093231022854
+ 8.3814903927824174e-05 0.00045228765276156626
+ 8.3814971607266262e-05 0.00045579239535176001
+ 8.3815039286708336e-05 0.00045870005395461338
+ 8.381509191939657e-05 0.00046058369469111949
+ 8.3815144552084817e-05 0.00046216451732223918
+ 8.3815197184773063e-05 0.00046346681282214352
+ 8.381524981746131e-05 0.00046451393123718372
+ 8.3815297809929112e-05 0.00046526519657479943
+ 8.3815345802396913e-05 0.00046583893527304737
+ 8.3815393794864715e-05 0.00046625041073407677
+ 8.3815441787332516e-05 0.00046651403875466578
+ 8.3815489779800318e-05 0.0004666433740508164
+ 8.3815537261554875e-05 0.00046665162291553914
+ 8.381558474330942e-05 0.000466552308242554
+ 8.3815632225063964e-05 0.00046635608374731292
+ 8.3815679706818522e-05 0.00046607281339991539
+ 8.3815727188573066e-05 0.00046571159614456351
+ 8.3815774670327611e-05 0.00046528079492301239
+ 8.3815824358583372e-05 0.00046476378468933915
+ 8.3815874046839134e-05 0.00046418694952370777
+ 8.3815923735094881e-05 0.00046355752837163748
+ 8.3815973423350643e-05 0.00046288205221083837
+ 8.3816023111606404e-05 0.00046216639229460844
+ 8.3816072799862152e-05 0.00046141580830294233
+ 8.3816127951386084e-05 0.00046054748419045071
+ 8.3816183102910016e-05 0.00045964758393211987
+ 8.3816238254433935e-05 0.00045872107390199996
+ 8.3816293405957867e-05 0.00045777228079549998
+ 8.3816348557481785e-05 0.00045680495887963081
+ 8.3816411640520551e-05 0.000455679953428722
+ 8.3816474723559303e-05 0.00045453907391423655
+ 8.3816537806598068e-05 0.0004533857886546739
+ 8.381660088963682e-05 0.00045222299034028662
+ 8.3816674140146442e-05 0.00045086399130210022
+ 8.3816747390656049e-05 0.00044949844535668453
+ 8.3816820641165657e-05 0.00044812878579885432
+ 8.3816905619421588e-05 0.00044653719761490697
+ 8.3816990597677534e-05 0.0004449449586312652
+ 8.3817093836844789e-05 0.00044301214871122791
+ 8.3817198171769427e-05 0.00044106269601017851
+ 8.3817302506694052e-05 0.00043911870626636078
+ 8.3817426664469177e-05 0.00043681393387383496
+ 8.3817550822244289e-05 0.00043451951813961668
+ 8.381770580080654e-05 0.00043167106196547318
+ 8.3817884937131793e-05 0.00042840086834201771
+ 8.3818098556602403e-05 0.00042453293757745131
+ 8.3818364485722965e-05 0.00041976628303681877
+ 8.3818717982712214e-05 0.00041351261779238365
+ 8.3819242097564155e-05 0.00040441158298440465
+ 8.3820136340120489e-05 0.00038934346113524376
+ 8.3822132807185047e-05 0.00035769765454050228
+ 8.3823988816858025e-05 0.00033058981538904275
+ 8.3826421668443089e-05 0.00029814348467284587
+ 8.3828854520028154e-05 0.00026888165874455468
+ 8.3831287371613218e-05 0.00024249178888257299
+ 8.3833720223198282e-05 0.00021869200206866874
+ 8.3836153074783346e-05 0.00019722808975099272
+ 8.3838585926368411e-05 0.00017787079297825666
+ 8.3841018777953475e-05 0.00016041335425741158
+ 8.3843451629538539e-05 0.0001446693086575522
+ 8.3845767705239787e-05 0.00013111903917235234
+ 8.3848819440406725e-05 0.00011518312547724692
+ 8.3851871175573663e-05 0.00010118403045864018
+ 8.3854922910740602e-05 8.8886357108097517e-05
+ 8.385797464590754e-05 7.8083318131395906e-05
+ 8.3861026381074478e-05 6.8593258842393536e-05
+ 8.3864078116241417e-05 6.025660181923537e-05
+ 8.3867773618773604e-05 5.1505809187250614e-05
+ 8.3871134288610922e-05 4.4656271026532631e-05
+ 8.3874494958448227e-05 3.8717628008379948e-05
+ 8.387862073169029e-05 3.2495702272495222e-05
+ 8.388274650493234e-05 2.7273646663031209e-05
+ 8.3886872278174403e-05 2.2890780980831938e-05
+ 8.3890998051416467e-05 1.9212246512347876e-05
+ 8.389512382465853e-05 1.6124856494297113e-05
+ 8.3900251138437106e-05 1.2970141364146993e-05
+ 8.3905378452215682e-05 1.0432633172092827e-05
+ 8.3910505765994272e-05 8.3915781182774641e-06
+ 8.3915633079772848e-05 6.7498471833962207e-06
+ 8.3921995979825155e-05 5.1518189724579756e-06
+ 8.3928358879877476e-05 3.9321378049054371e-06
+ 8.3934721779929783e-05 3.0012267671564931e-06
+ 8.3942497256254514e-05 2.15737185496337e-06
+ 8.3950272732579258e-05 1.5508026051292012e-06
+ 8.3958048208904003e-05 1.1147960586695601e-06
+ 8.3967983441936072e-05 7.3118840550782522e-07
+ 8.3977918674968155e-05 4.7961075194826108e-07
+ 8.3990125706218154e-05 2.8571159964289929e-07
+ 8.4002332737468153e-05 1.7024209705967684e-07
+ 8.4014539768718151e-05 1.0147848625806179e-07
+ 8.402674679996815e-05 6.0528851952355526e-08
+ 8.4038953831218149e-05 3.6142806128821739e-08
+ 8.4051160862468147e-05 2.1620593980565466e-08
+ 8.4063367893718146e-05 1.2972424953734794e-08
+ 8.4075574924968145e-05 7.8223266739669589e-09
+ 8.4087781956218157e-05 4.7553755500354248e-09
+ 8.4099988987468155e-05 2.9289656540459339e-09
+ 8.4112196018718154e-05 1.8413143839828223e-09
+ 8.4124403049968153e-05 1.1936037658401295e-09
+ 8.4136610081218151e-05 8.078836241498485e-10
+ 8.414881711246815e-05 5.7818218790680653e-10
+ 8.4161024143718149e-05 4.4139192644487092e-10
+ 8.4173231174968147e-05 3.5993152647751398e-10
+ 8.4185438206218146e-05 3.1142080027758294e-10
+ 8.4197645237468145e-05 2.8253202431124535e-10
+ 8.4209852268718157e-05 2.653283707170538e-10
+ 8.4222059299968156e-05 2.5508336753526945e-10
+ 8.4234266331218154e-05 2.4898233649178344e-10
+ 8.4246473362468153e-05 2.4534909287155193e-10
+ 8.4258680393718151e-05 2.4318544696123555e-10
+ 8.427088742496815e-05 2.4189696683490067e-10
+ 8.4283094456218149e-05 2.411296605642883e-10
+ 8.4295301487468147e-05 2.406727199550333e-10
+ 8.4307508518718146e-05 2.4040060549918595e-10
+ 8.4319715549968145e-05 2.4023855751768804e-10
+ 8.4331922581218143e-05 2.4014205601586099e-10
+ 8.4344129612468156e-05 2.4008458822552009e-10
+ 8.4356336643718154e-05 2.4005036536744095e-10
+ 8.4368543674968153e-05 2.4002998505548136e-10
+ 8.4380750706218152e-05 2.4001784836154639e-10
+ 8.439295773746815e-05 2.4001062082534474e-10
+ 8.4405164768718149e-05 2.4000631674323626e-10
+ 8.4417371799968148e-05 2.4000375361391963e-10
+ 8.4429578831218146e-05 2.4000222718017004e-10
+ 8.4441785862468145e-05 2.4000131819356677e-10
+ 8.4453992893718144e-05 2.4000077702242996e-10
+ 8.4466199924968142e-05 2.4000045459933931e-10
+ 8.4478406956218154e-05 2.4000026257884156e-10
+ 8.4490613987468153e-05 2.4000014832025053e-10
+ 8.4502821018718152e-05 2.4000008023582484e-10
+ 8.451502804996815e-05 2.4000003966625581e-10
+ 8.4527235081218149e-05 2.400000155533385e-10
+ 8.4539442112468148e-05 2.4000000121814107e-10
+ 8.4551649143718146e-05 2.3999999261673205e-10
+ 8.4563856174968145e-05 2.3999998758456908e-10
+ 8.4576063206218144e-05 2.3999998453222656e-10
+ 8.4588270237468142e-05 2.3999998265390494e-10
+ 8.4600477268718141e-05 2.3999998161732485e-10
+ 8.4612684299968153e-05 2.3999998104358188e-10
+ 8.4624891331218152e-05 2.3999998057389865e-10
+ 8.463709836246815e-05 2.3999998026292464e-10
+ 8.4649305393718149e-05 2.3999998019001177e-10
+ 8.4661512424968148e-05 2.3999998019899801e-10
+ 8.4673719456218146e-05 2.3999998020597388e-10
+ 8.4685926487468145e-05 2.3999998012855701e-10
+ 8.4698133518718144e-05 2.3999998005534517e-10
+ 8.4710340549968142e-05 2.3999998008389102e-10
+ 8.4722547581218141e-05 2.3999998009224399e-10
+ 8.4734754612468153e-05 2.3999998012219294e-10
+ 8.4746961643718152e-05 2.3999998013282356e-10
+ 8.4759168674968151e-05 2.3999998009115475e-10
+ 8.4771375706218149e-05 2.3999998009706464e-10
+ 8.4783582737468148e-05 2.3999998010363494e-10
+ 8.4795789768718147e-05 2.3999998011314167e-10
+ 8.4807996799968145e-05 2.3999998013616955e-10
+ 8.4820203831218144e-05 2.3999998011363462e-10
+ 8.4832410862468142e-05 2.3999998009274014e-10
+ 8.4844617893718141e-05 2.399999801011231e-10
+ 8.485682492496814e-05 2.399999800977465e-10
+ 8.4869031956218152e-05 2.3999998010717031e-10
+ 8.4881238987468151e-05 2.3999998026497155e-10
+ 8.4893446018718149e-05 2.3999998018940695e-10
+ 8.4905653049968148e-05 2.399999801489314e-10
+ 8.4917860081218147e-05 2.3999998016252337e-10
+ 8.4930067112468145e-05 2.3999998017736873e-10
+ 8.4942274143718144e-05 2.3999998008841631e-10
+ 8.4954481174968143e-05 2.399999801406156e-10
+ 8.4966688206218141e-05 2.3999998027111368e-10
+ 8.497889523746814e-05 2.399999803096209e-10
+ 8.4991102268718152e-05 2.399999801745041e-10
+ 8.5003309299968151e-05 2.3999998014351678e-10
+ 8.5015516331218149e-05 2.399999802735929e-10
+ 8.5027723362468148e-05 2.3999998026179471e-10
+ 8.5039930393718147e-05 2.3999998016976751e-10
+ 8.5052137424968145e-05 2.3999998022820648e-10
+ 8.5064344456218144e-05 2.3999998018386391e-10
+ 8.5076551487468143e-05 2.3999998024457121e-10
+ 8.5088758518718141e-05 2.399999802712344e-10
+ 8.510096554996814e-05 2.3999998016906244e-10
+ 8.5113172581218152e-05 2.399999802251944e-10
+ 8.5125379612468151e-05 2.3999998029674961e-10
+ 8.513758664371815e-05 2.3999998024490881e-10
+ 8.5149793674968148e-05 2.3999998022841694e-10
+ 8.5162000706218147e-05 2.3999998027402318e-10
+ 8.5174207737468146e-05 2.3999998031284179e-10
+ 8.5186414768718144e-05 2.3999998024592236e-10
+ 8.5198621799968143e-05 2.3999998028900653e-10
+ 8.5210828831218155e-05 2.3999998029018118e-10
+ 8.5223035862468154e-05 2.3999998020407995e-10
+ 8.5235242893718152e-05 2.3999998030027903e-10
+ 8.5247449924968151e-05 2.3999998034659856e-10
+ 8.525965695621815e-05 2.3999998035710371e-10
+ 8.5271863987468148e-05 2.3999998035781327e-10
+ 8.5284071018718147e-05 2.3999998028429372e-10
+ 8.5296278049968146e-05 2.3999998026462584e-10
+ 8.5308485081218158e-05 2.3999998034401652e-10
+ 8.5320692112468156e-05 2.3999998040748526e-10
+ 8.5332899143718155e-05 2.399999802904164e-10
+ 8.5345106174968154e-05 2.3999998026488739e-10
+ 8.5357313206218152e-05 2.399999803948264e-10
+ 8.5369520237468151e-05 2.399999803901337e-10
+ 8.538172726871815e-05 2.3999998030809217e-10
+ 8.5393934299968148e-05 2.3999998036169063e-10
+ 8.5406141331218161e-05 2.3999998033495331e-10
+ 8.5418348362468159e-05 2.3999998039429674e-10
+ 8.5430555393718158e-05 2.3999998043834603e-10
+ 8.5442762424968157e-05 2.3999998042747548e-10
+ 8.5454969456218155e-05 2.3999998033813589e-10
+ 8.5467176487468154e-05 2.3999998042749197e-10
+ 8.5479383518718153e-05 2.3999998045576412e-10
+ 8.5491590549968151e-05 2.3999998040668088e-10
+ 8.5503797581218163e-05 2.3999998041015307e-10
+ 8.5516004612468162e-05 2.3999998038280188e-10
+ 8.5528211643718161e-05 2.399999804963409e-10
+ 8.5540418674968159e-05 2.3999998050724164e-10
+ 8.5552625706218158e-05 2.3999998043757132e-10
+ 8.5564832737468157e-05 2.3999998042873677e-10
+ 8.5577039768718155e-05 2.3999998048062938e-10
+ 8.5589246799968154e-05 2.3999998046244087e-10
+ 8.5601453831218166e-05 2.3999998047367506e-10
+ 8.5613660862468165e-05 2.3999998045481209e-10
+ 8.5625867893718164e-05 2.3999998043752122e-10
+ 8.5638074924968162e-05 2.3999998042446345e-10
+ 8.5650281956218161e-05 2.3999998041722252e-10
+ 8.5662488987468159e-05 2.3999998041674074e-10
+ 8.5674696018718158e-05 2.3999998042357827e-10
+ 8.5686903049968157e-05 2.3999998043806778e-10
+ 8.5699110081218169e-05 2.3999998047660411e-10
+ 8.5711317112468168e-05 2.3999998051655456e-10
+ 8.5723524143718166e-05 2.3999998052591767e-10
+ 8.5735731174968165e-05 2.3999998048427911e-10
+ 8.5747938206218164e-05 2.3999998054712477e-10
+ 8.5760145237468162e-05 2.3999998057013456e-10
+ 8.5772352268718161e-05 2.3999998051176627e-10
+ 8.578455929996816e-05 2.3999998057450993e-10
+ 8.5796766331218172e-05 2.3999998053652084e-10
+ 8.580897336246817e-05 2.3999998056705243e-10
+ 8.5821180393718169e-05 2.399999805326457e-10
+ 8.5833387424968168e-05 2.399999805718764e-10
+ 8.5845594456218166e-05 2.3999998054921403e-10
+ 8.5857801487468165e-05 2.3999998061819825e-10
+ 8.5870008518718164e-05 2.399999805688973e-10
+ 8.5882215549968162e-05 2.3999998054792621e-10
+ 8.5894422581218175e-05 2.39999980627754e-10
+ 8.5906629612468173e-05 2.3999998059474422e-10
+ 8.5918836643718172e-05 2.399999805933057e-10
+ 8.5931043674968171e-05 2.3999998057922352e-10
+ 8.5943250706218169e-05 2.3999998056088616e-10
+ 8.5955457737468168e-05 2.3999998058786213e-10
+ 8.5967664768718167e-05 2.399999806005213e-10
+ 8.5979871799968165e-05 2.3999998060792622e-10
+ 8.5992078831218177e-05 2.3999998061547279e-10
+ 8.6004285862468176e-05 2.3999998062637359e-10
+ 8.6016492893718175e-05 2.3999998064254068e-10
+ 8.6028699924968173e-05 2.399999806651119e-10
+ 8.6040906956218172e-05 2.3999998065019003e-10
+ 8.6053113987468171e-05 2.3999998066078063e-10
+ 8.6065321018718169e-05 2.399999807158811e-10
+ 8.6077528049968168e-05 2.3999998065933043e-10
+ 8.608973508121818e-05 2.3999998069949765e-10
+ 8.6101942112468179e-05 2.3999998071137632e-10
+ 8.6114149143718178e-05 2.3999998066492584e-10
+ 8.6126356174968176e-05 2.3999998067631891e-10
+ 8.6138563206218175e-05 2.3999998068067386e-10
+ 8.6150770237468173e-05 2.3999998072884115e-10
+ 8.6162977268718172e-05 2.3999998071703879e-10
+ 8.6175184299968171e-05 2.399999807620995e-10
+ 8.6187391331218183e-05 2.3999998071038665e-10
+ 8.6199598362468182e-05 2.3999998068359319e-10
+ 8.621180539371818e-05 2.3999998073934671e-10
+ 8.6224012424968179e-05 2.3999998074833904e-10
+ 8.6236219456218178e-05 2.3999998072288318e-10
+ 8.6248426487468176e-05 2.3999998078919143e-10
+ 8.6260633518718175e-05 2.3999998076965073e-10
+ 8.6272840549968174e-05 2.399999807468099e-10
+ 8.6285047581218186e-05 2.3999998076982682e-10
+ 8.6297254612468184e-05 2.3999998077882701e-10
+ 8.6309461643718183e-05 2.3999998078272732e-10
+ 8.6321668674968182e-05 2.3999998077698307e-10
+ 8.633387570621818e-05 2.3999998078844893e-10
+ 8.6346082737468179e-05 2.3999998080355428e-10
+ 8.6358289768718178e-05 2.3999998082407074e-10
+ 8.6370496799968176e-05 2.3999998085105249e-10
+ 8.6382703831218189e-05 2.3999998076975625e-10
+ 8.6394910862468187e-05 2.399999808033618e-10
+ 8.6407117893718186e-05 2.3999998080328762e-10
+ 8.6419324924968185e-05 2.3999998084082399e-10
+ 8.6431531956218183e-05 2.3999998077877215e-10
+ 8.6443738987468182e-05 2.3999998083679345e-10
+ 8.6455946018718181e-05 2.3999998087406507e-10
+ 8.6468153049968179e-05 2.3999998083776306e-10
+ 8.6480360081218191e-05 2.3999998086990843e-10
+ 8.649256711246819e-05 2.3999998083702247e-10
+ 8.6504774143718189e-05 2.399999808776692e-10
+ 8.6516981174968187e-05 2.3999998085631119e-10
+ 8.6529188206218186e-05 2.3999998083949021e-10
+ 8.6541395237468185e-05 2.3999929577393646e-10
+ 8.6553602268718183e-05 2.3999721430085655e-10
+ 8.6565809299968182e-05 2.3999541801853927e-10
+ 8.6578016331218194e-05 2.3999352441667849e-10
+ 8.6590223362468193e-05 2.3998998231508299e-10
+ 8.6602430393718192e-05 2.3998269751518182e-10
+ 8.661463742496819e-05 2.3996731785187146e-10
+ 8.6620740940593189e-05 2.3994983464395233e-10
+ 8.6626844456218189e-05 2.3990674100743305e-10
+ 8.6629896214030695e-05 2.3985615585153402e-10
+ 8.6632947971843188e-05 2.3973456609508262e-10
+ 8.6634473850749435e-05 2.3959023649420816e-10
+ 8.6635999729655695e-05 2.3924487360909957e-10
+ 8.6636991106889201e-05 2.3866252493064795e-10
+ 8.6637269733896247e-05 2.3836567845599657e-10
+ 8.6637548360903307e-05 2.3795958755937176e-10
+ 8.6638098835627975e-05 2.3707317678626589e-10
+ 8.6640875273912441e-05 2.3289947932096134e-10
+ 8.665308230516244e-05 2.1857108082062022e-10
+ 8.6665289336412452e-05 2.0744394567167327e-10
+ 8.6677496367662451e-05 1.9657101424192844e-10
+ 8.6689703398912449e-05 1.8444183633608339e-10
+ 8.6701910430162448e-05 1.7048236032410772e-10
+ 8.6714117461412447e-05 1.5473832156939622e-10
+ 8.6726324492662445e-05 1.376643966131987e-10
+ 8.6738531523912444e-05 1.1997405552563603e-10
+ 8.6750738555162443e-05 1.0252468847149855e-10
+ 8.6762945586412441e-05 8.622433036431135e-11
+ 8.6775152617662454e-05 7.1953269034585456e-11
+ 8.6787359648912452e-05 6.0497851486217764e-11
+ 8.6799566680162451e-05 5.2496010132610782e-11
+ 8.681177371141245e-05 4.8395088933560857e-11
+ 8.6823980742662448e-05 4.8422873289603413e-11
+ 8.6836187773912447e-05 5.2572582289997926e-11
+ 8.6848394805162445e-05 6.0602144636946106e-11
+ 8.6860601836412458e-05 7.2047475992215135e-11
+ 8.6872808867662456e-05 8.6248800170538565e-11
+ 8.6885015898912455e-05 1.0238838404643464e-10
+ 8.6897222930162454e-05 1.19537446121802e-10
+ 8.6909429961412452e-05 1.367094991032434e-10
+ 8.6921636992662451e-05 1.5291703382970249e-10
+ 8.693384402391245e-05 1.6722827017382802e-10
+ 8.6936895781724956e-05 1.7041028620342427e-10
+ 8.6937048369615575e-05 1.7056469761267313e-10
+ 8.6937429839342137e-05 1.7094872387604414e-10
+ 8.6937467986314792e-05 1.7098696858623529e-10
+ 8.6937475615709331e-05 1.7099461407315297e-10
+ 8.6937490874498395e-05 1.7100990159048815e-10
+ 8.693749697801401e-05 1.7101601530675094e-10
+ 8.6937499419420273e-05 1.7101846058671687e-10
+ 8.6937499604455799e-05 1.7101864591102341e-10
+ 8.6937499974526852e-05 1.710190165576025e-10
+ 8.6937500714668957e-05 2.9362295535076986e-10
+ 8.6937501454811063e-05 6.7955376462053112e-10
+ 8.693750885623216e-05 1.9019685483973129e-08
+ 8.6937516257653243e-05 6.3680162617685321e-08
+ 8.6937523659074339e-05 1.3464578979540883e-07
+ 8.6937531060495422e-05 2.3189729697639808e-07
+ 8.6937538461916519e-05 3.5541134357275011e-07
+ 8.6937547512355696e-05 5.4209487018455778e-07
+ 8.6937556562794872e-05 7.6794744751962639e-07
+ 8.6937565613234063e-05 1.032901665904789e-06
+ 8.693757466367324e-05 1.3368810846168448e-06
+ 8.6937583714112417e-05 1.6798002590529673e-06
+ 8.6937595044533515e-05 2.1638522289015684e-06
+ 8.6937606374954613e-05 2.7085809274094572e-06
+ 8.6937617705375712e-05 3.3137595140903088e-06
+ 8.693762903579681e-05 3.9791394372703589e-06
+ 8.6937643214653372e-05 4.8961848891924115e-06
+ 8.693765739350992e-05 5.9065041934527361e-06
+ 8.6937671572366482e-05 7.0094688242501652e-06
+ 8.6937689032396946e-05 8.4939484121898285e-06
+ 8.6937706492427411e-05 1.011650368403691e-05
+ 8.6937723952457875e-05 1.187564441966631e-05
+ 8.6937746268477838e-05 1.4320324258348367e-05
+ 8.6937768584497815e-05 1.6981891243476683e-05
+ 8.6937790900517778e-05 1.9856448881756975e-05
+ 8.6937819090217254e-05 2.3785542948120637e-05
+ 8.6937847279916716e-05 2.8038794641957824e-05
+ 8.6937875469616192e-05 3.2606525910010655e-05
+ 8.6937903659315655e-05 3.7478440563006991e-05
+ 8.6937931849015131e-05 4.2643660624918842e-05
+ 8.6937960038714607e-05 4.809076449946518e-05
+ 8.693798822841407e-05 5.3807826764352856e-05
+ 8.6938019414106485e-05 6.0432058501488789e-05
+ 8.6938050599798887e-05 6.7354141141263776e-05
+ 8.6938081785491303e-05 7.4556149339010216e-05
+ 8.6938112971183718e-05 8.2019674226669682e-05
+ 8.6938150418414351e-05 9.1300740447793598e-05
+ 8.693818786564497e-05 0.00010089852928503813
+ 8.6938225312875603e-05 0.00011077933330704341
+ 8.6938270844195812e-05 0.00012312530862772575
+ 8.6938316375516036e-05 0.00013577798574481139
+ 8.6938361906836246e-05 0.00014867616552750304
+ 8.6938407438156456e-05 0.00016175929991125412
+ 8.6938441084028121e-05 0.00017151113091571656
+ 8.6938474729899787e-05 0.00018130797963939794
+ 8.6938508375771452e-05 0.00019112690048319055
+ 8.6938542021643118e-05 0.000200945563836072
+ 8.6938575667514783e-05 0.0002107423308290232
+ 8.6938609313386449e-05 0.00022049632214156449
+ 8.6938642959258114e-05 0.00023018748061678874
+ 8.693867660512978e-05 0.00023979662749408118
+ 8.6938710251001445e-05 0.0002493055121224335
+ 8.6938736870668162e-05 0.00025674620625396695
+ 8.6938763490334865e-05 0.00026410519322842072
+ 8.6938790110001581e-05 0.00027137476557784006
+ 8.6938816729668285e-05 0.00027854762813939171
+ 8.6938843349335001e-05 0.00028561690431054267
+ 8.6938869969001704e-05 0.0002925761407342706
+ 8.6938896588668421e-05 0.0002994193104460534
+ 8.6938923208335138e-05 0.00030614081452042582
+ 8.6938949828001841e-05 0.00031273548226053464
+ 8.6938976447668558e-05 0.00031919856997935221
+ 8.6939003067335261e-05 0.00032552575842600295
+ 8.6939029687001977e-05 0.00033171314891500655
+ 8.693905630666868e-05 0.00033775725822013397
+ 8.6939082926335397e-05 0.00034365501229800138
+ 8.69391095460021e-05 0.00034940373890948994
+ 8.6939136165668817e-05 0.00035500115920957621
+ 8.6939162785335534e-05 0.00036044537837818884
+ 8.6939189405002237e-05 0.00036573487536628151
+ 8.6939216024668953e-05 0.00037086849183281574
+ 8.6939239404935237e-05 0.00037524816041470616
+ 8.693926278520152e-05 0.00037950661982143294
+ 8.6939286165467816e-05 0.00038364373347733212
+ 8.69393095457341e-05 0.00038765955240256639
+ 8.6939332926000396e-05 0.00039155430797307712
+ 8.6939356306266679e-05 0.00039532840450424615
+ 8.6939379686532962e-05 0.00039898241168751826
+ 8.6939403066799259e-05 0.00040251705690861332
+ 8.6939426447065542e-05 0.00040593321747524688
+ 8.6939449827331825e-05 0.0004092319127814815
+ 8.6939473207598122e-05 0.00041241429643495774
+ 8.6939496587864405e-05 0.00041548164837231091
+ 8.6939519968130702e-05 0.00041843536698707185
+ 8.6939543348396985e-05 0.00042127696129328835
+ 8.6939566728663268e-05 0.00042400804314699181
+ 8.6939590108929565e-05 0.00042663031954648096
+ 8.6939613489195848e-05 0.00042914558503120656
+ 8.6939636869462131e-05 0.00043155571419782471
+ 8.6939660249728428e-05 0.00043386265435075173
+ 8.6939683629994711e-05 0.0004360684183033
+ 8.6939707010261008e-05 0.00043817507734421687
+ 8.6939735591237528e-05 0.00044061881915944171
+ 8.6939764172214048e-05 0.00044292160557832261
+ 8.6939792753190569e-05 0.00044508748731897325
+ 8.6939821334167103e-05 0.0004471205811035718
+ 8.6939849915143623e-05 0.00044902505354874717
+ 8.6939886199806222e-05 0.00045126415767136695
+ 8.6939925453373388e-05 0.00045347065125915753
+ 8.6939946977215274e-05 0.00045458914938144757
+ 8.6939973696714703e-05 0.00045589098737442259
+ 8.6940000416214146e-05 0.00045710004038524538
+ 8.6940027135713575e-05 0.00045821970861944291
+ 8.6940053855213018e-05 0.00045925335947318648
+ 8.6940080574712448e-05 0.00046020432082601948
+ 8.694010729421189e-05 0.00046107587487371744
+ 8.694013401371132e-05 0.00046187125249194449
+ 8.6940160733210763e-05 0.00046259362811953432
+ 8.6940187452710192e-05 0.00046324611514856153
+ 8.6940214172209635e-05 0.00046383176180687778
+ 8.6940240891709064e-05 0.00046435354751746608
+ 8.6940262548859624e-05 0.00046473161709406521
+ 8.6940284206010171e-05 0.00046507115570231151
+ 8.6940305863160731e-05 0.00046537364255429416
+ 8.6940327520311278e-05 0.00046564052306956875
+ 8.6940349177461824e-05 0.00046587320827894959
+ 8.6940370834612385e-05 0.00046607307433484731
+ 8.6940392491762931e-05 0.00046624146212347479
+ 8.6940414148913478e-05 0.00046637967697419719
+ 8.6940435806064038e-05 0.00046648898846127722
+ 8.6940457463214585e-05 0.00046657063029325929
+ 8.6940479120365131e-05 0.0004666258002852115
+ 8.6940496765399613e-05 0.00046665198683365781
+ 8.6940514410434081e-05 0.00046666198405394353
+ 8.6940532055468562e-05 0.00046665638716889121
+ 8.694054970050303e-05 0.00046663577581361698
+ 8.6940567345537511e-05 0.00046660071413966874
+ 8.6940584990571979e-05 0.00046655175093608377
+ 8.6940602635606461e-05 0.00046648941976632619
+ 8.6940620280640928e-05 0.00046641423912008399
+ 8.6940637925675396e-05 0.00046632671257892689
+ 8.6940655570709878e-05 0.00046622732899484812
+ 8.6940673215744345e-05 0.00046611656268073646
+ 8.6940690860778827e-05 0.00046599487361184948
+ 8.6940708505813295e-05 0.00046586270763738396
+ 8.6940726150847776e-05 0.00046572049670126538
+ 8.6940743795882244e-05 0.00046556865907130521
+ 8.6940761440916725e-05 0.00046540759957590188
+ 8.6940779085951193e-05 0.00046523770984748908
+ 8.6940796730985661e-05 0.00046505936857196291
+ 8.6940814376020142e-05 0.00046487294174334804
+ 8.694083202105461e-05 0.00046467878292299136
+ 8.6940849666089092e-05 0.00046447723350260048
+ 8.6940867311123559e-05 0.00046426862297047311
+ 8.6940884956158041e-05 0.00046405326918029163
+ 8.6940902601192509e-05 0.00046383147862188659
+ 8.6940920246226977e-05 0.0004636035466933999
+ 8.6940937891261458e-05 0.00046336975797430831
+ 8.6940955536295926e-05 0.00046313038649879376
+ 8.6940973181330407e-05 0.00046288569602897633
+ 8.6940990826364875e-05 0.00046263594032755121
+ 8.6941008471399356e-05 0.00046238136342939871
+ 8.6941026116433824e-05 0.00046212219991176166
+ 8.6941043761468292e-05 0.00046185867516261082
+ 8.6941061406502773e-05 0.00046159100564684353
+ 8.6941079051537241e-05 0.00046131939916998468
+ 8.6941096696571723e-05 0.00046104405513908457
+ 8.694111434160619e-05 0.00046076516482052872
+ 8.6941131986640672e-05 0.00046048291159450004
+ 8.694114963167514e-05 0.00046019747120585279
+ 8.6941167276709621e-05 0.00045990901201118061
+ 8.6941184921744089e-05 0.00045961769522188066
+ 8.6941202566778557e-05 0.00045932367514303494
+ 8.6941220211813038e-05 0.00045902709940794936
+ 8.6941237856847506e-05 0.00045872810920820898
+ 8.6941255501881987e-05 0.00045842683951912496
+ 8.6941273146916455e-05 0.00045812341932046545
+ 8.6941290791950937e-05 0.00045781797181237863
+ 8.6941308436985404e-05 0.00045751061462643097
+ 8.6941326082019886e-05 0.00045720146003169808
+ 8.6941343727054354e-05 0.00045689061513585962
+ 8.6941361372088822e-05 0.00045657818208126165
+ 8.6941379017123303e-05 0.00045626425823592343
+ 8.6941396662157771e-05 0.0004559489363794755
+ 8.6941414307192252e-05 0.0004556323048840281
+ 8.694143195222672e-05 0.00045531444788997848
+ 8.6941449597261201e-05 0.00045499544547677518
+ 8.6941467242295669e-05 0.00045467537382866608
+ 8.6941484887330137e-05 0.00045435430539546583
+ 8.6941502532364618e-05 0.00045403230904838535
+ 8.6941520177399086e-05 0.00045370945023097327
+ 8.6941537822433568e-05 0.00045338579110522598
+ 8.6941555467468036e-05 0.00045306139069292836
+ 8.6941573112502517e-05 0.00045273630501229328
+ 8.6941590757536985e-05 0.00045241058720997258
+ 8.6941608402571453e-05 0.00045208428768851668
+ 8.6941626047605934e-05 0.00045175745422936376
+ 8.6941643692640402e-05 0.00045143013211144381
+ 8.6941661337674883e-05 0.00045110236422548483
+ 8.6941682620107581e-05 0.00045070649383213837
+ 8.6941702745281692e-05 0.00045033166770387813
+ 8.6941722870455788e-05 0.00044995642757493547
+ 8.6941742995629899e-05 0.00044958082330929242
+ 8.6941763120803995e-05 0.00044920490166811688
+ 8.6941783245978092e-05 0.00044882870648050557
+ 8.6941803371152202e-05 0.00044845227880637947
+ 8.6941823496326299e-05 0.00044807565709178331
+ 8.6941843621500409e-05 0.00044769887731683952
+ 8.6941863746674506e-05 0.00044732197313660687
+ 8.6941888110746138e-05 0.00044686556133260454
+ 8.6941912474817757e-05 0.00044640906499999366
+ 8.694193683888939e-05 0.00044595253182312878
+ 8.6941961202961022e-05 0.00044549600565976083
+ 8.6941985567032641e-05 0.00044503952681690417
+ 8.6942009931104274e-05 0.00044458313230938829
+ 8.6942034295175907e-05 0.00044412685610195336
+ 8.6942058659247526e-05 0.00044367072933572632
+ 8.6942083023319158e-05 0.00044321478053989036
+ 8.6942107387390777e-05 0.00044275903582933563
+ 8.6942136719683584e-05 0.00044221066197735565
+ 8.6942166051976377e-05 0.00044166265618977781
+ 8.694219538426917e-05 0.00044111505229614979
+ 8.6942224716561963e-05 0.000440567880571222
+ 8.6942254048854757e-05 0.0004400211680723513
+ 8.694228338114755e-05 0.0004394749389480193
+ 8.6942312713440343e-05 0.0004389292147195882
+ 8.6942342045733136e-05 0.00043838401453830063
+ 8.69423778480292e-05 0.00043771929099924211
+ 8.6942412335454635e-05 0.00043707976746529866
+ 8.6942446822880069e-05 0.00043644103787377733
+ 8.6942481310305504e-05 0.00043580312030283216
+ 8.6942515797730938e-05 0.00043516603032572377
+ 8.6942557828321223e-05 0.00043439073279079223
+ 8.6942599858911494e-05 0.00043361670459320404
+ 8.6942641889501779e-05 0.00043284396248195208
+ 8.694268392009205e-05 0.00043207252012209858
+ 8.6942725950682335e-05 0.00043130238856505936
+ 8.6942777518503434e-05 0.00043035930871672526
+ 8.6942828186666485e-05 0.00042943462880424378
+ 8.6942878854829551e-05 0.00042851188736760037
+ 8.6942929522992602e-05 0.00042759109050169295
+ 8.6942993215143467e-05 0.00042643637215815307
+ 8.6943056907294331e-05 0.0004252847370223043
+ 8.6943120599445196e-05 0.00042413618616643506
+ 8.6943198945610729e-05 0.00042272760989246018
+ 8.69432786576497e-05 0.00042129925771114857
+ 8.6943358369688672e-05 0.00041987571829712041
+ 8.6943461292370768e-05 0.00041804477075287836
+ 8.6943569508909823e-05 0.00041612824858809757
+ 8.6943701914804448e-05 0.00041379527174881443
+ 8.694384706503019e-05 0.00041125276249577136
+ 8.6944034315235698e-05 0.00040799587225246868
+ 8.6944255865010439e-05 0.00040417569543334638
+ 8.6944554034092516e-05 0.00039909077578923559
+ 8.6944998769870898e-05 0.00039162496079868337
+ 8.6945805003989007e-05 0.00037844492463713218
+ 8.6946711764368328e-05 0.00036415075183872955
+ 8.6947737475686455e-05 0.00034863113834200367
+ 8.6948801143402345e-05 0.00033323544260725887
+ 8.6949944764949552e-05 0.00031744009309453978
+ 8.6952231646278917e-05 0.00028806442739914481
+ 8.6954182681216665e-05 0.00026516169925578173
+ 8.6956291228517253e-05 0.00024245284579639417
+ 8.6958581467436175e-05 0.00021998507757767748
+ 8.6960926666850033e-05 0.00019913410083615226
+ 8.696327186626389e-05 0.00018025945489984468
+ 8.6965590537179641e-05 0.00016335772611693962
+ 8.6968474569484294e-05 0.00014452917890563918
+ 8.6971358601788934e-05 0.00012787080313841811
+ 8.6974242634093587e-05 0.00011313246567173927
+ 8.697712666639824e-05 0.00010009286360866482
+ 8.698001069870288e-05 8.8556201336288662e-05
+ 8.6982894731007533e-05 7.8349250567829904e-05
+ 8.6985778763312187e-05 6.9318749243295542e-05
+ 8.6989342797663604e-05 5.9583601550415324e-05
+ 8.6992906832015021e-05 5.12156620124964e-05
+ 8.6996470866366438e-05 4.4022919356413453e-05
+ 8.7000034900717869e-05 3.7840328450154061e-05
+ 8.7003598935069286e-05 3.2526023165760874e-05
+ 8.7007899961127365e-05 2.7096692323683933e-05
+ 8.7012200987185458e-05 2.2573641128908005e-05
+ 8.7016502013243551e-05 1.8805590756409222e-05
+ 8.7020803039301631e-05 1.5666514280396347e-05
+ 8.7025104065359724e-05 1.3051421554109079e-05
+ 8.7030502505986988e-05 1.0377818664489998e-05
+ 8.7035900946614252e-05 8.251909089995107e-06
+ 8.7041299387241529e-05 6.5614966739560858e-06
+ 8.7046697827868793e-05 5.2173688876777125e-06
+ 8.705346824765748e-05 3.9138135354349389e-06
+ 8.7060238667446168e-05 2.9359531577328348e-06
+ 8.7067009087234856e-05 2.2024124497970242e-06
+ 8.7075385304343961e-05 1.5432541258101081e-06
+ 8.7083761521453081e-05 1.081378721967762e-06
+ 8.7092137738562186e-05 7.5774041132707628e-07
+ 8.7103043385488666e-05 4.7689837631713853e-07
+ 8.7113949032415145e-05 3.0015113649486665e-07
+ 8.7126156063665143e-05 1.7876217937191045e-07
+ 8.7138363094915142e-05 1.0647330757921957e-07
+ 8.7150570126165141e-05 6.3424252544034479e-08
+ 8.7162777157415139e-05 3.7787934734000867e-08
+ 8.7174984188665138e-05 2.2521155841269887e-08
+ 8.7187191219915137e-05 1.3429588576020001e-08
+ 8.7199398251165135e-05 8.015449872567151e-09
+ 8.7211605282415148e-05 4.7912734917149069e-09
+ 8.7223812313665146e-05 2.871251600636248e-09
+ 8.7236019344915145e-05 1.7278727196949598e-09
+ 8.7248226376165144e-05 1.0469960699243559e-09
+ 8.7260433407415142e-05 6.4154623608527275e-10
+ 8.7272640438665141e-05 4.0011708092908531e-10
+ 8.728484746991514e-05 2.563646256420896e-10
+ 8.7297054501165152e-05 1.7078006330613652e-10
+ 8.730926153241515e-05 1.1983532309874618e-10
+ 8.7321468563665149e-05 8.9519095817165878e-11
+ 8.7333675594915148e-05 7.14874426319846e-11
+ 8.7345882626165146e-05 6.0771426293748156e-11
+ 8.7358089657415145e-05 5.4411972164600532e-11
+ 8.7370296688665144e-05 5.0646908151112081e-11
+ 8.7382503719915142e-05 4.8426835103990855e-11
+ 8.7394710751165141e-05 4.7126820532761082e-11
+ 8.7406917782415153e-05 4.6374708016315066e-11
+ 8.7419124813665152e-05 4.594887297816922e-11
+ 8.743133184491515e-05 4.5717334758833713e-11
+ 8.7443538876165149e-05 4.5601496954841019e-11
+ 8.7455745907415148e-05 4.5554554261028926e-11
+ 8.7467952938665146e-05 4.5548633436145208e-11
+ 8.7480159969915145e-05 4.5567135561437956e-11
+ 8.7492367001165157e-05 4.5600175741221697e-11
+ 8.7499999999999999e-05 4.5624752229059989e-11
+ 8.7512207031249998e-05 4.5669966819297461e-11
+ 8.7524414062499996e-05 4.5718898557805248e-11
+ 8.7536621093749995e-05 4.5770037749483043e-11
+ 8.7548828124999994e-05 4.5822485350610839e-11
+ 8.7561035156249992e-05 4.5875705969269391e-11
+ 8.7573242187500005e-05 4.5929380773488921e-11
+ 8.7585449218750003e-05 4.5983319895906806e-11
+ 8.7597656250000002e-05 4.6037410269464089e-11
+ 8.7609863281250001e-05 4.6091584562801975e-11
+ 8.7622070312499999e-05 4.6145802680837535e-11
+ 8.7634277343749998e-05 4.6200040748086769e-11
+ 8.7646484374999997e-05 4.6254284548072891e-11
+ 8.7658691406249995e-05 4.6308525616398256e-11
+ 8.7670898437499994e-05 4.6362758914111761e-11
+ 8.7683105468749992e-05 4.641698144216514e-11
+ 8.7695312500000005e-05 4.6471191416301583e-11
+ 8.7707519531250003e-05 4.6525387775689795e-11
+ 8.7719726562500002e-05 4.6579569890308451e-11
+ 8.7731933593750001e-05 4.663373738668933e-11
+ 8.7744140624999999e-05 4.6687890044144897e-11
+ 8.7756347656249998e-05 4.6742027732970226e-11
+ 8.7768554687499997e-05 4.6796150377641402e-11
+ 8.7780761718749995e-05 4.6850257934899579e-11
+ 8.7792968749999994e-05 4.690435038069982e-11
+ 8.7805175781249993e-05 4.695842770243876e-11
+ 8.7817382812500005e-05 4.7012489894326265e-11
+ 8.7829589843750003e-05 4.7066536954629075e-11
+ 8.7841796875000002e-05 4.7120568884029375e-11
+ 8.7854003906250001e-05 4.7174585684647293e-11
+ 8.7866210937499999e-05 4.7228587359458799e-11
+ 8.7878417968749998e-05 4.728257391194907e-11
+ 8.7890624999999997e-05 4.7336545345906017e-11
+ 8.7902832031249995e-05 4.7390501665297362e-11
+ 8.7915039062499994e-05 4.7444442874197415e-11
+ 8.7927246093749993e-05 4.7498368976743532e-11
+ 8.7939453125000005e-05 4.7552279977110043e-11
+ 8.7951660156250004e-05 4.7606175879492929e-11
+ 8.7963867187500002e-05 4.76600566881005e-11
+ 8.7976074218750001e-05 4.771392240714795e-11
+ 8.798828125e-05 4.7767773040854128e-11
+ 8.8000488281249998e-05 4.7821608593439534e-11
+ 8.8012695312499997e-05 4.7875429069125182e-11
+ 8.8024902343749996e-05 4.7929234472131972e-11
+ 8.8037109374999994e-05 4.7983024806680162e-11
+ 8.8049316406249993e-05 4.8036800076989225e-11
+ 8.8061523437500005e-05 4.8090560287277661e-11
+ 8.8073730468750004e-05 4.81443054417629e-11
+ 8.8085937500000002e-05 4.8198035544661283e-11
+ 8.8098144531250001e-05 4.8251750600188019e-11
+ 8.81103515625e-05 4.8305450612557161e-11
+ 8.8122558593749998e-05 4.835913558598157e-11
+ 8.8134765624999997e-05 4.8412805524672993e-11
+ 8.8146972656249996e-05 4.846646043284194e-11
+ 8.8159179687499994e-05 4.8520100314697792e-11
+ 8.8171386718749993e-05 4.8573725174448732e-11
+ 8.8183593750000005e-05 4.8627335016301782e-11
+ 8.8195800781250004e-05 4.8680929844462761e-11
+ 8.8208007812500002e-05 4.8734509663136332e-11
+ 8.8220214843750001e-05 4.8788074476525962e-11
+ 8.8232421875e-05 4.8841624288833967e-11
+ 8.8244628906249998e-05 4.8895159104261467e-11
+ 8.8256835937499997e-05 4.894867892700839e-11
+ 8.8269042968749996e-05 4.9002183761273549e-11
+ 8.8281249999999994e-05 4.905567361125451e-11
+ 8.8293457031249993e-05 4.9109148481147716e-11
+ 8.8305664062500005e-05 4.9162608375148381e-11
+ 8.8317871093750004e-05 4.9216053297450589e-11
+ 8.8330078125000003e-05 4.9269483252247235e-11
+ 8.8342285156250001e-05 4.932289824373005e-11
+ 8.83544921875e-05 4.9376298276089576e-11
+ 8.8366699218749999e-05 4.9429683353515166e-11
+ 8.8378906249999997e-05 4.9483053480195042e-11
+ 8.8391113281249996e-05 4.9536408660316226e-11
+ 8.8403320312499994e-05 4.9589748898064572e-11
+ 8.8415527343749993e-05 4.9643074197624777e-11
+ 8.8427734375000005e-05 4.9696384563180337e-11
+ 8.8439941406250004e-05 4.9749679998913594e-11
+ 8.8452148437500003e-05 4.980296050900572e-11
+ 8.8464355468750001e-05 4.9856226097636712e-11
+ 8.84765625e-05 4.99094767689854e-11
+ 8.8488769531249999e-05 4.9962712527229435e-11
+ 8.8500976562499997e-05 5.0015933376545304e-11
+ 8.8513183593749996e-05 5.0069139321108297e-11
+ 8.8525390624999995e-05 5.0122330365092602e-11
+ 8.8537597656249993e-05 5.0175506512671175e-11
+ 8.8549804687500005e-05 5.0228667768015851e-11
+ 8.8562011718750004e-05 5.0281814135297241e-11
+ 8.8574218750000003e-05 5.0334945618684835e-11
+ 8.8586425781250001e-05 5.0388062222346936e-11
+ 8.85986328125e-05 5.0441163950450669e-11
+ 8.8610839843749999e-05 5.0494250807162017e-11
+ 8.8623046874999997e-05 5.0547322796645784e-11
+ 8.8635253906249996e-05 5.060037992306559e-11
+ 8.8647460937499995e-05 5.0653422190583924e-11
+ 8.8659667968749993e-05 5.0706449603362099e-11
+ 8.8671874999999992e-05 5.0759462165560252e-11
+ 8.8684082031250004e-05 5.0812459881337356e-11
+ 8.8696289062500003e-05 5.086544275485121e-11
+ 8.8708496093750002e-05 5.0918410790258479e-11
+ 8.8720703125e-05 5.0971363991714641e-11
+ 8.8732910156249999e-05 5.1024302363374004e-11
+ 8.8745117187499998e-05 5.1077225909389738e-11
+ 8.8757324218749996e-05 5.1130134633913832e-11
+ 8.8769531249999995e-05 5.1183028541097097e-11
+ 8.8781738281249993e-05 5.123590763508922e-11
+ 8.8793945312499992e-05 5.1288771920038706e-11
+ 8.8806152343750004e-05 5.1341621400092889e-11
+ 8.8818359375000003e-05 5.1394456079397949e-11
+ 8.8830566406250002e-05 5.1447275962098919e-11
+ 8.88427734375e-05 5.1500081052339658e-11
+ 8.8854980468749999e-05 5.1552871354262853e-11
+ 8.8867187499999998e-05 5.1605646872010057e-11
+ 8.8879394531249996e-05 5.1658407609721638e-11
+ 8.8891601562499995e-05 5.171115357153682e-11
+ 8.8903808593749994e-05 5.1763884761593666e-11
+ 8.8916015624999992e-05 5.1816601184029079e-11
+ 8.8928222656249991e-05 5.1869302842978788e-11
+ 8.8940429687500003e-05 5.1921989742577379e-11
+ 8.8952636718750002e-05 5.1974661886958285e-11
+ 8.896484375e-05 5.2027319280253771e-11
+ 8.8977050781249999e-05 5.2079961926594946e-11
+ 8.8989257812499998e-05 5.2132589830111786e-11
+ 8.9001464843749996e-05 5.2185202994933079e-11
+ 8.9013671874999995e-05 5.2237801425186463e-11
+ 8.9025878906249994e-05 5.2290385124998426e-11
+ 8.9038085937499992e-05 5.2342954098494298e-11
+ 8.9050292968749991e-05 5.2395508349798247e-11
+ 8.9062500000000003e-05 5.2448047883033309e-11
+ 8.9074707031250002e-05 5.2500572702321331e-11
+ 8.9086914062500001e-05 5.2553082811783024e-11
+ 8.9099121093749999e-05 5.260557821553798e-11
+ 8.9111328124999998e-05 5.265805891770455e-11
+ 8.9123535156249996e-05 5.2710524922400013e-11
+ 8.9135742187499995e-05 5.2762976233740464e-11
+ 8.9147949218749994e-05 5.281541285584085e-11
+ 8.9160156249999992e-05 5.2867834792814952e-11
+ 8.9172363281249991e-05 5.2920242048775429e-11
+ 8.918457031249999e-05 5.297263462783375e-11
+ 8.9196777343750002e-05 5.3025012534100265e-11
+ 8.9208984375000001e-05 5.3077375771684144e-11
+ 8.9221191406249999e-05 5.3129724344693429e-11
+ 8.9233398437499998e-05 5.3182058257235008e-11
+ 8.9245605468749997e-05 5.3234377513414598e-11
+ 8.9257812499999995e-05 5.3286682117336819e-11
+ 8.9270019531249994e-05 5.3338972073105086e-11
+ 8.9282226562499993e-05 5.339124738482168e-11
+ 8.9294433593749991e-05 5.3443508056587737e-11
+ 8.930664062499999e-05 5.349575409250326e-11
+ 8.9318847656249989e-05 5.3547985496667078e-11
+ 8.9331054687500001e-05 5.3600202273176877e-11
+ 8.9343261718749999e-05 5.3652404426129203e-11
+ 8.9355468749999998e-05 5.3704591959619454e-11
+ 8.9367675781249997e-05 5.3756764877741888e-11
+ 8.9379882812499995e-05 5.3808923184589598e-11
+ 8.9392089843749994e-05 5.3861066884254534e-11
+ 8.9404296874999993e-05 5.3913195980827531e-11
+ 8.9416503906249991e-05 5.3965310478398236e-11
+ 8.942871093749999e-05 5.4017410381055188e-11
+ 8.9440917968749989e-05 5.4069495692885746e-11
+ 8.9453124999999987e-05 5.4121566417976143e-11
+ 8.946533203125e-05 5.4173622560411455e-11
+ 8.9477539062499998e-05 5.4225664124275648e-11
+ 8.9489746093749997e-05 5.4277691113651499e-11
+ 8.9501953124999995e-05 5.4329703532620677e-11
+ 8.9514160156249994e-05 5.4381701385263697e-11
+ 8.9526367187499993e-05 5.4433684675659917e-11
+ 8.9538574218749991e-05 5.4485653407887576e-11
+ 8.955078124999999e-05 5.4537607586023745e-11
+ 8.9562988281249989e-05 5.4589547214144361e-11
+ 8.9575195312499987e-05 5.4641472296324253e-11
+ 8.958740234375e-05 5.4693382836637059e-11
+ 8.9599609374999998e-05 5.4745278839155299e-11
+ 8.9611816406249997e-05 5.4797160307950356e-11
+ 8.9624023437499996e-05 5.4849027247092475e-11
+ 8.9636230468749994e-05 5.4900879660650734e-11
+ 8.9648437499999993e-05 5.4952717552693121e-11
+ 8.9660644531249992e-05 5.5004540927286431e-11
+ 8.967285156249999e-05 5.5055228596414379e-11
+ 8.9685058593749989e-05 5.510627065877697e-11
+ 8.9697265624999988e-05 5.5158092921228189e-11
+ 8.9709472656249986e-05 5.5210849104087091e-11
+ 8.9721679687499998e-05 5.5264521350196526e-11
+ 8.9733886718749997e-05 5.5318219478297029e-11
+ 8.9739990234374996e-05 5.5343709041866146e-11
+ 8.9746093749999996e-05 5.5365175813779936e-11
+ 8.9749145507812489e-05 5.537183500008943e-11
+ 8.9752197265624995e-05 5.5371668509114686e-11
+ 8.9755249023437488e-05 5.5354771851498252e-11
+ 8.975660679077408e-05 5.5334751403020664e-11
+ 8.9756998216660859e-05 5.5326313558461538e-11
+ 8.9757389642547639e-05 5.5316205768572161e-11
+ 8.9758368207264568e-05 5.5280832763072969e-11
+ 8.9759409502908178e-05 5.5216998316807767e-11
+ 8.9759970598735328e-05 5.5162661637241072e-11
+ 8.9760339629298366e-05 5.5114439869388932e-11
+ 8.9761110323815835e-05 5.4960015216721681e-11
+ 8.9761741481233844e-05 5.4732817211499076e-11
+ 8.9762113084009007e-05 5.4516300482441227e-11
+ 8.9762434193795784e-05 5.42419953316085e-11
+ 8.9762647097925413e-05 5.400886072195258e-11
+ 8.9762860002055029e-05 5.3774257755821461e-11
+ 8.976498904335125e-05 5.1549852354822979e-11
+ 8.9777196074601248e-05 4.2855387214314058e-11
+ 8.9789403105851247e-05 4.053247294954365e-11
+ 8.9801610137101246e-05 4.3931039996784842e-11
+ 8.9813817168351244e-05 5.2388572167819672e-11
+ 8.9826024199601243e-05 6.5140225940715896e-11
+ 8.9838231230851242e-05 8.1286621114128428e-11
+ 8.985043826210124e-05 9.9800201152591339e-11
+ 8.9862645293351239e-05 1.1955731974057662e-10
+ 8.9874852324601238e-05 1.3938677731239894e-10
+ 8.9887059355851236e-05 1.581275910662053e-10
+ 8.9899266387101249e-05 1.7469004130247602e-10
+ 8.9911473418351247e-05 1.881149150311095e-10
+ 8.9923680449601246e-05 1.9762660690176225e-10
+ 8.9935887480851245e-05 2.026764694324815e-10
+ 8.9948094512101243e-05 2.0297359093770258e-10
+ 8.9960301543351242e-05 1.9850103705845601e-10
+ 8.997250857460124e-05 1.8951650785639057e-10
+ 8.9984715605851239e-05 1.7653730627935789e-10
+ 8.9996922637101238e-05 1.6031044421422816e-10
+ 9.0009129668351236e-05 1.4176958358946107e-10
+ 9.0021336699601235e-05 1.2198127662112241e-10
+ 9.0033543730851247e-05 1.0208359001036545e-10
+ 9.0045750762101246e-05 8.3220638681385549e-11
+ 9.0057957793351245e-05 6.6476791169901555e-11
+ 9.0061009551163738e-05 6.2738216402259133e-11
+ 9.006131472694499e-05 6.2375524734021021e-11
+ 9.0062077666398113e-05 6.1477937832984702e-11
+ 9.0062459136124674e-05 6.1034090082773124e-11
+ 9.0062482977982592e-05 6.1006459924724939e-11
+ 9.0062487746354176e-05 6.1000935454857881e-11
+ 9.0062497283097329e-05 6.0989888077255491e-11
+ 9.0062498046036791e-05 6.0989004377034889e-11
+ 9.0062499571915688e-05 6.0987237016591268e-11
+ 9.0062499693986011e-05 6.0987095630059761e-11
+ 9.0062499938126629e-05 6.0986812858020706e-11
+ 9.006249995765788e-05 6.0986790236316644e-11
+ 9.0062499996720384e-05 6.098674499293473e-11
+ 9.0062500074845377e-05 6.2330481534674083e-11
+ 9.0062500152970383e-05 6.6608198187672893e-11
+ 9.006250093422038e-05 2.7075208822833839e-10
+ 9.0062508051845974e-05 1.5641542586395462e-08
+ 9.0062515169471569e-05 5.5354276368357439e-08
+ 9.0062522287097163e-05 1.1939590331347595e-07
+ 9.0062529404722757e-05 2.0774988808958391e-07
+ 9.0062536522348365e-05 3.2039621340029153e-07
+ 9.0062543639973959e-05 4.5731138406416947e-07
+ 9.0062550757599553e-05 6.1846843192454422e-07
+ 9.0062557875225148e-05 8.0383692158836119e-07
+ 9.0062564992850742e-05 1.0133829569922963e-06
+ 9.0062572110476336e-05 1.2470691887940203e-06
+ 9.0062579228101944e-05 1.5048548225862434e-06
+ 9.0062587807568563e-05 1.8475543476526228e-06
+ 9.0062596387035208e-05 2.2251205386231599e-06
+ 9.0062604966501827e-05 2.637462112110794e-06
+ 9.0062613545968472e-05 3.0844806091734263e-06
+ 9.0062622125435091e-05 3.5660704276185103e-06
+ 9.0062630704901736e-05 4.0821188567621002e-06
+ 9.0062639284368355e-05 4.6325061146258863e-06
+ 9.0062647863835e-05 5.2171053875545835e-06
+ 9.0062658180770254e-05 5.965211217502911e-06
+ 9.0062668497705508e-05 6.7623492313414161e-06
+ 9.0062678814640761e-05 7.6082590651614992e-06
+ 9.0062689131576015e-05 8.5026660760363497e-06
+ 9.0062699448511269e-05 9.4452814742207388e-06
+ 9.0062709765446522e-05 1.0435802462230257e-05
+ 9.0062720082381776e-05 1.147391238070454e-05
+ 9.006273039931703e-05 1.25592808609545e-05
+ 9.0062742902012252e-05 1.393744004677843e-05
+ 9.0062755404707475e-05 1.538385928477854e-05
+ 9.0062767907402697e-05 1.6897871760843825e-05
+ 9.006278041009792e-05 1.8478782715895571e-05
+ 9.0062792912793129e-05 2.0125869935940648e-05
+ 9.0062805415488351e-05 2.1838384260846487e-05
+ 9.0062817918183573e-05 2.3615550111329756e-05
+ 9.0062830420878796e-05 2.5456566033633845e-05
+ 9.0062845592253871e-05 2.7775100207116592e-05
+ 9.0062860763628959e-05 3.0184906039223483e-05
+ 9.0062875935004034e-05 3.2684405463249104e-05
+ 9.0062891106379108e-05 3.5271969973378807e-05
+ 9.0062906277754197e-05 3.7945922288216153e-05
+ 9.0062921449129271e-05 4.0704538058428326e-05
+ 9.0062936620504346e-05 4.3546047616054653e-05
+ 9.0062954860519557e-05 4.7069469432613542e-05
+ 9.0062973100534768e-05 5.0706855826657106e-05
+ 9.006299134054998e-05 5.4454893918205257e-05
+ 9.0063009580565177e-05 5.8310193146384224e-05
+ 9.0063027820580388e-05 6.2269290123695639e-05
+ 9.0063046060595599e-05 6.6328653564053143e-05
+ 9.0063068199865848e-05 7.1385338233594827e-05
+ 9.0063090339136096e-05 7.6577901326810804e-05
+ 9.0063112478406344e-05 8.189969012601315e-05
+ 9.0063134617676593e-05 8.7343953274172687e-05
+ 9.0063161293011318e-05 9.4056657818521804e-05
+ 9.0063187873095805e-05 0.00010090035482762358
+ 9.0063214453180293e-05 0.00010788664307091889
+ 9.0063248688484338e-05 0.00011707548567577072
+ 9.0063282923788382e-05 0.00012645461865043843
+ 9.0063315356127044e-05 0.00013549167951766453
+ 9.0063347788465705e-05 0.00014465398332574899
+ 9.0063380220804367e-05 0.00015391958689944246
+ 9.0063412653143042e-05 0.00016326679416820027
+ 9.0063445085481703e-05 0.00017267423453976973
+ 9.0063477517820365e-05 0.00018212093762926101
+ 9.0063509950159026e-05 0.00019158640400330904
+ 9.0063542382497688e-05 0.00020105067163597072
+ 9.0063569584998139e-05 0.00020897371829601134
+ 9.0063596787498605e-05 0.00021687121736840308
+ 9.0063623989999057e-05 0.0002247324443841368
+ 9.0063651192499509e-05 0.00023254704172942061
+ 9.006367839499996e-05 0.00024030503688061725
+ 9.0063705597500412e-05 0.00024799685880477063
+ 9.0063732800000864e-05 0.00025561335251051022
+ 9.0063760002501316e-05 0.00026314579174345146
+ 9.0063787205001768e-05 0.00027058588982929906
+ 9.006381440750222e-05 0.00027792580867665878
+ 9.0063841610002685e-05 0.0002851581659600263
+ 9.0063868812503137e-05 0.00029227604051150784
+ 9.0063896015003589e-05 0.00029927297595749906
+ 9.006392321750404e-05 0.00030614298264376868
+ 9.0063950420004492e-05 0.00031288053789913813
+ 9.0063977622504944e-05 0.00031948058469418605
+ 9.0064004825005396e-05 0.00032593852875712024
+ 9.0064032027505861e-05 0.00033225023421413059
+ 9.0064059230006313e-05 0.00033841201782615327
+ 9.0064086432506765e-05 0.0003444206418985982
+ 9.0064115300883503e-05 0.00035062659892727544
+ 9.0064144169260226e-05 0.0003566540934654631
+ 9.0064173037636964e-05 0.00036250083298786399
+ 9.0064201906013701e-05 0.00036816503744223664
+ 9.0064230774390439e-05 0.00037364542226806104
+ 9.0064259642767176e-05 0.00037894118026981165
+ 9.00642885111439e-05 0.00038405196247931109
+ 9.0064317379520638e-05 0.000388977858140999
+ 9.0064346247897375e-05 0.00039371937395252178
+ 9.0064381135166678e-05 0.0003992047348763101
+ 9.006441602243598e-05 0.00040442447430172904
+ 9.0064449985506048e-05 0.00040925368585940502
+ 9.0064483948576116e-05 0.00041383750344981278
+ 9.006451791164617e-05 0.00041817993390062743
+ 9.0064551874716238e-05 0.00042228549548244641
+ 9.0064585837786306e-05 0.00042615916749456922
+ 9.0064627381082819e-05 0.0004305900119691504
+ 9.0064668924379332e-05 0.00043469258490726371
+ 9.0064710467675844e-05 0.0004384781612780042
+ 9.0064752010972357e-05 0.00044195857402361564
+ 9.00648023225231e-05 0.00044578261210212054
+ 9.0064853125173638e-05 0.00044923093231022854
+ 9.0064903927824163e-05 0.00045228765276156626
+ 9.0064971607266251e-05 0.00045579239535176001
+ 9.0065039286708326e-05 0.00045870005395461338
+ 9.0065091919396559e-05 0.00046058369469111949
+ 9.0065144552084806e-05 0.00046216451732223918
+ 9.0065197184773053e-05 0.00046346681282214352
+ 9.0065249817461299e-05 0.00046451393123718372
+ 9.0065297809929101e-05 0.00046526519657479943
+ 9.0065345802396902e-05 0.00046583893527304737
+ 9.0065393794864704e-05 0.00046625041073407677
+ 9.0065441787332505e-05 0.00046651403875466578
+ 9.0065489779800307e-05 0.0004666433740508164
+ 9.0065537261554865e-05 0.00046665162291553914
+ 9.0065584743309409e-05 0.000466552308242554
+ 9.0065632225063953e-05 0.00046635608374731292
+ 9.0065679706818511e-05 0.00046607281339991539
+ 9.0065727188573056e-05 0.00046571159614456351
+ 9.00657746703276e-05 0.00046528079492301239
+ 9.0065824358583361e-05 0.00046476378468933915
+ 9.0065874046839123e-05 0.00046418694952370777
+ 9.0065923735094871e-05 0.00046355752837163748
+ 9.0065973423350632e-05 0.00046288205221083837
+ 9.0066023111606394e-05 0.00046216639229460844
+ 9.0066072799862141e-05 0.00046141580830294233
+ 9.0066127951386073e-05 0.00046054748419045071
+ 9.0066183102910006e-05 0.00045964758393211987
+ 9.0066238254433924e-05 0.00045872107390199996
+ 9.0066293405957856e-05 0.00045777228079549998
+ 9.0066348557481775e-05 0.00045680495887963081
+ 9.006641164052054e-05 0.000455679953428722
+ 9.0066474723559292e-05 0.00045453907391423655
+ 9.0066537806598058e-05 0.0004533857886546739
+ 9.006660088963681e-05 0.00045222299034028662
+ 9.0066674140146431e-05 0.00045086399130210022
+ 9.0066747390656039e-05 0.00044949844535668453
+ 9.0066820641165646e-05 0.00044812878579885432
+ 9.0066905619421578e-05 0.00044653719761490697
+ 9.0066990597677523e-05 0.0004449449586312652
+ 9.0067093836844779e-05 0.00044301214871122791
+ 9.0067198171769417e-05 0.00044106269601017851
+ 9.0067302506694041e-05 0.00043911870626636078
+ 9.0067426664469167e-05 0.00043681393387383496
+ 9.0067550822244279e-05 0.00043451951813961668
+ 9.0067705800806529e-05 0.00043167106196547318
+ 9.0067884937131783e-05 0.00042840086834201771
+ 9.0068098556602392e-05 0.00042453293757745131
+ 9.0068364485722954e-05 0.00041976628303681877
+ 9.0068717982712203e-05 0.00041351261779238365
+ 9.0069242097564145e-05 0.00040441158298440465
+ 9.0070136340120478e-05 0.00038934346113524376
+ 9.0072132807185036e-05 0.00035769765454050228
+ 9.0073988816858014e-05 0.00033058981538904275
+ 9.0076421668443078e-05 0.00029814348467284587
+ 9.0078854520028143e-05 0.00026888165874455468
+ 9.0081287371613207e-05 0.00024249178888257299
+ 9.0083720223198271e-05 0.00021869200206866874
+ 9.0086153074783336e-05 0.00019722808975099272
+ 9.00885859263684e-05 0.00017787079297825666
+ 9.0091018777953464e-05 0.00016041335425741158
+ 9.0093451629538529e-05 0.0001446693086575522
+ 9.0095767705239776e-05 0.00013111903917235234
+ 9.0098819440406714e-05 0.00011518312547724692
+ 9.0101871175573653e-05 0.00010118403045864018
+ 9.0104922910740591e-05 8.8886357108097517e-05
+ 9.0107974645907529e-05 7.8083318131395906e-05
+ 9.0111026381074468e-05 6.8593258842393536e-05
+ 9.0114078116241406e-05 6.025660181923537e-05
+ 9.0117773618773593e-05 5.1505809187250614e-05
+ 9.0121134288610912e-05 4.4656271026532631e-05
+ 9.0124494958448216e-05 3.8717628008379948e-05
+ 9.012862073169028e-05 3.2495702272495222e-05
+ 9.0132746504932329e-05 2.7273646663031209e-05
+ 9.0136872278174393e-05 2.2890780980831938e-05
+ 9.0140998051416456e-05 1.9212246512347876e-05
+ 9.0145123824658519e-05 1.6124856494297113e-05
+ 9.0150251138437095e-05 1.2970141364146993e-05
+ 9.0155378452215672e-05 1.0432633172092827e-05
+ 9.0160505765994261e-05 8.3915781182774641e-06
+ 9.0165633079772838e-05 6.7498471833962207e-06
+ 9.0171995979825145e-05 5.1518189724579756e-06
+ 9.0178358879877465e-05 3.9321378049054371e-06
+ 9.0184721779929772e-05 3.0012267671564931e-06
+ 9.0192497256254503e-05 2.15737185496337e-06
+ 9.0200272732579248e-05 1.5508026051292012e-06
+ 9.0208048208903992e-05 1.1147960586695601e-06
+ 9.0217983441936062e-05 7.3118840550782522e-07
+ 9.0227918674968145e-05 4.7961075194826108e-07
+ 9.0240125706218143e-05 2.8571159964289929e-07
+ 9.0252332737468142e-05 1.7024209705967684e-07
+ 9.0264539768718141e-05 1.0147848625806179e-07
+ 9.0276746799968139e-05 6.0528851952355526e-08
+ 9.0288953831218138e-05 3.6142806128821739e-08
+ 9.0301160862468137e-05 2.1620593980565466e-08
+ 9.0313367893718135e-05 1.2972424953734794e-08
+ 9.0325574924968134e-05 7.8223266739669589e-09
+ 9.0337781956218146e-05 4.7553755500354248e-09
+ 9.0349988987468145e-05 2.9289656540459339e-09
+ 9.0362196018718143e-05 1.8413143839828223e-09
+ 9.0374403049968142e-05 1.1936037658401295e-09
+ 9.0386610081218141e-05 8.078836241498485e-10
+ 9.0398817112468139e-05 5.7818218790680653e-10
+ 9.0411024143718138e-05 4.4139192644487092e-10
+ 9.0423231174968137e-05 3.5993152647751398e-10
+ 9.0435438206218135e-05 3.1142080027758294e-10
+ 9.0447645237468134e-05 2.8253202431124535e-10
+ 9.0459852268718146e-05 2.653283707170538e-10
+ 9.0472059299968145e-05 2.5508336753526945e-10
+ 9.0484266331218143e-05 2.4898233649178344e-10
+ 9.0496473362468142e-05 2.4534909287155193e-10
+ 9.0508680393718141e-05 2.4318544696123555e-10
+ 9.0520887424968139e-05 2.4189696683490067e-10
+ 9.0533094456218138e-05 2.411296605642883e-10
+ 9.0545301487468137e-05 2.406727199550333e-10
+ 9.0557508518718135e-05 2.4040060549918595e-10
+ 9.0569715549968134e-05 2.4023855751768804e-10
+ 9.0581922581218133e-05 2.4014205601586099e-10
+ 9.0594129612468145e-05 2.4008458822552009e-10
+ 9.0606336643718144e-05 2.4005036536744095e-10
+ 9.0618543674968142e-05 2.4002998505548136e-10
+ 9.0630750706218141e-05 2.4001784836154639e-10
+ 9.064295773746814e-05 2.4001062082534474e-10
+ 9.0655164768718138e-05 2.4000631674323626e-10
+ 9.0667371799968137e-05 2.4000375361391963e-10
+ 9.0679578831218135e-05 2.4000222718017004e-10
+ 9.0691785862468134e-05 2.4000131819356677e-10
+ 9.0703992893718133e-05 2.4000077702242996e-10
+ 9.0716199924968131e-05 2.4000045459933931e-10
+ 9.0728406956218144e-05 2.4000026257884156e-10
+ 9.0740613987468142e-05 2.4000014832025053e-10
+ 9.0752821018718141e-05 2.4000008023582484e-10
+ 9.076502804996814e-05 2.4000003966625581e-10
+ 9.0777235081218138e-05 2.400000155533385e-10
+ 9.0789442112468137e-05 2.4000000121814107e-10
+ 9.0801649143718136e-05 2.3999999261673205e-10
+ 9.0813856174968134e-05 2.3999998758456908e-10
+ 9.0826063206218133e-05 2.3999998453222656e-10
+ 9.0838270237468132e-05 2.3999998265390494e-10
+ 9.085047726871813e-05 2.3999998161732485e-10
+ 9.0862684299968142e-05 2.3999998104358188e-10
+ 9.0874891331218141e-05 2.3999998057389865e-10
+ 9.088709836246814e-05 2.3999998026292464e-10
+ 9.0899305393718138e-05 2.3999998019001177e-10
+ 9.0911512424968137e-05 2.3999998019899801e-10
+ 9.0923719456218136e-05 2.3999998020597388e-10
+ 9.0935926487468134e-05 2.3999998012855701e-10
+ 9.0948133518718133e-05 2.3999998005534517e-10
+ 9.0960340549968132e-05 2.3999998008389102e-10
+ 9.097254758121813e-05 2.3999998009224399e-10
+ 9.0984754612468143e-05 2.3999998012219294e-10
+ 9.0996961643718141e-05 2.3999998013282356e-10
+ 9.100916867496814e-05 2.3999998009115475e-10
+ 9.1021375706218139e-05 2.3999998009706464e-10
+ 9.1033582737468137e-05 2.3999998010363494e-10
+ 9.1045789768718136e-05 2.3999998011314167e-10
+ 9.1057996799968134e-05 2.3999998013616955e-10
+ 9.1070203831218133e-05 2.3999998011363462e-10
+ 9.1082410862468132e-05 2.3999998009274014e-10
+ 9.109461789371813e-05 2.399999801011231e-10
+ 9.1106824924968129e-05 2.399999800977465e-10
+ 9.1119031956218141e-05 2.3999998010717031e-10
+ 9.113123898746814e-05 2.3999998026497155e-10
+ 9.1143446018718139e-05 2.3999998018940695e-10
+ 9.1155653049968137e-05 2.399999801489314e-10
+ 9.1167860081218136e-05 2.3999998016252337e-10
+ 9.1180067112468135e-05 2.3999998017736873e-10
+ 9.1192274143718133e-05 2.3999998008841631e-10
+ 9.1204481174968132e-05 2.399999801406156e-10
+ 9.1216688206218131e-05 2.3999998027111368e-10
+ 9.1228895237468129e-05 2.399999803096209e-10
+ 9.1241102268718141e-05 2.399999801745041e-10
+ 9.125330929996814e-05 2.3999998014351678e-10
+ 9.1265516331218139e-05 2.399999802735929e-10
+ 9.1277723362468137e-05 2.3999998026179471e-10
+ 9.1289930393718136e-05 2.3999998016976751e-10
+ 9.1302137424968135e-05 2.3999998022820648e-10
+ 9.1314344456218133e-05 2.3999998018386391e-10
+ 9.1326551487468132e-05 2.3999998024457121e-10
+ 9.1338758518718131e-05 2.399999802712344e-10
+ 9.1350965549968129e-05 2.3999998016906244e-10
+ 9.1363172581218142e-05 2.399999802251944e-10
+ 9.137537961246814e-05 2.3999998029674961e-10
+ 9.1387586643718139e-05 2.3999998024490881e-10
+ 9.1399793674968137e-05 2.3999998022841694e-10
+ 9.1412000706218136e-05 2.3999998027402318e-10
+ 9.1424207737468135e-05 2.3999998031284179e-10
+ 9.1436414768718133e-05 2.3999998024592236e-10
+ 9.1448621799968132e-05 2.3999998028900653e-10
+ 9.1460828831218144e-05 2.3999998029018118e-10
+ 9.1473035862468143e-05 2.3999998020407995e-10
+ 9.1485242893718142e-05 2.3999998030027903e-10
+ 9.149744992496814e-05 2.3999998034659856e-10
+ 9.1509656956218139e-05 2.3999998035710371e-10
+ 9.1521863987468138e-05 2.3999998035781327e-10
+ 9.1534071018718136e-05 2.3999998028429372e-10
+ 9.1546278049968135e-05 2.3999998026462584e-10
+ 9.1558485081218147e-05 2.3999998034401652e-10
+ 9.1570692112468146e-05 2.3999998040748526e-10
+ 9.1582899143718144e-05 2.399999802904164e-10
+ 9.1595106174968143e-05 2.3999998026488739e-10
+ 9.1607313206218142e-05 2.399999803948264e-10
+ 9.161952023746814e-05 2.399999803901337e-10
+ 9.1631727268718139e-05 2.3999998030809217e-10
+ 9.1643934299968138e-05 2.3999998036169063e-10
+ 9.165614133121815e-05 2.3999998033495331e-10
+ 9.1668348362468149e-05 2.3999998039429674e-10
+ 9.1680555393718147e-05 2.3999998043834603e-10
+ 9.1692762424968146e-05 2.3999998042747548e-10
+ 9.1704969456218145e-05 2.3999998033813589e-10
+ 9.1717176487468143e-05 2.3999998042749197e-10
+ 9.1729383518718142e-05 2.3999998045576412e-10
+ 9.1741590549968141e-05 2.3999998040668088e-10
+ 9.1753797581218153e-05 2.3999998041015307e-10
+ 9.1766004612468151e-05 2.3999998038280188e-10
+ 9.177821164371815e-05 2.399999804963409e-10
+ 9.1790418674968149e-05 2.3999998050724164e-10
+ 9.1802625706218147e-05 2.3999998043757132e-10
+ 9.1814832737468146e-05 2.3999998042873677e-10
+ 9.1827039768718145e-05 2.3999998048062938e-10
+ 9.1839246799968143e-05 2.3999998046244087e-10
+ 9.1851453831218156e-05 2.3999998047367506e-10
+ 9.1863660862468154e-05 2.3999998045481209e-10
+ 9.1875867893718153e-05 2.3999998043752122e-10
+ 9.1888074924968151e-05 2.3999998042446345e-10
+ 9.190028195621815e-05 2.3999998041722252e-10
+ 9.1912488987468149e-05 2.3999998041674074e-10
+ 9.1924696018718147e-05 2.3999998042357827e-10
+ 9.1936903049968146e-05 2.3999998043806778e-10
+ 9.1949110081218158e-05 2.3999998047660411e-10
+ 9.1961317112468157e-05 2.3999998051655456e-10
+ 9.1973524143718156e-05 2.3999998052591767e-10
+ 9.1985731174968154e-05 2.3999998048427911e-10
+ 9.1997938206218153e-05 2.3999998054712477e-10
+ 9.2010145237468152e-05 2.3999998057013456e-10
+ 9.202235226871815e-05 2.3999998051176627e-10
+ 9.2034559299968149e-05 2.3999998057450993e-10
+ 9.2046766331218161e-05 2.3999998053652084e-10
+ 9.205897336246816e-05 2.3999998056705243e-10
+ 9.2071180393718158e-05 2.399999805326457e-10
+ 9.2083387424968157e-05 2.399999805718764e-10
+ 9.2095594456218156e-05 2.3999998054921403e-10
+ 9.2107801487468154e-05 2.3999998061819825e-10
+ 9.2120008518718153e-05 2.399999805688973e-10
+ 9.2132215549968152e-05 2.3999998054792621e-10
+ 9.2144422581218164e-05 2.39999980627754e-10
+ 9.2156629612468163e-05 2.3999998059474422e-10
+ 9.2168836643718161e-05 2.399999805933057e-10
+ 9.218104367496816e-05 2.3999998057922352e-10
+ 9.2193250706218159e-05 2.3999998056088616e-10
+ 9.2205457737468157e-05 2.3999998058786213e-10
+ 9.2217664768718156e-05 2.399999806005213e-10
+ 9.2229871799968154e-05 2.3999998060792622e-10
+ 9.2242078831218167e-05 2.3999998061547279e-10
+ 9.2254285862468165e-05 2.3999998062637359e-10
+ 9.2266492893718164e-05 2.3999998064254068e-10
+ 9.2278699924968163e-05 2.399999806651119e-10
+ 9.2290906956218161e-05 2.3999998065019003e-10
+ 9.230311398746816e-05 2.3999998066078063e-10
+ 9.2315321018718159e-05 2.399999807158811e-10
+ 9.2327528049968157e-05 2.3999998065933043e-10
+ 9.2339735081218169e-05 2.3999998069949765e-10
+ 9.2351942112468168e-05 2.3999998071137632e-10
+ 9.2364149143718167e-05 2.3999998066492584e-10
+ 9.2376356174968165e-05 2.3999998067631891e-10
+ 9.2388563206218164e-05 2.3999998068067386e-10
+ 9.2400770237468163e-05 2.3999998072884115e-10
+ 9.2412977268718161e-05 2.3999998071703879e-10
+ 9.242518429996816e-05 2.399999807620995e-10
+ 9.2437391331218172e-05 2.3999998071038665e-10
+ 9.2449598362468171e-05 2.3999998068359319e-10
+ 9.246180539371817e-05 2.3999998073934671e-10
+ 9.2474012424968168e-05 2.3999998074833904e-10
+ 9.2486219456218167e-05 2.3999998072288318e-10
+ 9.2498426487468166e-05 2.3999998078919143e-10
+ 9.2510633518718164e-05 2.3999998076965073e-10
+ 9.2522840549968163e-05 2.399999807468099e-10
+ 9.2535047581218175e-05 2.3999998076982682e-10
+ 9.2547254612468174e-05 2.3999998077882701e-10
+ 9.2559461643718172e-05 2.3999998078272732e-10
+ 9.2571668674968171e-05 2.3999998077698307e-10
+ 9.258387570621817e-05 2.3999998078844893e-10
+ 9.2596082737468168e-05 2.3999998080355428e-10
+ 9.2608289768718167e-05 2.3999998082407074e-10
+ 9.2620496799968166e-05 2.3999998085105249e-10
+ 9.2632703831218178e-05 2.3999998076975625e-10
+ 9.2644910862468177e-05 2.399999808033618e-10
+ 9.2657117893718175e-05 2.3999998080328762e-10
+ 9.2669324924968174e-05 2.3999998084082399e-10
+ 9.2681531956218173e-05 2.3999998077877215e-10
+ 9.2693738987468171e-05 2.3999998083679345e-10
+ 9.270594601871817e-05 2.3999998087406507e-10
+ 9.2718153049968168e-05 2.3999998083776306e-10
+ 9.2730360081218181e-05 2.3999998086990843e-10
+ 9.2742567112468179e-05 2.3999998083702247e-10
+ 9.2754774143718178e-05 2.399999808776692e-10
+ 9.2766981174968177e-05 2.3999998085631119e-10
+ 9.2779188206218175e-05 2.3999998083949021e-10
+ 9.2791395237468174e-05 2.3999929577393646e-10
+ 9.2803602268718173e-05 2.3999721430085655e-10
+ 9.2815809299968171e-05 2.3999541801853927e-10
+ 9.2828016331218183e-05 2.3999352441667849e-10
+ 9.2840223362468182e-05 2.3998998231508299e-10
+ 9.2852430393718181e-05 2.3998269751518182e-10
+ 9.2864637424968179e-05 2.3996731785187146e-10
+ 9.2870740940593179e-05 2.3994983464395233e-10
+ 9.2876844456218178e-05 2.3990674100743305e-10
+ 9.2879896214030685e-05 2.3985615585153402e-10
+ 9.2882947971843177e-05 2.3973456609508262e-10
+ 9.2884473850749424e-05 2.3959023649420816e-10
+ 9.2885999729655684e-05 2.3924487360909957e-10
+ 9.2886991106889191e-05 2.3866252493064795e-10
+ 9.2887269733896236e-05 2.3836567845599657e-10
+ 9.2887548360903296e-05 2.3795958755937176e-10
+ 9.2888098835627964e-05 2.3707317678626589e-10
+ 9.2890875273912431e-05 2.3289947932096134e-10
+ 9.2903082305162429e-05 2.1857108082062022e-10
+ 9.2915289336412441e-05 2.0744394567167327e-10
+ 9.292749636766244e-05 1.9657101424192844e-10
+ 9.2939703398912439e-05 1.8444183633608339e-10
+ 9.2951910430162437e-05 1.7048236032410772e-10
+ 9.2964117461412436e-05 1.5473832156939622e-10
+ 9.2976324492662435e-05 1.376643966131987e-10
+ 9.2988531523912433e-05 1.1997405552563603e-10
+ 9.3000738555162432e-05 1.0252468847149855e-10
+ 9.3012945586412431e-05 8.622433036431135e-11
+ 9.3025152617662443e-05 7.1953269034585456e-11
+ 9.3037359648912441e-05 6.0497851486217764e-11
+ 9.304956668016244e-05 5.2496010132610782e-11
+ 9.3061773711412439e-05 4.8395088933560857e-11
+ 9.3073980742662437e-05 4.8422873289603413e-11
+ 9.3086187773912436e-05 5.2572582289997926e-11
+ 9.3098394805162435e-05 6.0602144636946106e-11
+ 9.3110601836412447e-05 7.2047475992215135e-11
+ 9.3122808867662446e-05 8.6248800170538565e-11
+ 9.3135015898912444e-05 1.0238838404643464e-10
+ 9.3147222930162443e-05 1.19537446121802e-10
+ 9.3159429961412442e-05 1.367094991032434e-10
+ 9.317163699266244e-05 1.5291703382970249e-10
+ 9.3183844023912439e-05 1.6722827017382802e-10
+ 9.3186895781724945e-05 1.7041028620342427e-10
+ 9.3187048369615565e-05 1.7056469761267313e-10
+ 9.3187429839342126e-05 1.7094872387604414e-10
+ 9.3187467986314781e-05 1.7098696858623529e-10
+ 9.318747561570932e-05 1.7099461407315297e-10
+ 9.3187490874498385e-05 1.7100990159048815e-10
+ 9.3187496978014e-05 1.7101601530675094e-10
+ 9.3187499419420262e-05 1.7101846058671687e-10
+ 9.3187499604455788e-05 1.7101864591102341e-10
+ 9.3187499974526841e-05 1.710190165576025e-10
+ 9.3187500714668947e-05 2.9362295535076986e-10
+ 9.3187501454811052e-05 6.7955376462053112e-10
+ 9.3187508856232149e-05 1.9019685483973129e-08
+ 9.3187516257653232e-05 6.3680162617685321e-08
+ 9.3187523659074329e-05 1.3464578979540883e-07
+ 9.3187531060495412e-05 2.3189729697639808e-07
+ 9.3187538461916508e-05 3.5541134357275011e-07
+ 9.3187547512355685e-05 5.4209487018455778e-07
+ 9.3187556562794862e-05 7.6794744751962639e-07
+ 9.3187565613234052e-05 1.032901665904789e-06
+ 9.3187574663673229e-05 1.3368810846168448e-06
+ 9.3187583714112406e-05 1.6798002590529673e-06
+ 9.3187595044533504e-05 2.1638522289015684e-06
+ 9.3187606374954603e-05 2.7085809274094572e-06
+ 9.3187617705375701e-05 3.3137595140903088e-06
+ 9.31876290357968e-05 3.9791394372703589e-06
+ 9.3187643214653361e-05 4.8961848891924115e-06
+ 9.3187657393509909e-05 5.9065041934527361e-06
+ 9.3187671572366471e-05 7.0094688242501652e-06
+ 9.3187689032396935e-05 8.4939484121898285e-06
+ 9.31877064924274e-05 1.011650368403691e-05
+ 9.3187723952457865e-05 1.187564441966631e-05
+ 9.3187746268477828e-05 1.4320324258348367e-05
+ 9.3187768584497804e-05 1.6981891243476683e-05
+ 9.3187790900517767e-05 1.9856448881756975e-05
+ 9.3187819090217243e-05 2.3785542948120637e-05
+ 9.3187847279916706e-05 2.8038794641957824e-05
+ 9.3187875469616182e-05 3.2606525910010655e-05
+ 9.3187903659315644e-05 3.7478440563006991e-05
+ 9.318793184901512e-05 4.2643660624918842e-05
+ 9.3187960038714596e-05 4.809076449946518e-05
+ 9.3187988228414059e-05 5.3807826764352856e-05
+ 9.3188019414106474e-05 6.0432058501488789e-05
+ 9.3188050599798876e-05 6.7354141141263776e-05
+ 9.3188081785491292e-05 7.4556149339010216e-05
+ 9.3188112971183707e-05 8.2019674226669682e-05
+ 9.318815041841434e-05 9.1300740447793598e-05
+ 9.3188187865644959e-05 0.00010089852928503813
+ 9.3188225312875592e-05 0.00011077933330704341
+ 9.3188270844195802e-05 0.00012312530862772575
+ 9.3188316375516025e-05 0.00013577798574481139
+ 9.3188361906836235e-05 0.00014867616552750304
+ 9.3188407438156445e-05 0.00016175929991125412
+ 9.318844108402811e-05 0.00017151113091571656
+ 9.3188474729899776e-05 0.00018130797963939794
+ 9.3188508375771441e-05 0.00019112690048319055
+ 9.3188542021643107e-05 0.000200945563836072
+ 9.3188575667514772e-05 0.0002107423308290232
+ 9.3188609313386438e-05 0.00022049632214156449
+ 9.3188642959258103e-05 0.00023018748061678874
+ 9.3188676605129769e-05 0.00023979662749408118
+ 9.3188710251001434e-05 0.0002493055121224335
+ 9.3188736870668151e-05 0.00025674620625396695
+ 9.3188763490334854e-05 0.00026410519322842072
+ 9.3188790110001571e-05 0.00027137476557784006
+ 9.3188816729668274e-05 0.00027854762813939171
+ 9.3188843349334991e-05 0.00028561690431054267
+ 9.3188869969001694e-05 0.0002925761407342706
+ 9.318889658866841e-05 0.0002994193104460534
+ 9.3188923208335127e-05 0.00030614081452042582
+ 9.318894982800183e-05 0.00031273548226053464
+ 9.3188976447668547e-05 0.00031919856997935221
+ 9.318900306733525e-05 0.00032552575842600295
+ 9.3189029687001967e-05 0.00033171314891500655
+ 9.318905630666867e-05 0.00033775725822013397
+ 9.3189082926335386e-05 0.00034365501229800138
+ 9.318910954600209e-05 0.00034940373890948994
+ 9.3189136165668806e-05 0.00035500115920957621
+ 9.3189162785335523e-05 0.00036044537837818884
+ 9.3189189405002226e-05 0.00036573487536628151
+ 9.3189216024668943e-05 0.00037086849183281574
+ 9.3189239404935226e-05 0.00037524816041470616
+ 9.3189262785201509e-05 0.00037950661982143294
+ 9.3189286165467806e-05 0.00038364373347733212
+ 9.3189309545734089e-05 0.00038765955240256639
+ 9.3189332926000385e-05 0.00039155430797307712
+ 9.3189356306266669e-05 0.00039532840450424615
+ 9.3189379686532952e-05 0.00039898241168751826
+ 9.3189403066799248e-05 0.00040251705690861332
+ 9.3189426447065532e-05 0.00040593321747524688
+ 9.3189449827331815e-05 0.0004092319127814815
+ 9.3189473207598111e-05 0.00041241429643495774
+ 9.3189496587864394e-05 0.00041548164837231091
+ 9.3189519968130691e-05 0.00041843536698707185
+ 9.3189543348396974e-05 0.00042127696129328835
+ 9.3189566728663257e-05 0.00042400804314699181
+ 9.3189590108929554e-05 0.00042663031954648096
+ 9.3189613489195837e-05 0.00042914558503120656
+ 9.318963686946212e-05 0.00043155571419782471
+ 9.3189660249728417e-05 0.00043386265435075173
+ 9.31896836299947e-05 0.0004360684183033
+ 9.3189707010260997e-05 0.00043817507734421687
+ 9.3189735591237517e-05 0.00044061881915944171
+ 9.3189764172214038e-05 0.00044292160557832261
+ 9.3189792753190558e-05 0.00044508748731897325
+ 9.3189821334167092e-05 0.0004471205811035718
+ 9.3189849915143613e-05 0.00044902505354874717
+ 9.3189886199806211e-05 0.00045126415767136695
+ 9.3189925453373377e-05 0.00045347065125915753
+ 9.3189946977215263e-05 0.00045458914938144757
+ 9.3189973696714693e-05 0.00045589098737442259
+ 9.3190000416214135e-05 0.00045710004038524538
+ 9.3190027135713565e-05 0.00045821970861944291
+ 9.3190053855213008e-05 0.00045925335947318648
+ 9.3190080574712437e-05 0.00046020432082601948
+ 9.319010729421188e-05 0.00046107587487371744
+ 9.3190134013711309e-05 0.00046187125249194449
+ 9.3190160733210752e-05 0.00046259362811953432
+ 9.3190187452710181e-05 0.00046324611514856153
+ 9.3190214172209624e-05 0.00046383176180687778
+ 9.3190240891709053e-05 0.00046435354751746608
+ 9.3190262548859614e-05 0.00046473161709406521
+ 9.319028420601016e-05 0.00046507115570231151
+ 9.319030586316072e-05 0.00046537364255429416
+ 9.3190327520311267e-05 0.00046564052306956875
+ 9.3190349177461814e-05 0.00046587320827894959
+ 9.3190370834612374e-05 0.00046607307433484731
+ 9.3190392491762921e-05 0.00046624146212347479
+ 9.3190414148913467e-05 0.00046637967697419719
+ 9.3190435806064027e-05 0.00046648898846127722
+ 9.3190457463214574e-05 0.00046657063029325929
+ 9.3190479120365121e-05 0.0004666258002852115
+ 9.3190496765399602e-05 0.00046665198683365781
+ 9.319051441043407e-05 0.00046666198405394353
+ 9.3190532055468551e-05 0.00046665638716889121
+ 9.3190549700503019e-05 0.00046663577581361698
+ 9.3190567345537501e-05 0.00046660071413966874
+ 9.3190584990571968e-05 0.00046655175093608377
+ 9.319060263560645e-05 0.00046648941976632619
+ 9.3190620280640918e-05 0.00046641423912008399
+ 9.3190637925675386e-05 0.00046632671257892689
+ 9.3190655570709867e-05 0.00046622732899484812
+ 9.3190673215744335e-05 0.00046611656268073646
+ 9.3190690860778816e-05 0.00046599487361184948
+ 9.3190708505813284e-05 0.00046586270763738396
+ 9.3190726150847765e-05 0.00046572049670126538
+ 9.3190743795882233e-05 0.00046556865907130521
+ 9.3190761440916715e-05 0.00046540759957590188
+ 9.3190779085951182e-05 0.00046523770984748908
+ 9.319079673098565e-05 0.00046505936857196291
+ 9.3190814376020132e-05 0.00046487294174334804
+ 9.31908320210546e-05 0.00046467878292299136
+ 9.3190849666089081e-05 0.00046447723350260048
+ 9.3190867311123549e-05 0.00046426862297047311
+ 9.319088495615803e-05 0.00046405326918029163
+ 9.3190902601192498e-05 0.00046383147862188659
+ 9.3190920246226966e-05 0.0004636035466933999
+ 9.3190937891261447e-05 0.00046336975797430831
+ 9.3190955536295915e-05 0.00046313038649879376
+ 9.3190973181330396e-05 0.00046288569602897633
+ 9.3190990826364864e-05 0.00046263594032755121
+ 9.3191008471399346e-05 0.00046238136342939871
+ 9.3191026116433813e-05 0.00046212219991176166
+ 9.3191043761468281e-05 0.00046185867516261082
+ 9.3191061406502763e-05 0.00046159100564684353
+ 9.3191079051537231e-05 0.00046131939916998468
+ 9.3191096696571712e-05 0.00046104405513908457
+ 9.319111434160618e-05 0.00046076516482052872
+ 9.3191131986640661e-05 0.00046048291159450004
+ 9.3191149631675129e-05 0.00046019747120585279
+ 9.319116727670961e-05 0.00045990901201118061
+ 9.3191184921744078e-05 0.00045961769522188066
+ 9.3191202566778546e-05 0.00045932367514303494
+ 9.3191220211813027e-05 0.00045902709940794936
+ 9.3191237856847495e-05 0.00045872810920820898
+ 9.3191255501881977e-05 0.00045842683951912496
+ 9.3191273146916445e-05 0.00045812341932046545
+ 9.3191290791950926e-05 0.00045781797181237863
+ 9.3191308436985394e-05 0.00045751061462643097
+ 9.3191326082019875e-05 0.00045720146003169808
+ 9.3191343727054343e-05 0.00045689061513585962
+ 9.3191361372088811e-05 0.00045657818208126165
+ 9.3191379017123292e-05 0.00045626425823592343
+ 9.319139666215776e-05 0.0004559489363794755
+ 9.3191414307192241e-05 0.0004556323048840281
+ 9.3191431952226709e-05 0.00045531444788997848
+ 9.3191449597261191e-05 0.00045499544547677518
+ 9.3191467242295659e-05 0.00045467537382866608
+ 9.3191484887330126e-05 0.00045435430539546583
+ 9.3191502532364608e-05 0.00045403230904838535
+ 9.3191520177399076e-05 0.00045370945023097327
+ 9.3191537822433557e-05 0.00045338579110522598
+ 9.3191555467468025e-05 0.00045306139069292836
+ 9.3191573112502506e-05 0.00045273630501229328
+ 9.3191590757536974e-05 0.00045241058720997258
+ 9.3191608402571442e-05 0.00045208428768851668
+ 9.3191626047605923e-05 0.00045175745422936376
+ 9.3191643692640391e-05 0.00045143013211144381
+ 9.3191661337674873e-05 0.00045110236422548483
+ 9.3191682620107571e-05 0.00045070649383213837
+ 9.3191702745281681e-05 0.00045033166770387813
+ 9.3191722870455778e-05 0.00044995642757493547
+ 9.3191742995629888e-05 0.00044958082330929242
+ 9.3191763120803984e-05 0.00044920490166811688
+ 9.3191783245978081e-05 0.00044882870648050557
+ 9.3191803371152191e-05 0.00044845227880637947
+ 9.3191823496326288e-05 0.00044807565709178331
+ 9.3191843621500398e-05 0.00044769887731683952
+ 9.3191863746674495e-05 0.00044732197313660687
+ 9.3191888110746128e-05 0.00044686556133260454
+ 9.3191912474817747e-05 0.00044640906499999366
+ 9.3191936838889379e-05 0.00044595253182312878
+ 9.3191961202961012e-05 0.00044549600565976083
+ 9.3191985567032631e-05 0.00044503952681690417
+ 9.3192009931104263e-05 0.00044458313230938829
+ 9.3192034295175896e-05 0.00044412685610195336
+ 9.3192058659247515e-05 0.00044367072933572632
+ 9.3192083023319148e-05 0.00044321478053989036
+ 9.3192107387390767e-05 0.00044275903582933563
+ 9.3192136719683573e-05 0.00044221066197735565
+ 9.3192166051976366e-05 0.00044166265618977781
+ 9.319219538426916e-05 0.00044111505229614979
+ 9.3192224716561953e-05 0.000440567880571222
+ 9.3192254048854746e-05 0.0004400211680723513
+ 9.3192283381147539e-05 0.0004394749389480193
+ 9.3192312713440332e-05 0.0004389292147195882
+ 9.3192342045733125e-05 0.00043838401453830063
+ 9.319237784802919e-05 0.00043771929099924211
+ 9.3192412335454624e-05 0.00043707976746529866
+ 9.3192446822880058e-05 0.00043644103787377733
+ 9.3192481310305493e-05 0.00043580312030283216
+ 9.3192515797730927e-05 0.00043516603032572377
+ 9.3192557828321212e-05 0.00043439073279079223
+ 9.3192599858911483e-05 0.00043361670459320404
+ 9.3192641889501768e-05 0.00043284396248195208
+ 9.3192683920092039e-05 0.00043207252012209858
+ 9.3192725950682324e-05 0.00043130238856505936
+ 9.3192777518503423e-05 0.00043035930871672526
+ 9.3192828186666475e-05 0.00042943462880424378
+ 9.319287885482954e-05 0.00042851188736760037
+ 9.3192929522992592e-05 0.00042759109050169295
+ 9.3192993215143456e-05 0.00042643637215815307
+ 9.319305690729432e-05 0.0004252847370223043
+ 9.3193120599445185e-05 0.00042413618616643506
+ 9.3193198945610718e-05 0.00042272760989246018
+ 9.319327865764969e-05 0.00042129925771114857
+ 9.3193358369688661e-05 0.00041987571829712041
+ 9.3193461292370757e-05 0.00041804477075287836
+ 9.3193569508909812e-05 0.00041612824858809757
+ 9.3193701914804437e-05 0.00041379527174881443
+ 9.3193847065030179e-05 0.00041125276249577136
+ 9.3194034315235687e-05 0.00040799587225246868
+ 9.3194255865010429e-05 0.00040417569543334638
+ 9.3194554034092505e-05 0.00039909077578923559
+ 9.3194998769870888e-05 0.00039162496079868337
+ 9.3195805003988997e-05 0.00037844492463713218
+ 9.3196711764368317e-05 0.00036415075183872955
+ 9.3197737475686444e-05 0.00034863113834200367
+ 9.3198801143402335e-05 0.00033323544260725887
+ 9.3199944764949541e-05 0.00031744009309453978
+ 9.3202231646278907e-05 0.00028806442739914481
+ 9.3204182681216655e-05 0.00026516169925578173
+ 9.3206291228517242e-05 0.00024245284579639417
+ 9.3208581467436164e-05 0.00021998507757767748
+ 9.3210926666850022e-05 0.00019913410083615226
+ 9.321327186626388e-05 0.00018025945489984468
+ 9.321559053717963e-05 0.00016335772611693962
+ 9.3218474569484283e-05 0.00014452917890563918
+ 9.3221358601788923e-05 0.00012787080313841811
+ 9.3224242634093576e-05 0.00011313246567173927
+ 9.322712666639823e-05 0.00010009286360866482
+ 9.3230010698702869e-05 8.8556201336288662e-05
+ 9.3232894731007523e-05 7.8349250567829904e-05
+ 9.3235778763312176e-05 6.9318749243295542e-05
+ 9.3239342797663593e-05 5.9583601550415324e-05
+ 9.324290683201501e-05 5.12156620124964e-05
+ 9.3246470866366427e-05 4.4022919356413453e-05
+ 9.3250034900717858e-05 3.7840328450154061e-05
+ 9.3253598935069275e-05 3.2526023165760874e-05
+ 9.3257899961127354e-05 2.7096692323683933e-05
+ 9.3262200987185448e-05 2.2573641128908005e-05
+ 9.3266502013243541e-05 1.8805590756409222e-05
+ 9.327080303930162e-05 1.5666514280396347e-05
+ 9.3275104065359713e-05 1.3051421554109079e-05
+ 9.3280502505986977e-05 1.0377818664489998e-05
+ 9.3285900946614241e-05 8.251909089995107e-06
+ 9.3291299387241518e-05 6.5614966739560858e-06
+ 9.3296697827868782e-05 5.2173688876777125e-06
+ 9.330346824765747e-05 3.9138135354349389e-06
+ 9.3310238667446157e-05 2.9359531577328348e-06
+ 9.3317009087234845e-05 2.2024124497970242e-06
+ 9.3325385304343951e-05 1.5432541258101081e-06
+ 9.333376152145307e-05 1.081378721967762e-06
+ 9.3342137738562176e-05 7.5774041132707628e-07
+ 9.3353043385488655e-05 4.7689837631713853e-07
+ 9.3363949032415134e-05 3.0015113649486665e-07
+ 9.3376156063665133e-05 1.7876217937191045e-07
+ 9.3388363094915131e-05 1.0647330757921957e-07
+ 9.340057012616513e-05 6.3424252544034479e-08
+ 9.3412777157415129e-05 3.7787934734000867e-08
+ 9.3424984188665127e-05 2.2521155841269887e-08
+ 9.3437191219915126e-05 1.3429588576020001e-08
+ 9.3449398251165125e-05 8.015449872567151e-09
+ 9.3461605282415137e-05 4.7912734917149069e-09
+ 9.3473812313665136e-05 2.871251600636248e-09
+ 9.3486019344915134e-05 1.7278727196949598e-09
+ 9.3498226376165133e-05 1.0469960699243559e-09
+ 9.3510433407415131e-05 6.4154623608527275e-10
+ 9.352264043866513e-05 4.0011708092908531e-10
+ 9.3534847469915129e-05 2.563646256420896e-10
+ 9.3547054501165141e-05 1.7078006330613652e-10
+ 9.355926153241514e-05 1.1983532309874618e-10
+ 9.3571468563665138e-05 8.9519095817165878e-11
+ 9.3583675594915137e-05 7.14874426319846e-11
+ 9.3595882626165136e-05 6.0771426293748156e-11
+ 9.3608089657415134e-05 5.4411972164600532e-11
+ 9.3620296688665133e-05 5.0646908151112081e-11
+ 9.3632503719915132e-05 4.8426835103990855e-11
+ 9.364471075116513e-05 4.7126820532761082e-11
+ 9.3656917782415142e-05 4.6374708016315066e-11
+ 9.3669124813665141e-05 4.594887297816922e-11
+ 9.368133184491514e-05 4.5717334758833713e-11
+ 9.3693538876165138e-05 4.5601496954841019e-11
+ 9.3705745907415137e-05 4.5554554261028926e-11
+ 9.3717952938665136e-05 4.5548633436145208e-11
+ 9.3730159969915134e-05 4.5567135561437956e-11
+ 9.3742367001165147e-05 4.5600175741221697e-11
+ 9.3750000000000002e-05 4.5624752229059989e-11
+ 9.3762207031250001e-05 4.5669966819297461e-11
+ 9.3774414062499999e-05 4.5718898557805248e-11
+ 9.3786621093749998e-05 4.5770037749483043e-11
+ 9.3798828124999997e-05 4.5822485350610839e-11
+ 9.3811035156249995e-05 4.5875705969269391e-11
+ 9.3823242187500007e-05 4.5929380773488921e-11
+ 9.3835449218750006e-05 4.5983319895906806e-11
+ 9.3847656250000005e-05 4.6037410269464089e-11
+ 9.3859863281250003e-05 4.6091584562801975e-11
+ 9.3872070312500002e-05 4.6145802680837535e-11
+ 9.3884277343750001e-05 4.6200040748086769e-11
+ 9.3896484374999999e-05 4.6254284548072891e-11
+ 9.3908691406249998e-05 4.6308525616398256e-11
+ 9.3920898437499997e-05 4.6362758914111761e-11
+ 9.3933105468749995e-05 4.641698144216514e-11
+ 9.3945312500000008e-05 4.6471191416301583e-11
+ 9.3957519531250006e-05 4.6525387775689795e-11
+ 9.3969726562500005e-05 4.6579569890308451e-11
+ 9.3981933593750004e-05 4.663373738668933e-11
+ 9.3994140625000002e-05 4.6687890044144897e-11
+ 9.4006347656250001e-05 4.6742027732970226e-11
+ 9.4018554687499999e-05 4.6796150377641402e-11
+ 9.4030761718749998e-05 4.6850257934899579e-11
+ 9.4042968749999997e-05 4.690435038069982e-11
+ 9.4055175781249995e-05 4.695842770243876e-11
+ 9.4067382812500008e-05 4.7012489894326265e-11
+ 9.4079589843750006e-05 4.7066536954629075e-11
+ 9.4091796875000005e-05 4.7120568884029375e-11
+ 9.4104003906250004e-05 4.7174585684647293e-11
+ 9.4116210937500002e-05 4.7228587359458799e-11
+ 9.4128417968750001e-05 4.728257391194907e-11
+ 9.4140625e-05 4.7336545345906017e-11
+ 9.4152832031249998e-05 4.7390501665297362e-11
+ 9.4165039062499997e-05 4.7444442874197415e-11
+ 9.4177246093749996e-05 4.7498368976743532e-11
+ 9.4189453125000008e-05 4.7552279977110043e-11
+ 9.4201660156250006e-05 4.7606175879492929e-11
+ 9.4213867187500005e-05 4.76600566881005e-11
+ 9.4226074218750004e-05 4.771392240714795e-11
+ 9.4238281250000002e-05 4.7767773040854128e-11
+ 9.4250488281250001e-05 4.7821608593439534e-11
+ 9.42626953125e-05 4.7875429069125182e-11
+ 9.4274902343749998e-05 4.7929234472131972e-11
+ 9.4287109374999997e-05 4.7983024806680162e-11
+ 9.4299316406249996e-05 4.8036800076989225e-11
+ 9.4311523437500008e-05 4.8090560287277661e-11
+ 9.4323730468750007e-05 4.81443054417629e-11
+ 9.4335937500000005e-05 4.8198035544661283e-11
+ 9.4348144531250004e-05 4.8251750600188019e-11
+ 9.4360351562500002e-05 4.8305450612557161e-11
+ 9.4372558593750001e-05 4.835913558598157e-11
+ 9.4384765625e-05 4.8412805524672993e-11
+ 9.4396972656249998e-05 4.846646043284194e-11
+ 9.4409179687499997e-05 4.8520100314697792e-11
+ 9.4421386718749996e-05 4.8573725174448732e-11
+ 9.4433593750000008e-05 4.8627335016301782e-11
+ 9.4445800781250007e-05 4.8680929844462761e-11
+ 9.4458007812500005e-05 4.8734509663136332e-11
+ 9.4470214843750004e-05 4.8788074476525962e-11
+ 9.4482421875000003e-05 4.8841624288833967e-11
+ 9.4494628906250001e-05 4.8895159104261467e-11
+ 9.45068359375e-05 4.894867892700839e-11
+ 9.4519042968749999e-05 4.9002183761273549e-11
+ 9.4531249999999997e-05 4.905567361125451e-11
+ 9.4543457031249996e-05 4.9109148481147716e-11
+ 9.4555664062500008e-05 4.9162608375148381e-11
+ 9.4567871093750007e-05 4.9216053297450589e-11
+ 9.4580078125000005e-05 4.9269483252247235e-11
+ 9.4592285156250004e-05 4.932289824373005e-11
+ 9.4604492187500003e-05 4.9376298276089576e-11
+ 9.4616699218750001e-05 4.9429683353515166e-11
+ 9.462890625e-05 4.9483053480195042e-11
+ 9.4641113281249999e-05 4.9536408660316226e-11
+ 9.4653320312499997e-05 4.9589748898064572e-11
+ 9.466552734375001e-05 4.9643074197624777e-11
+ 9.4677734375000008e-05 4.9696384563180337e-11
+ 9.4689941406250007e-05 4.9749679998913594e-11
+ 9.4702148437500006e-05 4.980296050900572e-11
+ 9.4714355468750004e-05 4.9856226097636712e-11
+ 9.4726562500000003e-05 4.99094767689854e-11
+ 9.4738769531250001e-05 4.9962712527229435e-11
+ 9.47509765625e-05 5.0015933376545304e-11
+ 9.4763183593749999e-05 5.0069139321108297e-11
+ 9.4775390624999997e-05 5.0122330365092602e-11
+ 9.4787597656249996e-05 5.0175506512671175e-11
+ 9.4799804687500008e-05 5.0228667768015851e-11
+ 9.4812011718750007e-05 5.0281814135297241e-11
+ 9.4824218750000006e-05 5.0334945618684835e-11
+ 9.4836425781250004e-05 5.0388062222346936e-11
+ 9.4848632812500003e-05 5.0441163950450669e-11
+ 9.4860839843750002e-05 5.0494250807162017e-11
+ 9.4873046875e-05 5.0547322796645784e-11
+ 9.4885253906249999e-05 5.060037992306559e-11
+ 9.4897460937499998e-05 5.0653422190583924e-11
+ 9.4909667968749996e-05 5.0706449603362099e-11
+ 9.4921875000000008e-05 5.0759462165560252e-11
+ 9.4934082031250007e-05 5.0812459881337356e-11
+ 9.4946289062500006e-05 5.086544275485121e-11
+ 9.4958496093750004e-05 5.0918410790258479e-11
+ 9.4970703125000003e-05 5.0971363991714641e-11
+ 9.4982910156250002e-05 5.1024302363374004e-11
+ 9.49951171875e-05 5.1077225909389738e-11
+ 9.5007324218749999e-05 5.1130134633913832e-11
+ 9.5019531249999998e-05 5.1183028541097097e-11
+ 9.5031738281249996e-05 5.123590763508922e-11
+ 9.5043945312499995e-05 5.1288771920038706e-11
+ 9.5056152343750007e-05 5.1341621400092889e-11
+ 9.5068359375000006e-05 5.1394456079397949e-11
+ 9.5080566406250004e-05 5.1447275962098919e-11
+ 9.5092773437500003e-05 5.1500081052339658e-11
+ 9.5104980468750002e-05 5.1552871354262853e-11
+ 9.51171875e-05 5.1605646872010057e-11
+ 9.5129394531249999e-05 5.1658407609721638e-11
+ 9.5141601562499998e-05 5.171115357153682e-11
+ 9.5153808593749996e-05 5.1763884761593666e-11
+ 9.5166015624999995e-05 5.1816601184029079e-11
+ 9.5178222656249994e-05 5.1869302842978788e-11
+ 9.5190429687500006e-05 5.1921989742577379e-11
+ 9.5202636718750005e-05 5.1974661886958285e-11
+ 9.5214843750000003e-05 5.2027319280253771e-11
+ 9.5227050781250002e-05 5.2079961926594946e-11
+ 9.5239257812500001e-05 5.2132589830111786e-11
+ 9.5251464843749999e-05 5.2185202994933079e-11
+ 9.5263671874999998e-05 5.2237801425186463e-11
+ 9.5275878906249997e-05 5.2290385124998426e-11
+ 9.5288085937499995e-05 5.2342954098494298e-11
+ 9.5300292968749994e-05 5.2395508349798247e-11
+ 9.5312499999999992e-05 5.2448047883033309e-11
+ 9.5324707031250005e-05 5.2500572702321331e-11
+ 9.5336914062500003e-05 5.2553082811783024e-11
+ 9.5349121093750002e-05 5.260557821553798e-11
+ 9.5361328125000001e-05 5.265805891770455e-11
+ 9.5373535156249999e-05 5.2710524922400013e-11
+ 9.5385742187499998e-05 5.2762976233740464e-11
+ 9.5397949218749997e-05 5.281541285584085e-11
+ 9.5410156249999995e-05 5.2867834792814952e-11
+ 9.5422363281249994e-05 5.2920242048775429e-11
+ 9.5434570312499993e-05 5.297263462783375e-11
+ 9.5446777343750005e-05 5.3025012534100265e-11
+ 9.5458984375000003e-05 5.3077375771684144e-11
+ 9.5471191406250002e-05 5.3129724344693429e-11
+ 9.5483398437500001e-05 5.3182058257235008e-11
+ 9.5495605468749999e-05 5.3234377513414598e-11
+ 9.5507812499999998e-05 5.3286682117336819e-11
+ 9.5520019531249997e-05 5.3338972073105086e-11
+ 9.5532226562499995e-05 5.339124738482168e-11
+ 9.5544433593749994e-05 5.3443508056587737e-11
+ 9.5556640624999993e-05 5.349575409250326e-11
+ 9.5568847656249991e-05 5.3547985496667078e-11
+ 9.5581054687500004e-05 5.3600202273176877e-11
+ 9.5593261718750002e-05 5.3652404426129203e-11
+ 9.5605468750000001e-05 5.3704591959619454e-11
+ 9.561767578125e-05 5.3756764877741888e-11
+ 9.5629882812499998e-05 5.3808923184589598e-11
+ 9.5642089843749997e-05 5.3861066884254534e-11
+ 9.5654296874999996e-05 5.3913195980827531e-11
+ 9.5666503906249994e-05 5.3965310478398236e-11
+ 9.5678710937499993e-05 5.4017410381055188e-11
+ 9.5690917968749991e-05 5.4069495692885746e-11
+ 9.5703125000000004e-05 5.4121566417976143e-11
+ 9.5715332031250002e-05 5.4173622560411455e-11
+ 9.5727539062500001e-05 5.4225664124275648e-11
+ 9.573974609375e-05 5.4277691113651499e-11
+ 9.5751953124999998e-05 5.4329703532620677e-11
+ 9.5764160156249997e-05 5.4381701385263697e-11
+ 9.5776367187499996e-05 5.4433684675659917e-11
+ 9.5788574218749994e-05 5.4485653407887576e-11
+ 9.5800781249999993e-05 5.4537607586023745e-11
+ 9.5812988281249992e-05 5.4589547214144361e-11
+ 9.582519531249999e-05 5.4641472296324253e-11
+ 9.5837402343750002e-05 5.4693382836637059e-11
+ 9.5849609375000001e-05 5.4745278839155299e-11
+ 9.586181640625e-05 5.4797160307950356e-11
+ 9.5874023437499998e-05 5.4849027247092475e-11
+ 9.5886230468749997e-05 5.4900879660650734e-11
+ 9.5898437499999996e-05 5.4952717552693121e-11
+ 9.5910644531249994e-05 5.5004540927286431e-11
+ 9.5922851562499993e-05 5.5055228596414379e-11
+ 9.5935058593749992e-05 5.510627065877697e-11
+ 9.594726562499999e-05 5.5158092921228189e-11
+ 9.5959472656249989e-05 5.5210849104087091e-11
+ 9.5971679687500001e-05 5.5264521350196526e-11
+ 9.598388671875e-05 5.5318219478297029e-11
+ 9.5989990234374999e-05 5.5343709041866146e-11
+ 9.5996093749999999e-05 5.5365175813779936e-11
+ 9.5999145507812491e-05 5.537183500008943e-11
+ 9.6002197265624998e-05 5.5371668509114686e-11
+ 9.6005249023437491e-05 5.5354771851498252e-11
+ 9.6006606790774082e-05 5.5334751403020664e-11
+ 9.6006998216660862e-05 5.5326313558461538e-11
+ 9.6007389642547642e-05 5.5316205768572161e-11
+ 9.6008368207264571e-05 5.5280832763072969e-11
+ 9.6009409502908181e-05 5.5216998316807767e-11
+ 9.6009970598735317e-05 5.5162661637241072e-11
+ 9.6010339629298369e-05 5.5114439869388932e-11
+ 9.6011110323815838e-05 5.4960015216721681e-11
+ 9.6011741481233847e-05 5.4732817211499076e-11
+ 9.601211308400901e-05 5.4516300482441227e-11
+ 9.6012434193795787e-05 5.42419953316085e-11
+ 9.6012647097925416e-05 5.400886072195258e-11
+ 9.6012860002055031e-05 5.3774257755821461e-11
+ 9.6014989043351239e-05 5.1549852354822979e-11
+ 9.6027196074601251e-05 4.2855387214314058e-11
+ 9.603940310585125e-05 4.053247294954365e-11
+ 9.6051610137101249e-05 4.3931039996784842e-11
+ 9.6063817168351247e-05 5.2388572167819672e-11
+ 9.6076024199601246e-05 6.5140225940715896e-11
+ 9.6088231230851245e-05 8.1286621114128428e-11
+ 9.6100438262101243e-05 9.9800201152591339e-11
+ 9.6112645293351242e-05 1.1955731974057662e-10
+ 9.6124852324601241e-05 1.3938677731239894e-10
+ 9.6137059355851239e-05 1.581275910662053e-10
+ 9.6149266387101251e-05 1.7469004130247602e-10
+ 9.616147341835125e-05 1.881149150311095e-10
+ 9.6173680449601249e-05 1.9762660690176225e-10
+ 9.6185887480851247e-05 2.026764694324815e-10
+ 9.6198094512101246e-05 2.0297359093770258e-10
+ 9.6210301543351245e-05 1.9850103705845601e-10
+ 9.6222508574601243e-05 1.8951650785639057e-10
+ 9.6234715605851242e-05 1.7653730627935789e-10
+ 9.6246922637101241e-05 1.6031044421422816e-10
+ 9.6259129668351239e-05 1.4176958358946107e-10
+ 9.6271336699601238e-05 1.2198127662112241e-10
+ 9.628354373085125e-05 1.0208359001036545e-10
+ 9.6295750762101249e-05 8.3220638681385549e-11
+ 9.6307957793351247e-05 6.6476791169901555e-11
+ 9.631100955116374e-05 6.2738216402259133e-11
+ 9.6311314726944992e-05 6.2375524734021021e-11
+ 9.6312077666398116e-05 6.1477937832984702e-11
+ 9.6312459136124677e-05 6.1034090082773124e-11
+ 9.6312482977982595e-05 6.1006459924724939e-11
+ 9.6312487746354178e-05 6.1000935454857881e-11
+ 9.6312497283097332e-05 6.0989888077255491e-11
+ 9.6312498046036794e-05 6.0989004377034889e-11
+ 9.6312499571915691e-05 6.0987237016591268e-11
+ 9.6312499693986014e-05 6.0987095630059761e-11
+ 9.6312499938126632e-05 6.0986812858020706e-11
+ 9.6312499957657883e-05 6.0986790236316644e-11
+ 9.6312499996720387e-05 6.098674499293473e-11
+ 9.6312500074845379e-05 6.2330481534674083e-11
+ 9.6312500152970386e-05 6.6608198187672893e-11
+ 9.6312500934220383e-05 2.7075208822833839e-10
+ 9.6312508051845977e-05 1.5641542586395462e-08
+ 9.6312515169471571e-05 5.5354276368357439e-08
+ 9.6312522287097166e-05 1.1939590331347595e-07
+ 9.631252940472276e-05 2.0774988808958391e-07
+ 9.6312536522348368e-05 3.2039621340029153e-07
+ 9.6312543639973962e-05 4.5731138406416947e-07
+ 9.6312550757599556e-05 6.1846843192454422e-07
+ 9.6312557875225151e-05 8.0383692158836119e-07
+ 9.6312564992850745e-05 1.0133829569922963e-06
+ 9.6312572110476339e-05 1.2470691887940203e-06
+ 9.6312579228101933e-05 1.5048548225862434e-06
+ 9.6312587807568579e-05 1.8475543476526228e-06
+ 9.6312596387035197e-05 2.2251205386231599e-06
+ 9.6312604966501843e-05 2.637462112110794e-06
+ 9.6312613545968461e-05 3.0844806091734263e-06
+ 9.6312622125435107e-05 3.5660704276185103e-06
+ 9.6312630704901726e-05 4.0821188567621002e-06
+ 9.6312639284368371e-05 4.6325061146258863e-06
+ 9.631264786383499e-05 5.2171053875545835e-06
+ 9.6312658180770257e-05 5.965211217502911e-06
+ 9.6312668497705511e-05 6.7623492313414161e-06
+ 9.6312678814640764e-05 7.6082590651614992e-06
+ 9.6312689131576018e-05 8.5026660760363497e-06
+ 9.6312699448511272e-05 9.4452814742207388e-06
+ 9.6312709765446525e-05 1.0435802462230257e-05
+ 9.6312720082381779e-05 1.147391238070454e-05
+ 9.6312730399317046e-05 1.25592808609545e-05
+ 9.6312742902012255e-05 1.393744004677843e-05
+ 9.6312755404707478e-05 1.538385928477854e-05
+ 9.63127679074027e-05 1.6897871760843825e-05
+ 9.6312780410097922e-05 1.8478782715895571e-05
+ 9.6312792912793131e-05 2.0125869935940648e-05
+ 9.6312805415488354e-05 2.1838384260846487e-05
+ 9.6312817918183576e-05 2.3615550111329756e-05
+ 9.6312830420878799e-05 2.5456566033633845e-05
+ 9.6312845592253873e-05 2.7775100207116592e-05
+ 9.6312860763628948e-05 3.0184906039223483e-05
+ 9.6312875935004036e-05 3.2684405463249104e-05
+ 9.6312891106379111e-05 3.5271969973378807e-05
+ 9.63129062777542e-05 3.7945922288216153e-05
+ 9.6312921449129274e-05 4.0704538058428326e-05
+ 9.6312936620504349e-05 4.3546047616054653e-05
+ 9.631295486051956e-05 4.7069469432613542e-05
+ 9.6312973100534771e-05 5.0706855826657106e-05
+ 9.6312991340549982e-05 5.4454893918205257e-05
+ 9.631300958056518e-05 5.8310193146384224e-05
+ 9.6313027820580391e-05 6.2269290123695639e-05
+ 9.6313046060595602e-05 6.6328653564053143e-05
+ 9.631306819986585e-05 7.1385338233594827e-05
+ 9.6313090339136099e-05 7.6577901326810804e-05
+ 9.6313112478406347e-05 8.189969012601315e-05
+ 9.6313134617676596e-05 8.7343953274172687e-05
+ 9.631316129301132e-05 9.4056657818521804e-05
+ 9.6313187873095808e-05 0.00010090035482762358
+ 9.6313214453180296e-05 0.00010788664307091889
+ 9.631324868848434e-05 0.00011707548567577072
+ 9.6313282923788385e-05 0.00012645461865043843
+ 9.6313315356127047e-05 0.00013549167951766453
+ 9.6313347788465708e-05 0.00014465398332574899
+ 9.631338022080437e-05 0.00015391958689944246
+ 9.6313412653143045e-05 0.00016326679416820027
+ 9.6313445085481706e-05 0.00017267423453976973
+ 9.6313477517820368e-05 0.00018212093762926101
+ 9.6313509950159029e-05 0.00019158640400330904
+ 9.631354238249769e-05 0.00020105067163597072
+ 9.6313569584998142e-05 0.00020897371829601134
+ 9.6313596787498594e-05 0.00021687121736840308
+ 9.631362398999906e-05 0.0002247324443841368
+ 9.6313651192499511e-05 0.00023254704172942061
+ 9.6313678394999963e-05 0.00024030503688061725
+ 9.6313705597500415e-05 0.00024799685880477063
+ 9.6313732800000867e-05 0.00025561335251051022
+ 9.6313760002501319e-05 0.00026314579174345146
+ 9.6313787205001771e-05 0.00027058588982929906
+ 9.6313814407502236e-05 0.00027792580867665878
+ 9.6313841610002688e-05 0.0002851581659600263
+ 9.631386881250314e-05 0.00029227604051150784
+ 9.6313896015003591e-05 0.00029927297595749906
+ 9.6313923217504043e-05 0.00030614298264376868
+ 9.6313950420004495e-05 0.00031288053789913813
+ 9.6313977622504947e-05 0.00031948058469418605
+ 9.6314004825005399e-05 0.00032593852875712024
+ 9.6314032027505851e-05 0.00033225023421413059
+ 9.6314059230006316e-05 0.00033841201782615327
+ 9.6314086432506768e-05 0.0003444206418985982
+ 9.6314115300883505e-05 0.00035062659892727544
+ 9.6314144169260229e-05 0.0003566540934654631
+ 9.6314173037636967e-05 0.00036250083298786399
+ 9.6314201906013704e-05 0.00036816503744223664
+ 9.6314230774390442e-05 0.00037364542226806104
+ 9.6314259642767179e-05 0.00037894118026981165
+ 9.6314288511143903e-05 0.00038405196247931109
+ 9.6314317379520641e-05 0.000388977858140999
+ 9.6314346247897378e-05 0.00039371937395252178
+ 9.631438113516668e-05 0.0003992047348763101
+ 9.6314416022435983e-05 0.00040442447430172904
+ 9.6314449985506051e-05 0.00040925368585940502
+ 9.6314483948576119e-05 0.00041383750344981278
+ 9.6314517911646173e-05 0.00041817993390062743
+ 9.6314551874716241e-05 0.00042228549548244641
+ 9.6314585837786309e-05 0.00042615916749456922
+ 9.6314627381082822e-05 0.0004305900119691504
+ 9.6314668924379334e-05 0.00043469258490726371
+ 9.6314710467675847e-05 0.0004384781612780042
+ 9.631475201097236e-05 0.00044195857402361564
+ 9.6314802322523103e-05 0.00044578261210212054
+ 9.6314853125173641e-05 0.00044923093231022854
+ 9.6314903927824166e-05 0.00045228765276156626
+ 9.6314971607266254e-05 0.00045579239535176001
+ 9.6315039286708329e-05 0.00045870005395461338
+ 9.6315091919396562e-05 0.00046058369469111949
+ 9.6315144552084809e-05 0.00046216451732223918
+ 9.6315197184773055e-05 0.00046346681282214352
+ 9.6315249817461302e-05 0.00046451393123718372
+ 9.6315297809929104e-05 0.00046526519657479943
+ 9.6315345802396905e-05 0.00046583893527304737
+ 9.6315393794864707e-05 0.00046625041073407677
+ 9.6315441787332508e-05 0.00046651403875466578
+ 9.631548977980031e-05 0.0004666433740508164
+ 9.6315537261554868e-05 0.00046665162291553914
+ 9.6315584743309412e-05 0.000466552308242554
+ 9.6315632225063956e-05 0.00046635608374731292
+ 9.6315679706818514e-05 0.00046607281339991539
+ 9.6315727188573058e-05 0.00046571159614456351
+ 9.6315774670327616e-05 0.00046528079492301239
+ 9.6315824358583364e-05 0.00046476378468933915
+ 9.6315874046839126e-05 0.00046418694952370777
+ 9.6315923735094874e-05 0.00046355752837163748
+ 9.6315973423350635e-05 0.00046288205221083837
+ 9.6316023111606396e-05 0.00046216639229460844
+ 9.6316072799862144e-05 0.00046141580830294233
+ 9.6316127951386076e-05 0.00046054748419045071
+ 9.6316183102910008e-05 0.00045964758393211987
+ 9.6316238254433927e-05 0.00045872107390199996
+ 9.6316293405957859e-05 0.00045777228079549998
+ 9.6316348557481778e-05 0.00045680495887963081
+ 9.6316411640520543e-05 0.000455679953428722
+ 9.6316474723559295e-05 0.00045453907391423655
+ 9.6316537806598061e-05 0.0004533857886546739
+ 9.6316600889636813e-05 0.00045222299034028662
+ 9.631667414014642e-05 0.00045086399130210022
+ 9.6316747390656041e-05 0.00044949844535668453
+ 9.6316820641165649e-05 0.00044812878579885432
+ 9.6316905619421581e-05 0.00044653719761490697
+ 9.6316990597677526e-05 0.0004449449586312652
+ 9.6317093836844781e-05 0.00044301214871122791
+ 9.631719817176942e-05 0.00044106269601017851
+ 9.6317302506694044e-05 0.00043911870626636078
+ 9.631742666446917e-05 0.00043681393387383496
+ 9.6317550822244281e-05 0.00043451951813961668
+ 9.6317705800806532e-05 0.00043167106196547318
+ 9.6317884937131785e-05 0.00042840086834201771
+ 9.6318098556602395e-05 0.00042453293757745131
+ 9.6318364485722957e-05 0.00041976628303681877
+ 9.6318717982712206e-05 0.00041351261779238365
+ 9.6319242097564148e-05 0.00040441158298440465
+ 9.6320136340120481e-05 0.00038934346113524376
+ 9.6322132807185039e-05 0.00035769765454050228
+ 9.6323988816858017e-05 0.00033058981538904275
+ 9.6326421668443081e-05 0.00029814348467284587
+ 9.6328854520028146e-05 0.00026888165874455468
+ 9.633128737161321e-05 0.00024249178888257299
+ 9.6333720223198274e-05 0.00021869200206866874
+ 9.6336153074783339e-05 0.00019722808975099272
+ 9.6338585926368403e-05 0.00017787079297825666
+ 9.6341018777953467e-05 0.00016041335425741158
+ 9.6343451629538532e-05 0.0001446693086575522
+ 9.6345767705239779e-05 0.00013111903917235234
+ 9.6348819440406717e-05 0.00011518312547724692
+ 9.6351871175573656e-05 0.00010118403045864018
+ 9.6354922910740594e-05 8.8886357108097517e-05
+ 9.6357974645907532e-05 7.8083318131395906e-05
+ 9.636102638107447e-05 6.8593258842393536e-05
+ 9.6364078116241409e-05 6.025660181923537e-05
+ 9.6367773618773596e-05 5.1505809187250614e-05
+ 9.6371134288610914e-05 4.4656271026532631e-05
+ 9.6374494958448219e-05 3.8717628008379948e-05
+ 9.6378620731690283e-05 3.2495702272495222e-05
+ 9.6382746504932332e-05 2.7273646663031209e-05
+ 9.6386872278174396e-05 2.2890780980831938e-05
+ 9.6390998051416459e-05 1.9212246512347876e-05
+ 9.6395123824658522e-05 1.6124856494297113e-05
+ 9.6400251138437098e-05 1.2970141364146993e-05
+ 9.6405378452215675e-05 1.0432633172092827e-05
+ 9.6410505765994264e-05 8.3915781182774641e-06
+ 9.6415633079772841e-05 6.7498471833962207e-06
+ 9.6421995979825147e-05 5.1518189724579756e-06
+ 9.6428358879877468e-05 3.9321378049054371e-06
+ 9.6434721779929775e-05 3.0012267671564931e-06
+ 9.6442497256254506e-05 2.15737185496337e-06
+ 9.645027273257925e-05 1.5508026051292012e-06
+ 9.6458048208903995e-05 1.1147960586695601e-06
+ 9.6467983441936064e-05 7.3118840550782522e-07
+ 9.6477918674968147e-05 4.7961075194826108e-07
+ 9.6490125706218146e-05 2.8571159964289929e-07
+ 9.6502332737468145e-05 1.7024209705967684e-07
+ 9.6514539768718143e-05 1.0147848625806179e-07
+ 9.6526746799968142e-05 6.0528851952355526e-08
+ 9.6538953831218141e-05 3.6142806128821739e-08
+ 9.6551160862468139e-05 2.1620593980565466e-08
+ 9.6563367893718138e-05 1.2972424953734794e-08
+ 9.6575574924968137e-05 7.8223266739669589e-09
+ 9.6587781956218149e-05 4.7553755500354248e-09
+ 9.6599988987468148e-05 2.9289656540459339e-09
+ 9.6612196018718146e-05 1.8413143839828223e-09
+ 9.6624403049968145e-05 1.1936037658401295e-09
+ 9.6636610081218143e-05 8.078836241498485e-10
+ 9.6648817112468142e-05 5.7818218790680653e-10
+ 9.6661024143718141e-05 4.4139192644487092e-10
+ 9.6673231174968139e-05 3.5993152647751398e-10
+ 9.6685438206218138e-05 3.1142080027758294e-10
+ 9.6697645237468137e-05 2.8253202431124535e-10
+ 9.6709852268718135e-05 2.653283707170538e-10
+ 9.6722059299968148e-05 2.5508336753526945e-10
+ 9.6734266331218146e-05 2.4898233649178344e-10
+ 9.6746473362468145e-05 2.4534909287155193e-10
+ 9.6758680393718144e-05 2.4318544696123555e-10
+ 9.6770887424968142e-05 2.4189696683490067e-10
+ 9.6783094456218141e-05 2.411296605642883e-10
+ 9.679530148746814e-05 2.406727199550333e-10
+ 9.6807508518718138e-05 2.4040060549918595e-10
+ 9.6819715549968137e-05 2.4023855751768804e-10
+ 9.6831922581218136e-05 2.4014205601586099e-10
+ 9.6844129612468148e-05 2.4008458822552009e-10
+ 9.6856336643718146e-05 2.4005036536744095e-10
+ 9.6868543674968145e-05 2.4002998505548136e-10
+ 9.6880750706218144e-05 2.4001784836154639e-10
+ 9.6892957737468142e-05 2.4001062082534474e-10
+ 9.6905164768718141e-05 2.4000631674323626e-10
+ 9.691737179996814e-05 2.4000375361391963e-10
+ 9.6929578831218138e-05 2.4000222718017004e-10
+ 9.6941785862468137e-05 2.4000131819356677e-10
+ 9.6953992893718136e-05 2.4000077702242996e-10
+ 9.6966199924968134e-05 2.4000045459933931e-10
+ 9.6978406956218147e-05 2.4000026257884156e-10
+ 9.6990613987468145e-05 2.4000014832025053e-10
+ 9.7002821018718144e-05 2.4000008023582484e-10
+ 9.7015028049968142e-05 2.4000003966625581e-10
+ 9.7027235081218141e-05 2.400000155533385e-10
+ 9.703944211246814e-05 2.4000000121814107e-10
+ 9.7051649143718138e-05 2.3999999261673205e-10
+ 9.7063856174968137e-05 2.3999998758456908e-10
+ 9.7076063206218136e-05 2.3999998453222656e-10
+ 9.7088270237468134e-05 2.3999998265390494e-10
+ 9.7100477268718147e-05 2.3999998161732485e-10
+ 9.7112684299968145e-05 2.3999998104358188e-10
+ 9.7124891331218144e-05 2.3999998057389865e-10
+ 9.7137098362468143e-05 2.3999998026292464e-10
+ 9.7149305393718141e-05 2.3999998019001177e-10
+ 9.716151242496814e-05 2.3999998019899801e-10
+ 9.7173719456218139e-05 2.3999998020597388e-10
+ 9.7185926487468137e-05 2.3999998012855701e-10
+ 9.7198133518718136e-05 2.3999998005534517e-10
+ 9.7210340549968135e-05 2.3999998008389102e-10
+ 9.7222547581218133e-05 2.3999998009224399e-10
+ 9.7234754612468145e-05 2.3999998012219294e-10
+ 9.7246961643718144e-05 2.3999998013282356e-10
+ 9.7259168674968143e-05 2.3999998009115475e-10
+ 9.7271375706218141e-05 2.3999998009706464e-10
+ 9.728358273746814e-05 2.3999998010363494e-10
+ 9.7295789768718139e-05 2.3999998011314167e-10
+ 9.7307996799968137e-05 2.3999998013616955e-10
+ 9.7320203831218136e-05 2.3999998011363462e-10
+ 9.7332410862468135e-05 2.3999998009274014e-10
+ 9.7344617893718133e-05 2.399999801011231e-10
+ 9.7356824924968132e-05 2.399999800977465e-10
+ 9.7369031956218144e-05 2.3999998010717031e-10
+ 9.7381238987468143e-05 2.3999998026497155e-10
+ 9.7393446018718141e-05 2.3999998018940695e-10
+ 9.740565304996814e-05 2.399999801489314e-10
+ 9.7417860081218139e-05 2.3999998016252337e-10
+ 9.7430067112468137e-05 2.3999998017736873e-10
+ 9.7442274143718136e-05 2.3999998008841631e-10
+ 9.7454481174968135e-05 2.399999801406156e-10
+ 9.7466688206218133e-05 2.3999998027111368e-10
+ 9.7478895237468132e-05 2.399999803096209e-10
+ 9.7491102268718131e-05 2.399999801745041e-10
+ 9.7503309299968143e-05 2.3999998014351678e-10
+ 9.7515516331218142e-05 2.399999802735929e-10
+ 9.752772336246814e-05 2.3999998026179471e-10
+ 9.7539930393718139e-05 2.3999998016976751e-10
+ 9.7552137424968138e-05 2.3999998022820648e-10
+ 9.7564344456218136e-05 2.3999998018386391e-10
+ 9.7576551487468135e-05 2.3999998024457121e-10
+ 9.7588758518718133e-05 2.399999802712344e-10
+ 9.7600965549968132e-05 2.3999998016906244e-10
+ 9.7613172581218144e-05 2.399999802251944e-10
+ 9.7625379612468143e-05 2.3999998029674961e-10
+ 9.7637586643718142e-05 2.3999998024490881e-10
+ 9.764979367496814e-05 2.3999998022841694e-10
+ 9.7662000706218139e-05 2.3999998027402318e-10
+ 9.7674207737468138e-05 2.3999998031284179e-10
+ 9.7686414768718136e-05 2.3999998024592236e-10
+ 9.7698621799968135e-05 2.3999998028900653e-10
+ 9.7710828831218147e-05 2.3999998029018118e-10
+ 9.7723035862468146e-05 2.3999998020407995e-10
+ 9.7735242893718144e-05 2.3999998030027903e-10
+ 9.7747449924968143e-05 2.3999998034659856e-10
+ 9.7759656956218142e-05 2.3999998035710371e-10
+ 9.777186398746814e-05 2.3999998035781327e-10
+ 9.7784071018718139e-05 2.3999998028429372e-10
+ 9.7796278049968138e-05 2.3999998026462584e-10
+ 9.780848508121815e-05 2.3999998034401652e-10
+ 9.7820692112468149e-05 2.3999998040748526e-10
+ 9.7832899143718147e-05 2.399999802904164e-10
+ 9.7845106174968146e-05 2.3999998026488739e-10
+ 9.7857313206218145e-05 2.399999803948264e-10
+ 9.7869520237468143e-05 2.399999803901337e-10
+ 9.7881727268718142e-05 2.3999998030809217e-10
+ 9.7893934299968141e-05 2.3999998036169063e-10
+ 9.7906141331218153e-05 2.3999998033495331e-10
+ 9.7918348362468151e-05 2.3999998039429674e-10
+ 9.793055539371815e-05 2.3999998043834603e-10
+ 9.7942762424968149e-05 2.3999998042747548e-10
+ 9.7954969456218147e-05 2.3999998033813589e-10
+ 9.7967176487468146e-05 2.3999998042749197e-10
+ 9.7979383518718145e-05 2.3999998045576412e-10
+ 9.7991590549968143e-05 2.3999998040668088e-10
+ 9.8003797581218156e-05 2.3999998041015307e-10
+ 9.8016004612468154e-05 2.3999998038280188e-10
+ 9.8028211643718153e-05 2.399999804963409e-10
+ 9.8040418674968152e-05 2.3999998050724164e-10
+ 9.805262570621815e-05 2.3999998043757132e-10
+ 9.8064832737468149e-05 2.3999998042873677e-10
+ 9.8077039768718147e-05 2.3999998048062938e-10
+ 9.8089246799968146e-05 2.3999998046244087e-10
+ 9.8101453831218158e-05 2.3999998047367506e-10
+ 9.8113660862468157e-05 2.3999998045481209e-10
+ 9.8125867893718156e-05 2.3999998043752122e-10
+ 9.8138074924968154e-05 2.3999998042446345e-10
+ 9.8150281956218153e-05 2.3999998041722252e-10
+ 9.8162488987468152e-05 2.3999998041674074e-10
+ 9.817469601871815e-05 2.3999998042357827e-10
+ 9.8186903049968149e-05 2.3999998043806778e-10
+ 9.8199110081218161e-05 2.3999998047660411e-10
+ 9.821131711246816e-05 2.3999998051655456e-10
+ 9.8223524143718158e-05 2.3999998052591767e-10
+ 9.8235731174968157e-05 2.3999998048427911e-10
+ 9.8247938206218156e-05 2.3999998054712477e-10
+ 9.8260145237468154e-05 2.3999998057013456e-10
+ 9.8272352268718153e-05 2.3999998051176627e-10
+ 9.8284559299968152e-05 2.3999998057450993e-10
+ 9.8296766331218164e-05 2.3999998053652084e-10
+ 9.8308973362468163e-05 2.3999998056705243e-10
+ 9.8321180393718161e-05 2.399999805326457e-10
+ 9.833338742496816e-05 2.399999805718764e-10
+ 9.8345594456218159e-05 2.3999998054921403e-10
+ 9.8357801487468157e-05 2.3999998061819825e-10
+ 9.8370008518718156e-05 2.399999805688973e-10
+ 9.8382215549968155e-05 2.3999998054792621e-10
+ 9.8394422581218167e-05 2.39999980627754e-10
+ 9.8406629612468165e-05 2.3999998059474422e-10
+ 9.8418836643718164e-05 2.399999805933057e-10
+ 9.8431043674968163e-05 2.3999998057922352e-10
+ 9.8443250706218161e-05 2.3999998056088616e-10
+ 9.845545773746816e-05 2.3999998058786213e-10
+ 9.8467664768718159e-05 2.399999806005213e-10
+ 9.8479871799968157e-05 2.3999998060792622e-10
+ 9.849207883121817e-05 2.3999998061547279e-10
+ 9.8504285862468168e-05 2.3999998062637359e-10
+ 9.8516492893718167e-05 2.3999998064254068e-10
+ 9.8528699924968166e-05 2.399999806651119e-10
+ 9.8540906956218164e-05 2.3999998065019003e-10
+ 9.8553113987468163e-05 2.3999998066078063e-10
+ 9.8565321018718161e-05 2.399999807158811e-10
+ 9.857752804996816e-05 2.3999998065933043e-10
+ 9.8589735081218172e-05 2.3999998069949765e-10
+ 9.8601942112468171e-05 2.3999998071137632e-10
+ 9.861414914371817e-05 2.3999998066492584e-10
+ 9.8626356174968168e-05 2.3999998067631891e-10
+ 9.8638563206218167e-05 2.3999998068067386e-10
+ 9.8650770237468166e-05 2.3999998072884115e-10
+ 9.8662977268718164e-05 2.3999998071703879e-10
+ 9.8675184299968163e-05 2.399999807620995e-10
+ 9.8687391331218175e-05 2.3999998071038665e-10
+ 9.8699598362468174e-05 2.3999998068359319e-10
+ 9.8711805393718172e-05 2.3999998073934671e-10
+ 9.8724012424968171e-05 2.3999998074833904e-10
+ 9.873621945621817e-05 2.3999998072288318e-10
+ 9.8748426487468168e-05 2.3999998078919143e-10
+ 9.8760633518718167e-05 2.3999998076965073e-10
+ 9.8772840549968166e-05 2.399999807468099e-10
+ 9.8785047581218178e-05 2.3999998076982682e-10
+ 9.8797254612468177e-05 2.3999998077882701e-10
+ 9.8809461643718175e-05 2.3999998078272732e-10
+ 9.8821668674968174e-05 2.3999998077698307e-10
+ 9.8833875706218173e-05 2.3999998078844893e-10
+ 9.8846082737468171e-05 2.3999998080355428e-10
+ 9.885828976871817e-05 2.3999998082407074e-10
+ 9.8870496799968169e-05 2.3999998085105249e-10
+ 9.8882703831218181e-05 2.3999998076975625e-10
+ 9.8894910862468179e-05 2.399999808033618e-10
+ 9.8907117893718178e-05 2.3999998080328762e-10
+ 9.8919324924968177e-05 2.3999998084082399e-10
+ 9.8931531956218175e-05 2.3999998077877215e-10
+ 9.8943738987468174e-05 2.3999998083679345e-10
+ 9.8955946018718173e-05 2.3999998087406507e-10
+ 9.8968153049968171e-05 2.3999998083776306e-10
+ 9.8980360081218184e-05 2.3999998086990843e-10
+ 9.8992567112468182e-05 2.3999998083702247e-10
+ 9.9004774143718181e-05 2.399999808776692e-10
+ 9.9016981174968179e-05 2.3999998085631119e-10
+ 9.9029188206218178e-05 2.3999998083949021e-10
+ 9.9041395237468177e-05 2.3999929577393646e-10
+ 9.9053602268718175e-05 2.3999721430085655e-10
+ 9.9065809299968174e-05 2.3999541801853927e-10
+ 9.9078016331218186e-05 2.3999352441667849e-10
+ 9.9090223362468185e-05 2.3998998231508299e-10
+ 9.9102430393718184e-05 2.3998269751518182e-10
+ 9.9114637424968182e-05 2.3996731785187146e-10
+ 9.9120740940593182e-05 2.3994983464395233e-10
+ 9.9126844456218181e-05 2.3990674100743305e-10
+ 9.9129896214030687e-05 2.3985615585153402e-10
+ 9.913294797184318e-05 2.3973456609508262e-10
+ 9.9134473850749427e-05 2.3959023649420816e-10
+ 9.9135999729655687e-05 2.3924487360909957e-10
+ 9.913699110688918e-05 2.3866252493064795e-10
+ 9.9137269733896239e-05 2.3836567845599657e-10
+ 9.9137548360903299e-05 2.3795958755937176e-10
+ 9.9138098835627967e-05 2.3707317678626589e-10
+ 9.9140875273912433e-05 2.3289947932096134e-10
+ 9.9153082305162432e-05 2.1857108082062022e-10
+ 9.9165289336412431e-05 2.0744394567167327e-10
+ 9.9177496367662443e-05 1.9657101424192844e-10
+ 9.9189703398912442e-05 1.8444183633608339e-10
+ 9.920191043016244e-05 1.7048236032410772e-10
+ 9.9214117461412439e-05 1.5473832156939622e-10
+ 9.9226324492662438e-05 1.376643966131987e-10
+ 9.9238531523912436e-05 1.1997405552563603e-10
+ 9.9250738555162435e-05 1.0252468847149855e-10
+ 9.9262945586412447e-05 8.622433036431135e-11
+ 9.9275152617662446e-05 7.1953269034585456e-11
+ 9.9287359648912444e-05 6.0497851486217764e-11
+ 9.9299566680162443e-05 5.2496010132610782e-11
+ 9.9311773711412442e-05 4.8395088933560857e-11
+ 9.932398074266244e-05 4.8422873289603413e-11
+ 9.9336187773912439e-05 5.2572582289997926e-11
+ 9.9348394805162438e-05 6.0602144636946106e-11
+ 9.9360601836412436e-05 7.2047475992215135e-11
+ 9.9372808867662448e-05 8.6248800170538565e-11
+ 9.9385015898912447e-05 1.0238838404643464e-10
+ 9.9397222930162446e-05 1.19537446121802e-10
+ 9.9409429961412444e-05 1.367094991032434e-10
+ 9.9421636992662443e-05 1.5291703382970249e-10
+ 9.9433844023912442e-05 1.6722827017382802e-10
+ 9.9436895781724948e-05 1.7041028620342427e-10
+ 9.9437048369615567e-05 1.7056469761267313e-10
+ 9.9437429839342129e-05 1.7094872387604414e-10
+ 9.9437467986314784e-05 1.7098696858623529e-10
+ 9.9437475615709323e-05 1.7099461407315297e-10
+ 9.9437490874498388e-05 1.7100990159048815e-10
+ 9.9437496978014003e-05 1.7101601530675094e-10
+ 9.9437499419420265e-05 1.7101846058671687e-10
+ 9.9437499604455791e-05 1.7101864591102341e-10
+ 9.9437499974526844e-05 1.710190165576025e-10
+ 9.943750071466895e-05 2.9362295535076986e-10
+ 9.9437501454811055e-05 6.7955376462053112e-10
+ 9.9437508856232152e-05 1.9019685483973129e-08
+ 9.9437516257653235e-05 6.3680162617685321e-08
+ 9.9437523659074331e-05 1.3464578979540883e-07
+ 9.9437531060495414e-05 2.3189729697639808e-07
+ 9.9437538461916511e-05 3.5541134357275011e-07
+ 9.9437547512355688e-05 5.4209487018455778e-07
+ 9.9437556562794865e-05 7.6794744751962639e-07
+ 9.9437565613234055e-05 1.032901665904789e-06
+ 9.9437574663673232e-05 1.3368810846168448e-06
+ 9.9437583714112409e-05 1.6798002590529673e-06
+ 9.9437595044533507e-05 2.1638522289015684e-06
+ 9.9437606374954606e-05 2.7085809274094572e-06
+ 9.9437617705375704e-05 3.3137595140903088e-06
+ 9.9437629035796802e-05 3.9791394372703589e-06
+ 9.9437643214653364e-05 4.8961848891924115e-06
+ 9.9437657393509912e-05 5.9065041934527361e-06
+ 9.9437671572366474e-05 7.0094688242501652e-06
+ 9.9437689032396938e-05 8.4939484121898285e-06
+ 9.9437706492427403e-05 1.011650368403691e-05
+ 9.9437723952457868e-05 1.187564441966631e-05
+ 9.943774626847783e-05 1.4320324258348367e-05
+ 9.9437768584497807e-05 1.6981891243476683e-05
+ 9.943779090051777e-05 1.9856448881756975e-05
+ 9.9437819090217246e-05 2.3785542948120637e-05
+ 9.9437847279916709e-05 2.8038794641957824e-05
+ 9.9437875469616185e-05 3.2606525910010655e-05
+ 9.9437903659315647e-05 3.7478440563006991e-05
+ 9.9437931849015123e-05 4.2643660624918842e-05
+ 9.9437960038714586e-05 4.809076449946518e-05
+ 9.9437988228414062e-05 5.3807826764352856e-05
+ 9.9438019414106477e-05 6.0432058501488789e-05
+ 9.9438050599798879e-05 6.7354141141263776e-05
+ 9.9438081785491295e-05 7.4556149339010216e-05
+ 9.943811297118371e-05 8.2019674226669682e-05
+ 9.9438150418414343e-05 9.1300740447793598e-05
+ 9.9438187865644962e-05 0.00010089852928503813
+ 9.9438225312875595e-05 0.00011077933330704341
+ 9.9438270844195805e-05 0.00012312530862772575
+ 9.9438316375516028e-05 0.00013577798574481139
+ 9.9438361906836238e-05 0.00014867616552750304
+ 9.9438407438156448e-05 0.00016175929991125412
+ 9.9438441084028113e-05 0.00017151113091571656
+ 9.9438474729899779e-05 0.00018130797963939794
+ 9.9438508375771444e-05 0.00019112690048319055
+ 9.943854202164311e-05 0.000200945563836072
+ 9.9438575667514775e-05 0.0002107423308290232
+ 9.9438609313386441e-05 0.00022049632214156449
+ 9.9438642959258106e-05 0.00023018748061678874
+ 9.9438676605129772e-05 0.00023979662749408118
+ 9.9438710251001437e-05 0.0002493055121224335
+ 9.9438736870668154e-05 0.00025674620625396695
+ 9.9438763490334857e-05 0.00026410519322842072
+ 9.9438790110001574e-05 0.00027137476557784006
+ 9.9438816729668277e-05 0.00027854762813939171
+ 9.9438843349334993e-05 0.00028561690431054267
+ 9.9438869969001697e-05 0.0002925761407342706
+ 9.9438896588668413e-05 0.0002994193104460534
+ 9.9438923208335116e-05 0.00030614081452042582
+ 9.9438949828001833e-05 0.00031273548226053464
+ 9.943897644766855e-05 0.00031919856997935221
+ 9.9439003067335253e-05 0.00032552575842600295
+ 9.9439029687001969e-05 0.00033171314891500655
+ 9.9439056306668673e-05 0.00033775725822013397
+ 9.9439082926335389e-05 0.00034365501229800138
+ 9.9439109546002092e-05 0.00034940373890948994
+ 9.9439136165668809e-05 0.00035500115920957621
+ 9.9439162785335526e-05 0.00036044537837818884
+ 9.9439189405002229e-05 0.00036573487536628151
+ 9.9439216024668946e-05 0.00037086849183281574
+ 9.9439239404935229e-05 0.00037524816041470616
+ 9.9439262785201512e-05 0.00037950661982143294
+ 9.9439286165467809e-05 0.00038364373347733212
+ 9.9439309545734092e-05 0.00038765955240256639
+ 9.9439332926000388e-05 0.00039155430797307712
+ 9.9439356306266671e-05 0.00039532840450424615
+ 9.9439379686532955e-05 0.00039898241168751826
+ 9.9439403066799251e-05 0.00040251705690861332
+ 9.9439426447065534e-05 0.00040593321747524688
+ 9.9439449827331817e-05 0.0004092319127814815
+ 9.9439473207598114e-05 0.00041241429643495774
+ 9.9439496587864397e-05 0.00041548164837231091
+ 9.9439519968130694e-05 0.00041843536698707185
+ 9.9439543348396977e-05 0.00042127696129328835
+ 9.943956672866326e-05 0.00042400804314699181
+ 9.9439590108929557e-05 0.00042663031954648096
+ 9.943961348919584e-05 0.00042914558503120656
+ 9.9439636869462123e-05 0.00043155571419782471
+ 9.943966024972842e-05 0.00043386265435075173
+ 9.9439683629994703e-05 0.0004360684183033
+ 9.9439707010261e-05 0.00043817507734421687
+ 9.943973559123752e-05 0.00044061881915944171
+ 9.9439764172214041e-05 0.00044292160557832261
+ 9.9439792753190561e-05 0.00044508748731897325
+ 9.9439821334167095e-05 0.0004471205811035718
+ 9.9439849915143616e-05 0.00044902505354874717
+ 9.9439886199806214e-05 0.00045126415767136695
+ 9.943992545337338e-05 0.00045347065125915753
+ 9.9439946977215266e-05 0.00045458914938144757
+ 9.9439973696714695e-05 0.00045589098737442259
+ 9.9440000416214138e-05 0.00045710004038524538
+ 9.9440027135713568e-05 0.00045821970861944291
+ 9.944005385521301e-05 0.00045925335947318648
+ 9.944008057471244e-05 0.00046020432082601948
+ 9.9440107294211883e-05 0.00046107587487371744
+ 9.9440134013711312e-05 0.00046187125249194449
+ 9.9440160733210755e-05 0.00046259362811953432
+ 9.9440187452710184e-05 0.00046324611514856153
+ 9.9440214172209627e-05 0.00046383176180687778
+ 9.9440240891709056e-05 0.00046435354751746608
+ 9.9440262548859616e-05 0.00046473161709406521
+ 9.9440284206010163e-05 0.00046507115570231151
+ 9.944030586316071e-05 0.00046537364255429416
+ 9.944032752031127e-05 0.00046564052306956875
+ 9.9440349177461817e-05 0.00046587320827894959
+ 9.9440370834612377e-05 0.00046607307433484731
+ 9.9440392491762923e-05 0.00046624146212347479
+ 9.944041414891347e-05 0.00046637967697419719
+ 9.944043580606403e-05 0.00046648898846127722
+ 9.9440457463214577e-05 0.00046657063029325929
+ 9.9440479120365137e-05 0.0004666258002852115
+ 9.9440496765399605e-05 0.00046665198683365781
+ 9.9440514410434073e-05 0.00046666198405394353
+ 9.9440532055468554e-05 0.00046665638716889121
+ 9.9440549700503022e-05 0.00046663577581361698
+ 9.9440567345537503e-05 0.00046660071413966874
+ 9.9440584990571971e-05 0.00046655175093608377
+ 9.9440602635606453e-05 0.00046648941976632619
+ 9.9440620280640921e-05 0.00046641423912008399
+ 9.9440637925675388e-05 0.00046632671257892689
+ 9.944065557070987e-05 0.00046622732899484812
+ 9.9440673215744338e-05 0.00046611656268073646
+ 9.9440690860778819e-05 0.00046599487361184948
+ 9.9440708505813287e-05 0.00046586270763738396
+ 9.9440726150847768e-05 0.00046572049670126538
+ 9.9440743795882236e-05 0.00046556865907130521
+ 9.9440761440916704e-05 0.00046540759957590188
+ 9.9440779085951185e-05 0.00046523770984748908
+ 9.9440796730985653e-05 0.00046505936857196291
+ 9.9440814376020135e-05 0.00046487294174334804
+ 9.9440832021054602e-05 0.00046467878292299136
+ 9.9440849666089084e-05 0.00046447723350260048
+ 9.9440867311123552e-05 0.00046426862297047311
+ 9.9440884956158033e-05 0.00046405326918029163
+ 9.9440902601192501e-05 0.00046383147862188659
+ 9.9440920246226969e-05 0.0004636035466933999
+ 9.944093789126145e-05 0.00046336975797430831
+ 9.9440955536295918e-05 0.00046313038649879376
+ 9.9440973181330399e-05 0.00046288569602897633
+ 9.9440990826364867e-05 0.00046263594032755121
+ 9.9441008471399348e-05 0.00046238136342939871
+ 9.9441026116433816e-05 0.00046212219991176166
+ 9.9441043761468298e-05 0.00046185867516261082
+ 9.9441061406502766e-05 0.00046159100564684353
+ 9.9441079051537233e-05 0.00046131939916998468
+ 9.9441096696571715e-05 0.00046104405513908457
+ 9.9441114341606183e-05 0.00046076516482052872
+ 9.9441131986640664e-05 0.00046048291159450004
+ 9.9441149631675132e-05 0.00046019747120585279
+ 9.9441167276709613e-05 0.00045990901201118061
+ 9.9441184921744081e-05 0.00045961769522188066
+ 9.9441202566778549e-05 0.00045932367514303494
+ 9.944122021181303e-05 0.00045902709940794936
+ 9.9441237856847498e-05 0.00045872810920820898
+ 9.944125550188198e-05 0.00045842683951912496
+ 9.9441273146916447e-05 0.00045812341932046545
+ 9.9441290791950929e-05 0.00045781797181237863
+ 9.9441308436985397e-05 0.00045751061462643097
+ 9.9441326082019864e-05 0.00045720146003169808
+ 9.9441343727054346e-05 0.00045689061513585962
+ 9.9441361372088814e-05 0.00045657818208126165
+ 9.9441379017123295e-05 0.00045626425823592343
+ 9.9441396662157763e-05 0.0004559489363794755
+ 9.9441414307192244e-05 0.0004556323048840281
+ 9.9441431952226712e-05 0.00045531444788997848
+ 9.9441449597261194e-05 0.00045499544547677518
+ 9.9441467242295661e-05 0.00045467537382866608
+ 9.9441484887330129e-05 0.00045435430539546583
+ 9.9441502532364611e-05 0.00045403230904838535
+ 9.9441520177399078e-05 0.00045370945023097327
+ 9.944153782243356e-05 0.00045338579110522598
+ 9.9441555467468028e-05 0.00045306139069292836
+ 9.9441573112502509e-05 0.00045273630501229328
+ 9.9441590757536977e-05 0.00045241058720997258
+ 9.9441608402571458e-05 0.00045208428768851668
+ 9.9441626047605926e-05 0.00045175745422936376
+ 9.9441643692640394e-05 0.00045143013211144381
+ 9.9441661337674875e-05 0.00045110236422548483
+ 9.9441682620107574e-05 0.00045070649383213837
+ 9.9441702745281684e-05 0.00045033166770387813
+ 9.944172287045578e-05 0.00044995642757493547
+ 9.9441742995629891e-05 0.00044958082330929242
+ 9.9441763120803987e-05 0.00044920490166811688
+ 9.9441783245978084e-05 0.00044882870648050557
+ 9.9441803371152194e-05 0.00044845227880637947
+ 9.9441823496326291e-05 0.00044807565709178331
+ 9.9441843621500401e-05 0.00044769887731683952
+ 9.9441863746674498e-05 0.00044732197313660687
+ 9.944188811074613e-05 0.00044686556133260454
+ 9.9441912474817749e-05 0.00044640906499999366
+ 9.9441936838889382e-05 0.00044595253182312878
+ 9.9441961202961015e-05 0.00044549600565976083
+ 9.9441985567032634e-05 0.00044503952681690417
+ 9.9442009931104266e-05 0.00044458313230938829
+ 9.9442034295175899e-05 0.00044412685610195336
+ 9.9442058659247518e-05 0.00044367072933572632
+ 9.944208302331915e-05 0.00044321478053989036
+ 9.9442107387390769e-05 0.00044275903582933563
+ 9.9442136719683576e-05 0.00044221066197735565
+ 9.9442166051976369e-05 0.00044166265618977781
+ 9.9442195384269162e-05 0.00044111505229614979
+ 9.9442224716561956e-05 0.000440567880571222
+ 9.9442254048854749e-05 0.0004400211680723513
+ 9.9442283381147542e-05 0.0004394749389480193
+ 9.9442312713440335e-05 0.0004389292147195882
+ 9.9442342045733128e-05 0.00043838401453830063
+ 9.9442377848029192e-05 0.00043771929099924211
+ 9.9442412335454627e-05 0.00043707976746529866
+ 9.9442446822880061e-05 0.00043644103787377733
+ 9.9442481310305496e-05 0.00043580312030283216
+ 9.944251579773093e-05 0.00043516603032572377
+ 9.9442557828321215e-05 0.00043439073279079223
+ 9.9442599858911486e-05 0.00043361670459320404
+ 9.9442641889501771e-05 0.00043284396248195208
+ 9.9442683920092042e-05 0.00043207252012209858
+ 9.9442725950682327e-05 0.00043130238856505936
+ 9.9442777518503426e-05 0.00043035930871672526
+ 9.9442828186666477e-05 0.00042943462880424378
+ 9.9442878854829543e-05 0.00042851188736760037
+ 9.9442929522992594e-05 0.00042759109050169295
+ 9.9442993215143459e-05 0.00042643637215815307
+ 9.9443056907294323e-05 0.0004252847370223043
+ 9.9443120599445188e-05 0.00042413618616643506
+ 9.9443198945610721e-05 0.00042272760989246018
+ 9.9443278657649692e-05 0.00042129925771114857
+ 9.9443358369688664e-05 0.00041987571829712041
+ 9.944346129237076e-05 0.00041804477075287836
+ 9.9443569508909815e-05 0.00041612824858809757
+ 9.944370191480444e-05 0.00041379527174881443
+ 9.9443847065030182e-05 0.00041125276249577136
+ 9.944403431523569e-05 0.00040799587225246868
+ 9.9444255865010432e-05 0.00040417569543334638
+ 9.9444554034092508e-05 0.00039909077578923559
+ 9.9444998769870891e-05 0.00039162496079868337
+ 9.9445805003989e-05 0.00037844492463713218
+ 9.944671176436832e-05 0.00036415075183872955
+ 9.9447737475686447e-05 0.00034863113834200367
+ 9.9448801143402338e-05 0.00033323544260725887
+ 9.9449944764949544e-05 0.00031744009309453978
+ 9.945223164627891e-05 0.00028806442739914481
+ 9.9454182681216657e-05 0.00026516169925578173
+ 9.9456291228517245e-05 0.00024245284579639417
+ 9.9458581467436167e-05 0.00021998507757767748
+ 9.9460926666850025e-05 0.00019913410083615226
+ 9.9463271866263883e-05 0.00018025945489984468
+ 9.9465590537179633e-05 0.00016335772611693962
+ 9.9468474569484286e-05 0.00014452917890563918
+ 9.9471358601788926e-05 0.00012787080313841811
+ 9.9474242634093579e-05 0.00011313246567173927
+ 9.9477126666398233e-05 0.00010009286360866482
+ 9.9480010698702872e-05 8.8556201336288662e-05
+ 9.9482894731007526e-05 7.8349250567829904e-05
+ 9.9485778763312179e-05 6.9318749243295542e-05
+ 9.9489342797663596e-05 5.9583601550415324e-05
+ 9.9492906832015013e-05 5.12156620124964e-05
+ 9.949647086636643e-05 4.4022919356413453e-05
+ 9.9500034900717847e-05 3.7840328450154061e-05
+ 9.9503598935069278e-05 3.2526023165760874e-05
+ 9.9507899961127357e-05 2.7096692323683933e-05
+ 9.951220098718545e-05 2.2573641128908005e-05
+ 9.9516502013243544e-05 1.8805590756409222e-05
+ 9.9520803039301623e-05 1.5666514280396347e-05
+ 9.9525104065359716e-05 1.3051421554109079e-05
+ 9.953050250598698e-05 1.0377818664489998e-05
+ 9.9535900946614257e-05 8.251909089995107e-06
+ 9.9541299387241521e-05 6.5614966739560858e-06
+ 9.9546697827868785e-05 5.2173688876777125e-06
+ 9.9553468247657472e-05 3.9138135354349389e-06
+ 9.956023866744616e-05 2.9359531577328348e-06
+ 9.9567009087234848e-05 2.2024124497970242e-06
+ 9.9575385304343953e-05 1.5432541258101081e-06
+ 9.9583761521453073e-05 1.081378721967762e-06
+ 9.9592137738562178e-05 7.5774041132707628e-07
+ 9.9603043385488658e-05 4.7689837631713853e-07
+ 9.9613949032415137e-05 3.0015113649486665e-07
+ 9.9626156063665136e-05 1.7876217937191045e-07
+ 9.9638363094915134e-05 1.0647330757921957e-07
+ 9.9650570126165133e-05 6.3424252544034479e-08
+ 9.9662777157415132e-05 3.7787934734000867e-08
+ 9.967498418866513e-05 2.2521155841269887e-08
+ 9.9687191219915129e-05 1.3429588576020001e-08
+ 9.9699398251165141e-05 8.015449872567151e-09
+ 9.971160528241514e-05 4.7912734917149069e-09
+ 9.9723812313665138e-05 2.871251600636248e-09
+ 9.9736019344915137e-05 1.7278727196949598e-09
+ 9.9748226376165136e-05 1.0469960699243559e-09
+ 9.9760433407415134e-05 6.4154623608527275e-10
+ 9.9772640438665133e-05 4.0011708092908531e-10
+ 9.9784847469915132e-05 2.563646256420896e-10
+ 9.979705450116513e-05 1.7078006330613652e-10
+ 9.9809261532415142e-05 1.1983532309874618e-10
+ 9.9821468563665141e-05 8.9519095817165878e-11
+ 9.983367559491514e-05 7.14874426319846e-11
+ 9.9845882626165138e-05 6.0771426293748156e-11
+ 9.9858089657415137e-05 5.4411972164600532e-11
+ 9.9870296688665136e-05 5.0646908151112081e-11
+ 9.9882503719915134e-05 4.8426835103990855e-11
+ 9.9894710751165147e-05 4.7126820532761082e-11
+ 9.9906917782415145e-05 4.6374708016315066e-11
+ 9.9919124813665144e-05 4.594887297816922e-11
+ 9.9931331844915143e-05 4.5717334758833713e-11
+ 9.9943538876165141e-05 4.5601496954841019e-11
+ 9.995574590741514e-05 4.5554554261028926e-11
+ 9.9967952938665139e-05 4.5548633436145208e-11
+ 9.9980159969915137e-05 4.5567135561437956e-11
+ 9.9992367001165136e-05 4.5600175741221697e-11
+ 0.0001 4.5625492954690469e-11
+ )
VpgndB pgndB 0 PWL(
+ 0 4.3429323819786375e-10
+ 1.2207031250000001e-08 4.3423882549145797e-10
+ 2.4414062500000001e-08 4.3418442800650571e-10
+ 3.6621093750000003e-08 4.3413004574565444e-10
+ 4.8828125000000002e-08 4.3407567870875607e-10
+ 6.1035156250000001e-08 4.3402132689399754e-10
+ 7.3242187500000007e-08 4.3396699029857563e-10
+ 8.5449218750000012e-08 4.3391266891909689e-10
+ 9.7656250000000018e-08 4.338583627518177e-10
+ 1.0986328125000002e-07 4.338040717927861e-10
+ 1.2207031250000003e-07 4.3374979603792648e-10
+ 1.3427734375000003e-07 4.3369553548309005e-10
+ 1.4648437500000004e-07 4.3364129012408513e-10
+ 1.5869140625000005e-07 4.3358705995669485e-10
+ 1.7089843750000005e-07 4.3353284497668784e-10
+ 1.8310546875000006e-07 4.3347864517982436e-10
+ 1.9531250000000006e-07 4.3342446056186068e-10
+ 2.0751953125000007e-07 4.3337029111855061e-10
+ 2.1972656250000007e-07 4.3331613684564742e-10
+ 2.3193359375000008e-07 4.3326199773890431e-10
+ 2.4414062500000006e-07 4.3320787379407488e-10
+ 2.5634765625000004e-07 4.3315376500691365e-10
+ 2.6855468750000002e-07 4.3309967137317592e-10
+ 2.8076171875e-07 4.3304559288861817e-10
+ 2.9296874999999997e-07 4.3299152954899793e-10
+ 3.0517578124999995e-07 4.3293748135007384e-10
+ 3.1738281249999993e-07 4.3288344828760572e-10
+ 3.2958984374999991e-07 4.3282943035735457e-10
+ 3.4179687499999989e-07 4.3277542755508266e-10
+ 3.5400390624999987e-07 4.327214398765532e-10
+ 3.6621093749999985e-07 4.3266746731753079e-10
+ 3.7841796874999983e-07 4.3261350987378112e-10
+ 3.9062499999999981e-07 4.3255956754107106e-10
+ 4.0283203124999979e-07 4.3250564031516869e-10
+ 4.1503906249999977e-07 4.324517281918434e-10
+ 4.2724609374999974e-07 4.3239783116686546e-10
+ 4.3945312499999972e-07 4.3234394923600652e-10
+ 4.516601562499997e-07 4.3229008239503964e-10
+ 4.6386718749999968e-07 4.322362306397386e-10
+ 4.7607421874999966e-07 4.3218239396587857e-10
+ 4.8828124999999969e-07 4.3212857236923607e-10
+ 5.0048828124999972e-07 4.3207476584558855e-10
+ 5.1269531249999976e-07 4.3202097439071481e-10
+ 5.2490234374999979e-07 4.3196719800039462e-10
+ 5.3710937499999982e-07 4.3191343667040926e-10
+ 5.4931640624999985e-07 4.3185969039654094e-10
+ 5.6152343749999988e-07 4.3180595917457319e-10
+ 5.7373046874999992e-07 4.3175224300029046e-10
+ 5.8593749999999995e-07 4.3169854186947872e-10
+ 5.9814453124999998e-07 4.3164485577792515e-10
+ 6.1035156250000001e-07 4.3159118472141752e-10
+ 6.2255859375000004e-07 4.315375286957455e-10
+ 6.3476562500000008e-07 4.3148388769669956e-10
+ 6.4697265625000011e-07 4.3143026172007142e-10
+ 6.5917968750000014e-07 4.3137665076165393e-10
+ 6.7138671875000017e-07 4.3132305481724119e-10
+ 6.835937500000002e-07 4.3126947388262849e-10
+ 6.9580078125000024e-07 4.3121590795361226e-10
+ 7.0800781250000027e-07 4.3116235702599014e-10
+ 7.202148437500003e-07 4.311088210955608e-10
+ 7.3242187500000033e-07 4.3105530015812432e-10
+ 7.4462890625000036e-07 4.3100179420948178e-10
+ 7.568359375000004e-07 4.3094830324543561e-10
+ 7.6904296875000043e-07 4.3089482726178914e-10
+ 7.8125000000000046e-07 4.3084136625434698e-10
+ 7.9345703125000049e-07 4.3078792021891527e-10
+ 8.0566406250000052e-07 4.3073448915130076e-10
+ 8.1787109375000056e-07 4.3068107304731183e-10
+ 8.3007812500000059e-07 4.3062767190275767e-10
+ 8.4228515625000062e-07 4.3057428571344897e-10
+ 8.5449218750000065e-07 4.305209144751974e-10
+ 8.6669921875000069e-07 4.3046755818381573e-10
+ 8.7890625000000072e-07 4.3041421683511815e-10
+ 8.9111328125000075e-07 4.3036089042491982e-10
+ 9.0332031250000078e-07 4.3030757894903721e-10
+ 9.1552734375000081e-07 4.3025428240328784e-10
+ 9.2773437500000085e-07 4.3020100078349046e-10
+ 9.3994140625000088e-07 4.3014773408546503e-10
+ 9.5214843750000091e-07 4.3009448230503257e-10
+ 9.6435546875000094e-07 4.3004124543801536e-10
+ 9.7656250000000087e-07 4.2998802348023685e-10
+ 9.8876953125000079e-07 4.2993481642752165e-10
+ 1.0009765625000007e-06 4.298816242756955e-10
+ 1.0131835937500006e-06 4.2982844702058526e-10
+ 1.0253906250000006e-06 4.2977528465801911e-10
+ 1.0375976562500005e-06 4.2972213718382639e-10
+ 1.0498046875000004e-06 4.296690045938374e-10
+ 1.0620117187500004e-06 4.2961588688388387e-10
+ 1.0742187500000003e-06 4.2956278404979846e-10
+ 1.0864257812500002e-06 4.2950969608741529e-10
+ 1.0986328125000001e-06 4.2945662299256918e-10
+ 1.1108398437500001e-06 4.2940356476109669e-10
+ 1.123046875e-06 4.2935052138883517e-10
+ 1.1352539062499999e-06 4.2929749287162315e-10
+ 1.1474609374999998e-06 4.2924447920530045e-10
+ 1.1596679687499998e-06 4.2919148038570803e-10
+ 1.1718749999999997e-06 4.2913849640868801e-10
+ 1.1840820312499996e-06 4.2908552727008359e-10
+ 1.1962890624999995e-06 4.2903257296573924e-10
+ 1.2084960937499995e-06 4.2897963349150058e-10
+ 1.2207031249999994e-06 4.2892670884321429e-10
+ 1.2329101562499993e-06 4.288737990167283e-10
+ 1.2451171874999992e-06 4.2882090400789185e-10
+ 1.2573242187499992e-06 4.2876802381255504e-10
+ 1.2695312499999991e-06 4.2871515842656934e-10
+ 1.281738281249999e-06 4.2866230784578723e-10
+ 1.2939453124999989e-06 4.2860947206606246e-10
+ 1.3061523437499989e-06 4.2855665108325002e-10
+ 1.3183593749999988e-06 4.2850384489320595e-10
+ 1.3305664062499987e-06 4.2845105349178732e-10
+ 1.3427734374999987e-06 4.2839827687485269e-10
+ 1.3549804687499986e-06 4.2834551503826145e-10
+ 1.3671874999999985e-06 4.2829276797787439e-10
+ 1.3793945312499984e-06 4.2824003568955333e-10
+ 1.3916015624999984e-06 4.2818731816916134e-10
+ 1.4038085937499983e-06 4.2813461541256231e-10
+ 1.4160156249999982e-06 4.2808192741562203e-10
+ 1.4282226562499981e-06 4.2802925417420679e-10
+ 1.4404296874999981e-06 4.2797659568418397e-10
+ 1.452636718749998e-06 4.2792395194142275e-10
+ 1.4648437499999979e-06 4.2787132294179297e-10
+ 1.4770507812499978e-06 4.2781870868116553e-10
+ 1.4892578124999978e-06 4.2776610915541303e-10
+ 1.5014648437499977e-06 4.2771352436040875e-10
+ 1.5136718749999976e-06 4.2766095429202714e-10
+ 1.5258789062499975e-06 4.2760839894614423e-10
+ 1.5380859374999975e-06 4.2755585831863669e-10
+ 1.5502929687499974e-06 4.2750333240538267e-10
+ 1.5624999999999973e-06 4.2745082120226136e-10
+ 1.5747070312499972e-06 4.2739832470515305e-10
+ 1.5869140624999972e-06 4.273458429099393e-10
+ 1.5991210937499971e-06 4.2729337581250278e-10
+ 1.611328124999997e-06 4.2724092340872732e-10
+ 1.623535156249997e-06 4.2718848569449787e-10
+ 1.6357421874999969e-06 4.2713606266570053e-10
+ 1.6479492187499968e-06 4.2708365431822263e-10
+ 1.6601562499999967e-06 4.270312606479525e-10
+ 1.6723632812499967e-06 4.2697888165077988e-10
+ 1.6845703124999966e-06 4.2692651732259529e-10
+ 1.6967773437499965e-06 4.2687416765929084e-10
+ 1.7089843749999964e-06 4.2682183265675928e-10
+ 1.7211914062499964e-06 4.2676951231089505e-10
+ 1.7333984374999963e-06 4.2671720661759342e-10
+ 1.7456054687499962e-06 4.2666491557275079e-10
+ 1.7578124999999961e-06 4.2661263917226478e-10
+ 1.7700195312499961e-06 4.265603774120343e-10
+ 1.782226562499996e-06 4.265081302879591e-10
+ 1.7944335937499959e-06 4.2645589779594043e-10
+ 1.8066406249999958e-06 4.2640367993188038e-10
+ 1.8188476562499958e-06 4.2635147669168246e-10
+ 1.8310546874999957e-06 4.2629928807125108e-10
+ 1.8432617187499956e-06 4.2624711406649186e-10
+ 1.8554687499999955e-06 4.2619495467331169e-10
+ 1.8676757812499955e-06 4.2614280988761856e-10
+ 1.8798828124999954e-06 4.2609067970532156e-10
+ 1.8920898437499953e-06 4.2603856412233079e-10
+ 1.9042968749999953e-06 4.2598646313455786e-10
+ 1.9165039062499952e-06 4.2593437673791515e-10
+ 1.9287109374999951e-06 4.2588230492831644e-10
+ 1.940917968749995e-06 4.2583024770167654e-10
+ 1.953124999999995e-06 4.2577820505391141e-10
+ 1.9653320312499949e-06 4.2572617698093814e-10
+ 1.9775390624999948e-06 4.2567416347867499e-10
+ 1.9897460937499947e-06 4.2562216454304139e-10
+ 2.0019531249999947e-06 4.2557018016995789e-10
+ 2.0141601562499946e-06 4.2551821035534623e-10
+ 2.0263671874999945e-06 4.2546625509512913e-10
+ 2.0385742187499944e-06 4.254143143852306e-10
+ 2.0507812499999944e-06 4.2536238822157581e-10
+ 2.0629882812499943e-06 4.2531047660009089e-10
+ 2.0751953124999942e-06 4.2525857951670346e-10
+ 2.0874023437499941e-06 4.252066969673418e-10
+ 2.0996093749999941e-06 4.2515482894793579e-10
+ 2.111816406249994e-06 4.2510297545441604e-10
+ 2.1240234374999939e-06 4.2505113648271467e-10
+ 2.1362304687499939e-06 4.2499931202876474e-10
+ 2.1484374999999938e-06 4.2494750208850055e-10
+ 2.1606445312499937e-06 4.248957066578573e-10
+ 2.1728515624999936e-06 4.2482519493572964e-10
+ 2.1850585937499936e-06 4.2475256100502045e-10
+ 2.1972656249999935e-06 4.2468173951608737e-10
+ 2.2094726562499934e-06 4.2459666096075283e-10
+ 2.2216796874999933e-06 4.2448010616874532e-10
+ 2.2338867187499933e-06 4.242745676347303e-10
+ 2.239990234374993e-06 4.2406762246865748e-10
+ 2.2460937499999932e-06 4.2364446431160585e-10
+ 2.2491455078124933e-06 4.2320637096990359e-10
+ 2.2521972656249934e-06 4.2237081875579266e-10
+ 2.2552490234374934e-06 4.2039912634768696e-10
+ 2.2566067907740856e-06 4.184858057925494e-10
+ 2.2569982166608607e-06 4.1769354662518729e-10
+ 2.2573896425476357e-06 4.1673967866159501e-10
+ 2.2583682072645731e-06 4.1328644574257995e-10
+ 2.2594095029081848e-06 4.0647792025774505e-10
+ 2.2599705987353218e-06 4.0009399586852752e-10
+ 2.2603396292983672e-06 3.9400830485401903e-10
+ 2.2611103238158415e-06 3.7217296598144555e-10
+ 2.2617414812338479e-06 3.3482378565862255e-10
+ 2.2621130840090086e-06 2.9476725253157392e-10
+ 2.2624341937957887e-06 2.3913652951300332e-10
+ 2.26264709792541e-06 2.1273235713088472e-10
+ 2.2628600020550312e-06 2.1207408791108858e-10
+ 2.2649890433512439e-06 2.1185023895337551e-10
+ 2.2771960746012438e-06 2.0757980032582087e-10
+ 2.2894031058512437e-06 1.9827504053149293e-10
+ 2.3016101371012437e-06 1.8447156434439206e-10
+ 2.3138171683512436e-06 1.6696410651490149e-10
+ 2.3260241996012435e-06 1.4676018343964647e-10
+ 2.3382312308512435e-06 1.2502212943217047e-10
+ 2.3504382621012434e-06 1.0300022779102304e-10
+ 2.3626452933512433e-06 8.1960799754197404e-11
+ 2.3748523246012432e-06 6.311338755160194e-11
+ 2.3870593558512432e-06 4.7541218733423125e-11
+ 2.3992663871012431e-06 3.6138949326912032e-11
+ 2.411473418351243e-06 2.9561263935700322e-11
+ 2.4236804496012429e-06 2.8185285811614418e-11
+ 2.4358874808512429e-06 3.2088955187765566e-11
+ 2.4480945121012428e-06 4.1046615499322252e-11
+ 2.4603015433512427e-06 5.4542057385810135e-11
+ 2.4725085746012426e-06 7.1798266491615728e-11
+ 2.4847156058512426e-06 9.1822160785597292e-11
+ 2.4969226371012425e-06 1.1346174161334856e-10
+ 2.5091296683512424e-06 1.3547236949090519e-10
+ 2.5213366996012423e-06 1.5658835172212636e-10
+ 2.5335437308512423e-06 1.7559572435646284e-10
+ 2.5457507621012422e-06 1.9140204326212496e-10
+ 2.5579577933512421e-06 2.030991720132836e-10
+ 2.5610095511637422e-06 2.0529687447679853e-10
+ 2.5613147269449921e-06 2.0549982177660819e-10
+ 2.562077666398117e-06 2.0599366009052315e-10
+ 2.5624591361246795e-06 2.062333046850057e-10
+ 2.5624829779825896e-06 2.0624812098499301e-10
+ 2.5624877463541714e-06 2.0625108196291897e-10
+ 2.5624972830973351e-06 2.0625700163649109e-10
+ 2.5624980460367883e-06 2.0625747507891284e-10
+ 2.5624995719156946e-06 2.0625842190532621e-10
+ 2.562499693986007e-06 2.0625849764807365e-10
+ 2.5624999381266319e-06 2.0625864913207268e-10
+ 2.5624999576578818e-06 2.0625866125070641e-10
+ 2.5624999967203816e-06 2.0625868548793557e-10
+ 2.5625000748453813e-06 8.3574849775232329e-10
+ 2.562500152970381e-06 2.8382408459534785e-09
+ 2.5625009342203779e-06 9.7910663945931592e-08
+ 2.5625080518459743e-06 6.9281309170090845e-06
+ 2.5625151694715707e-06 2.3496919613390592e-05
+ 2.5625222870971671e-06 4.8515586154137975e-05
+ 2.5625294047227634e-06 8.0864107426474553e-05
+ 2.5625365223483598e-06 0.0001195688537478285
+ 2.5625436399739562e-06 0.00016378325676260678
+ 2.5625507575995526e-06 0.00021277103077073492
+ 2.562557875225149e-06 0.00026589161027525284
+ 2.5625649928507454e-06 0.00032258751106878353
+ 2.5625721104763418e-06 0.00038237336083026571
+ 2.5625792281019382e-06 0.00044482637875059637
+ 2.5625878075685702e-06 0.00052313156179263198
+ 2.5625963870352022e-06 0.00060422377214069478
+ 2.5626049665018343e-06 0.00068763160407692863
+ 2.5626135459684663e-06 0.00077295453496090106
+ 2.5626221254350983e-06 0.00085985181282763258
+ 2.5626307049017303e-06 0.00094803308914625053
+ 2.5626392843683624e-06 0.0010372505228311898
+ 2.5626478638349944e-06 0.0011272921245865509
+ 2.5626581807702498e-06 0.0012364048498757886
+ 2.5626684977055052e-06 0.0013461799437633384
+ 2.5626788146407606e-06 0.0014563930288477433
+ 2.562689131576016e-06 0.001566855276772596
+ 2.5626994485112714e-06 0.0016774068636345029
+ 2.5627097654465268e-06 0.001787911643031166
+ 2.5627200823817821e-06 0.0018982528107135616
+ 2.5627303993170375e-06 0.0020083293767566338
+ 2.562742902012257e-06 0.002141246780886198
+ 2.5627554047074765e-06 0.0022735106700283729
+ 2.562767907402696e-06 0.0024050029041599369
+ 2.5627804100979155e-06 0.0025356196305195535
+ 2.5627929127931349e-06 0.0026652683340791378
+ 2.5628054154883544e-06 0.002793865545581445
+ 2.5628179181835739e-06 0.0029213350620943554
+ 2.5628304208787934e-06 0.0030476065669750823
+ 2.5628455922538732e-06 0.0031991277392290247
+ 2.562860763628953e-06 0.0033486794005026179
+ 2.5628759350040328e-06 0.0034961593179601309
+ 2.5628911063791127e-06 0.0036414711081661105
+ 2.5629062777541925e-06 0.0037845233735065873
+ 2.5629214491292723e-06 0.0039252290818992874
+ 2.5629366205043521e-06 0.0040635051254073566
+ 2.5629548605195594e-06 0.0042264209820281088
+ 2.5629731005347667e-06 0.0043855785109888799
+ 2.562991340549974e-06 0.004540852807539594
+ 2.5630095805651813e-06 0.0046921255232483241
+ 2.5630278205803886e-06 0.004839284756390172
+ 2.5630460605955959e-06 0.0049822250059800644
+ 2.5630681998658447e-06 0.0051499118748984281
+ 2.5630903391360935e-06 0.0053110729761570875
+ 2.5631124784063423e-06 0.0054655577982168782
+ 2.563134617676591e-06 0.0056132299331846198
+ 2.5631612930113167e-06 0.0057819364493443522
+ 2.5631878730958064e-06 0.0059398423573548687
+ 2.5632144531802961e-06 0.0060874136176253622
+ 2.5632486884843397e-06 0.0062620603819550135
+ 2.5632829237883832e-06 0.0064191641307141745
+ 2.5633153561270468e-06 0.0065517091134031152
+ 2.5633477884657104e-06 0.0066683776453289999
+ 2.563380220804374e-06 0.0067692021882621509
+ 2.5634126531430375e-06 0.0068542763543729904
+ 2.5634450854817011e-06 0.0069237529436825757
+ 2.5634775178203647e-06 0.0069778416850672731
+ 2.5635099501590283e-06 0.0070168067033145008
+ 2.5635423824976919e-06 0.0070409637367341727
+ 2.5635695849981454e-06 0.0070500711051410814
+ 2.563596787498599e-06 0.0070492564131712353
+ 2.5636239899990525e-06 0.0070387804986578604
+ 2.563651192499506e-06 0.0070189238317284377
+ 2.5636783949999595e-06 0.0069899850256677273
+ 2.5637055975004131e-06 0.0069522793135452206
+ 2.5637328000008666e-06 0.0069061369988542495
+ 2.5637600025013201e-06 0.0068519018883273245
+ 2.5637872050017737e-06 0.0067899297149596706
+ 2.5638144075022272e-06 0.0067205865590935169
+ 2.5638416100026807e-06 0.0066442472751925379
+ 2.5638688125031343e-06 0.006561293931672073
+ 2.5638960150035878e-06 0.0064721142708494637
+ 2.5639232175040413e-06 0.0063771001957435066
+ 2.5639504200044949e-06 0.0062766462900859356
+ 2.5639776225049484e-06 0.0061711483775146155
+ 2.5640048250054019e-06 0.0060610021255013743
+ 2.5640320275058554e-06 0.0059466016991306979
+ 2.564059230006309e-06 0.0058283384693926773
+ 2.5640864325067625e-06 0.0057065997804302861
+ 2.5641153008834975e-06 0.0055740309990659331
+ 2.5641441692602324e-06 0.0054384272991202893
+ 2.5641730376369674e-06 0.0053002282345430132
+ 2.5642019060137023e-06 0.0051598626838551204
+ 2.5642307743904373e-06 0.0050177476630414884
+ 2.5642596427671722e-06 0.0048742872442221231
+ 2.5642885111439072e-06 0.0047298715812966012
+ 2.5643173795206421e-06 0.0045848760430473451
+ 2.5643462478973771e-06 0.0044396604535071188
+ 2.5643811351666819e-06 0.0042643637747592994
+ 2.5644160224359868e-06 0.0040898203879790361
+ 2.5644499855060496e-06 0.0039211359224094145
+ 2.5644839485761124e-06 0.0037541355090310092
+ 2.5645179116461752e-06 0.0035892460195200843
+ 2.564551874716238e-06 0.0034268598627977894
+ 2.5645858377863008e-06 0.0032673350066711841
+ 2.5646273810828166e-06 0.0030765664536155394
+ 2.5646689243793324e-06 0.0028910852643209248
+ 2.5647104676758482e-06 0.0027113416169293153
+ 2.5647520109723639e-06 0.0025377141992044784
+ 2.5648023225230976e-06 0.0023360685105670866
+ 2.564853125173634e-06 0.0021424443576868821
+ 2.5649039278241704e-06 0.001959156496722657
+ 2.5649716072662458e-06 0.0017313192252947558
+ 2.5650392867083211e-06 0.0015222190408349249
+ 2.5650919193965658e-06 0.001372431253814393
+ 2.5651445520848105e-06 0.0012336381966261724
+ 2.5651971847730552e-06 0.0011055447342070166
+ 2.5652498174612999e-06 0.00098778684645394604
+ 2.5652978099291026e-06 0.00088906516794052203
+ 2.5653458023969054e-06 0.00079823747715313789
+ 2.5653937948647082e-06 0.00071492972227882204
+ 2.5654417873325109e-06 0.00063875107498295779
+ 2.5654897798003137e-06 0.00056929990178360005
+ 2.5655372615548627e-06 0.00050680910974394439
+ 2.5655847433094117e-06 0.00045011010916966049
+ 2.5656322250639607e-06 0.00039881145821643485
+ 2.5656797068185097e-06 0.00035252854906615789
+ 2.5657271885730587e-06 0.00031088653907439246
+ 2.5657746703276077e-06 0.0002735227890958723
+ 2.5658243585833644e-06 0.00023862511600889196
+ 2.5658740468391212e-06 0.00020765025205703798
+ 2.5659237350948779e-06 0.00018023763188315632
+ 2.5659734233506347e-06 0.00015604795426756195
+ 2.5660231116063915e-06 0.0001347637411803884
+ 2.5660727998621482e-06 0.00011608953467670693
+ 2.5661279513860744e-06 9.8086983151495662e-05
+ 2.5661831029100005e-06 8.2620379659707852e-05
+ 2.5662382544339267e-06 6.937830638173144e-05
+ 2.5662934059578528e-06 5.8079646203919961e-05
+ 2.566348557481779e-06 4.8471998343402797e-05
+ 2.5664116405205382e-06 3.9267448447275403e-05
+ 2.5664747235592973e-06 3.1683839518460041e-05
+ 2.5665378065980565e-06 2.5463033689023789e-05
+ 2.5666008896368157e-06 2.0382309617297274e-05
+ 2.566674140146425e-06 1.5662206653736814e-05
+ 2.5667473906560343e-06 1.1971024407425274e-05
+ 2.5668206411656436e-06 9.101093726216712e-06
+ 2.5669056194215832e-06 6.5781195004269459e-06
+ 2.5669905976775228e-06 4.7207090840830405e-06
+ 2.5670938368447841e-06 3.1245246960755978e-06
+ 2.567198171769413e-06 2.0371887602864823e-06
+ 2.5673025066940418e-06 1.3141391771344707e-06
+ 2.5674266644691634e-06 7.6923430377838728e-07
+ 2.567550822244285e-06 4.435788450454647e-07
+ 2.5677058008065315e-06 2.1851475951109054e-07
+ 2.5678849371317864e-06 9.3708673373505121e-08
+ 2.5680985566023881e-06 3.2883700516734768e-08
+ 2.568364485722952e-06 8.5309004428172277e-09
+ 2.5687179827122034e-06 1.4552417250701691e-09
+ 2.5692420975641447e-06 3.0578689270965244e-10
+ 2.5701363401204738e-06 2.4569663308855879e-10
+ 2.5721328071850344e-06 2.4259754686171839e-10
+ 2.5739888168580155e-06 2.4182034068072913e-10
+ 2.576421668443079e-06 2.4138174969930913e-10
+ 2.5788545200281424e-06 2.4076582964276258e-10
+ 2.5812873716132059e-06 2.4012576594620444e-10
+ 2.5837202231982694e-06 2.4057963384973803e-10
+ 2.5861530747833328e-06 2.4092919901400983e-10
+ 2.5885859263683963e-06 2.401872610697499e-10
+ 2.5910187779534598e-06 2.3987554496708928e-10
+ 2.5934516295385232e-06 2.4037942571475707e-10
+ 2.5957677052397796e-06 2.4025247901632375e-10
+ 2.5988194404067183e-06 2.4017887589128354e-10
+ 2.6018711755736571e-06 2.4009951114703349e-10
+ 2.6049229107405958e-06 2.4004351142745323e-10
+ 2.6079746459075345e-06 2.4016098617015712e-10
+ 2.6110263810744732e-06 2.4071442426522539e-10
+ 2.6140781162414119e-06 2.3968616681674537e-10
+ 2.6177736187735985e-06 2.4003007462135484e-10
+ 2.6211342886109086e-06 2.4006402385879101e-10
+ 2.6244949584482187e-06 2.4006047129867007e-10
+ 2.6286207316902777e-06 2.4005210497337081e-10
+ 2.6327465049323367e-06 2.4004042399080182e-10
+ 2.6368722781743958e-06 2.4003044384477591e-10
+ 2.6409980514164548e-06 2.4003749578386358e-10
+ 2.6451238246585138e-06 2.4008180521387353e-10
+ 2.650251138437096e-06 2.4016443526047099e-10
+ 2.6553784522156781e-06 2.3985136550844345e-10
+ 2.6605057659942602e-06 2.3994252727381691e-10
+ 2.6656330797728424e-06 2.4004700010028028e-10
+ 2.671995979825151e-06 2.4004483697536087e-10
+ 2.6783588798774597e-06 2.3997024527683999e-10
+ 2.6847217799297684e-06 2.3997592655072043e-10
+ 2.6924972562545095e-06 2.4000749931504923e-10
+ 2.7002727325792507e-06 2.4001269631983051e-10
+ 2.7080482089039918e-06 2.3999782508278659e-10
+ 2.7179834419360667e-06 2.3999355892689472e-10
+ 2.7279186749681417e-06 2.4000179472492324e-10
+ 2.7401257062181416e-06 2.4000339716614338e-10
+ 2.7523327374681415e-06 2.3999888202599127e-10
+ 2.7645397687181414e-06 2.3999830525938688e-10
+ 2.7767467999681414e-06 2.4000037974237526e-10
+ 2.7889538312181413e-06 2.4000087414852165e-10
+ 2.8011608624681412e-06 2.3999993966201389e-10
+ 2.8133678937181411e-06 2.3999960494882817e-10
+ 2.8255749249681411e-06 2.4000001432309894e-10
+ 2.837781956218141e-06 2.4000021737723387e-10
+ 2.8499889874681409e-06 2.4000004462513988e-10
+ 2.8621960187181408e-06 2.3999993006727966e-10
+ 2.8744030499681408e-06 2.3999999917748096e-10
+ 2.8866100812181407e-06 2.4000006049017395e-10
+ 2.8988171124681406e-06 2.4000003421757239e-10
+ 2.9110241437181405e-06 2.4000000237870328e-10
+ 2.9232311749681405e-06 2.4000001256652595e-10
+ 2.9354382062181404e-06 2.4000002745854788e-10
+ 2.9476452374681403e-06 2.4000002475271839e-10
+ 2.9598522687181403e-06 2.4000001795384735e-10
+ 2.9720592999681402e-06 2.400000173879749e-10
+ 2.9842663312181401e-06 2.4000002070407596e-10
+ 2.99647336246814e-06 2.4000002067419452e-10
+ 3.00868039371814e-06 2.4000001976473751e-10
+ 3.0208874249681399e-06 2.40000019362722e-10
+ 3.0330944562181398e-06 2.4000002028128461e-10
+ 3.0453014874681397e-06 2.4000002060646208e-10
+ 3.0575085187181397e-06 2.4000002008287723e-10
+ 3.0697155499681396e-06 2.4000001934276911e-10
+ 3.0819225812181395e-06 2.4000001968966948e-10
+ 3.0941296124681394e-06 2.4000002093381111e-10
+ 3.1063366437181394e-06 2.4000001965726013e-10
+ 3.1185436749681393e-06 2.4000001961507071e-10
+ 3.1307507062181392e-06 2.4000002048512451e-10
+ 3.1429577374681391e-06 2.4000001998121006e-10
+ 3.1551647687181391e-06 2.400000199764228e-10
+ 3.167371799968139e-06 2.4000001998665694e-10
+ 3.1795788312181389e-06 2.4000001988395378e-10
+ 3.1917858624681389e-06 2.4000001969840786e-10
+ 3.2039928937181388e-06 2.4000001962628526e-10
+ 3.2161999249681387e-06 2.4000001985975601e-10
+ 3.2284069562181386e-06 2.4000001994562599e-10
+ 3.2406139874681386e-06 2.4000001873790616e-10
+ 3.2528210187181385e-06 2.400000206888198e-10
+ 3.2650280499681384e-06 2.4000002115772409e-10
+ 3.2772350812181383e-06 2.4000001926167516e-10
+ 3.2894421124681383e-06 2.4000001865095655e-10
+ 3.3016491437181382e-06 2.4000002024868279e-10
+ 3.3138561749681381e-06 2.4000002062807212e-10
+ 3.326063206218138e-06 2.4000001971246058e-10
+ 3.338270237468138e-06 2.4000001913611468e-10
+ 3.3504772687181379e-06 2.4000001939609548e-10
+ 3.3626842999681378e-06 2.4000001928925776e-10
+ 3.3748913312181377e-06 2.4000002036211893e-10
+ 3.3870983624681377e-06 2.4000001948566678e-10
+ 3.3993053937181376e-06 2.40000020557049e-10
+ 3.4115124249681375e-06 2.400000203491446e-10
+ 3.4237194562181374e-06 2.4000001961720044e-10
+ 3.4359264874681374e-06 2.400000200808237e-10
+ 3.4481335187181373e-06 2.4000002006495584e-10
+ 3.4603405499681372e-06 2.4000001941755901e-10
+ 3.4725475812181372e-06 2.4000001925514504e-10
+ 3.4847546124681371e-06 2.4000001949494439e-10
+ 3.496961643718137e-06 2.4000001987457185e-10
+ 3.5091686749681369e-06 2.4000001956535886e-10
+ 3.5213757062181369e-06 2.4000001976899341e-10
+ 3.5335827374681368e-06 2.4000001989767335e-10
+ 3.5457897687181367e-06 2.4000002010421042e-10
+ 3.5579967999681366e-06 2.4000002031692612e-10
+ 3.5702038312181366e-06 2.4000001943796074e-10
+ 3.5824108624681365e-06 2.4000001979057998e-10
+ 3.5946178937181364e-06 2.4000001994141042e-10
+ 3.6068249249681363e-06 2.4000001910787902e-10
+ 3.6190319562181363e-06 2.4000002014157438e-10
+ 3.6312389874681362e-06 2.4000002007976212e-10
+ 3.6434460187181361e-06 2.4000001897875313e-10
+ 3.655653049968136e-06 2.4000002030066949e-10
+ 3.667860081218136e-06 2.4000002070432142e-10
+ 3.6800671124681359e-06 2.4000001950520541e-10
+ 3.6922741437181358e-06 2.4000001947980057e-10
+ 3.7044811749681357e-06 2.4000002027253361e-10
+ 3.7166882062181357e-06 2.40000020609859e-10
+ 3.7288952374681356e-06 2.4000001911322354e-10
+ 3.7411022687181355e-06 2.4000001969739074e-10
+ 3.7533092999681355e-06 2.4000002073053612e-10
+ 3.7655163312181354e-06 2.4000001994814067e-10
+ 3.7777233624681353e-06 2.4000001923239209e-10
+ 3.7899303937181352e-06 2.4000002015288261e-10
+ 3.8021374249681352e-06 2.4000001930210656e-10
+ 3.8143444562181351e-06 2.4000001837686493e-10
+ 3.8265514874681354e-06 2.4000001946449939e-10
+ 3.8387585187181358e-06 2.4000002038326192e-10
+ 3.8509655499681361e-06 2.400000203109469e-10
+ 3.8631725812181365e-06 2.400000203952259e-10
+ 3.8753796124681368e-06 2.4000001970496741e-10
+ 3.8875866437181372e-06 2.4000001924454606e-10
+ 3.8997936749681375e-06 2.4000001905466872e-10
+ 3.9120007062181379e-06 2.400000204518705e-10
+ 3.9242077374681382e-06 2.4000002011557764e-10
+ 3.9364147687181386e-06 2.4000001946831419e-10
+ 3.9486217999681389e-06 2.4000001925940771e-10
+ 3.9608288312181393e-06 2.4000001980987061e-10
+ 3.9730358624681396e-06 2.4000002089319245e-10
+ 3.98524289371814e-06 2.4000001973823067e-10
+ 3.9974499249681403e-06 2.4000001879346328e-10
+ 4.0096569562181407e-06 2.4000001869932423e-10
+ 4.021863987468141e-06 2.4000002074828773e-10
+ 4.0340710187181414e-06 2.4000001934026167e-10
+ 4.0462780499681417e-06 2.4000001952115826e-10
+ 4.0584850812181421e-06 2.4000001987859593e-10
+ 4.0706921124681424e-06 2.400000198982881e-10
+ 4.0828991437181428e-06 2.40000018977687e-10
+ 4.0951061749681431e-06 2.4000001970468766e-10
+ 4.1073132062181435e-06 2.4000001969944985e-10
+ 4.1195202374681438e-06 2.4000002027367879e-10
+ 4.1317272687181442e-06 2.4000001840031488e-10
+ 4.1439342999681445e-06 2.4000001957318321e-10
+ 4.1561413312181449e-06 2.400000188108562e-10
+ 4.1683483624681452e-06 2.4000002046679305e-10
+ 4.1805553937181456e-06 2.4000001950571268e-10
+ 4.1927624249681459e-06 2.4000001838116472e-10
+ 4.2049694562181463e-06 2.4000001853089837e-10
+ 4.2171764874681466e-06 2.4000002004811227e-10
+ 4.229383518718147e-06 2.4000001966057371e-10
+ 4.2415905499681473e-06 2.4000001941089245e-10
+ 4.2537975812181477e-06 2.4000001913185568e-10
+ 4.266004612468148e-06 2.4000001954838558e-10
+ 4.2782116437181484e-06 2.4000001920964592e-10
+ 4.2904186749681487e-06 2.4000001943469307e-10
+ 4.3026257062181491e-06 2.4000001866641258e-10
+ 4.3148327374681494e-06 2.4000002020897109e-10
+ 4.3270397687181498e-06 2.4000001940179987e-10
+ 4.3392467999681501e-06 2.4000001993507329e-10
+ 4.3514538312181505e-06 2.4000002008198123e-10
+ 4.3636608624681508e-06 2.400000198005213e-10
+ 4.3758678937181512e-06 2.4000001916301211e-10
+ 4.3880749249681515e-06 2.4000001960280073e-10
+ 4.4002819562181519e-06 2.4000001963117276e-10
+ 4.4124889874681522e-06 2.400000196254434e-10
+ 4.4246960187181526e-06 2.4000002030623543e-10
+ 4.4369030499681529e-06 2.4000001985486468e-10
+ 4.4491100812181533e-06 2.4000001975560508e-10
+ 4.4613171124681536e-06 2.4000002002563028e-10
+ 4.473524143718154e-06 2.4000001880683233e-10
+ 4.4857311749681543e-06 2.400000186107882e-10
+ 4.4979382062181547e-06 2.4000002026174485e-10
+ 4.510145237468155e-06 2.4000001964579944e-10
+ 4.5223522687181554e-06 2.4000001869414737e-10
+ 4.5345592999681557e-06 2.4000002024855297e-10
+ 4.5467663312181561e-06 2.4000001886895933e-10
+ 4.5589733624681564e-06 2.4000001996539064e-10
+ 4.5711803937181568e-06 2.4000001852201533e-10
+ 4.5833874249681571e-06 2.4000001995376353e-10
+ 4.5955944562181575e-06 2.4000001885033681e-10
+ 4.6078014874681578e-06 2.400000202275795e-10
+ 4.6200085187181582e-06 2.4000001938682899e-10
+ 4.6322155499681585e-06 2.400000185286626e-10
+ 4.6444225812181589e-06 2.4000002021567022e-10
+ 4.6566296124681592e-06 2.4000001929093104e-10
+ 4.6688366437181596e-06 2.4000001945502139e-10
+ 4.6810436749681599e-06 2.4000001849176264e-10
+ 4.6932507062181603e-06 2.4000001899160695e-10
+ 4.7054577374681606e-06 2.4000001908469775e-10
+ 4.717664768718161e-06 2.4000002021320925e-10
+ 4.7298717999681613e-06 2.4000001986077044e-10
+ 4.7420788312181617e-06 2.4000001985660228e-10
+ 4.754285862468162e-06 2.4000001982734366e-10
+ 4.7664928937181624e-06 2.4000001909394165e-10
+ 4.7786999249681627e-06 2.4000001971428865e-10
+ 4.7909069562181631e-06 2.4000001921042243e-10
+ 4.8031139874681634e-06 2.400000190589926e-10
+ 4.8153210187181638e-06 2.400000192770844e-10
+ 4.8275280499681641e-06 2.4000001876027354e-10
+ 4.8397350812181645e-06 2.4000001963225885e-10
+ 4.8519421124681648e-06 2.4000001898595255e-10
+ 4.8641491437181652e-06 2.4000001876650681e-10
+ 4.8763561749681655e-06 2.4000001955479303e-10
+ 4.8885632062181659e-06 2.400000192149284e-10
+ 4.9007702374681662e-06 2.4000001962818762e-10
+ 4.9129772687181666e-06 2.400000192259498e-10
+ 4.9251842999681669e-06 2.4000001958046752e-10
+ 4.9373913312181673e-06 2.4000001876653049e-10
+ 4.9495983624681676e-06 2.4000001901679062e-10
+ 4.961805393718168e-06 2.4000001929188411e-10
+ 4.9740124249681683e-06 2.4000001878460593e-10
+ 4.9862194562181687e-06 2.4000001895149019e-10
+ 4.998426487468169e-06 2.4000001953324466e-10
+ 5.0106335187181694e-06 2.4000001930179932e-10
+ 5.0228405499681697e-06 2.4000001867284628e-10
+ 5.03504758121817e-06 2.4000001876404646e-10
+ 5.0472546124681704e-06 2.4000001844012502e-10
+ 5.0594616437181707e-06 2.4000001847700822e-10
+ 5.0716686749681711e-06 2.4000001848915366e-10
+ 5.0838757062181714e-06 2.4000001847211049e-10
+ 5.0960827374681718e-06 2.4000001842583542e-10
+ 5.1082897687181721e-06 2.4000001874485954e-10
+ 5.1204967999681725e-06 2.4000001864470591e-10
+ 5.1327038312181728e-06 2.400000192645186e-10
+ 5.1449108624681732e-06 2.4000001911011029e-10
+ 5.1571178937181735e-06 2.400000189594016e-10
+ 5.1693249249681739e-06 2.4000001834385696e-10
+ 5.1815319562181742e-06 2.4000001923683012e-10
+ 5.1937389874681746e-06 2.4000002008098464e-10
+ 5.2059460187181749e-06 2.400000183211859e-10
+ 5.2181530499681753e-06 2.4000001983070817e-10
+ 5.2303600812181756e-06 2.4000001841550595e-10
+ 5.242567112468176e-06 2.4000001987140726e-10
+ 5.2547741437181763e-06 2.4000001839799459e-10
+ 5.2669811749681767e-06 2.4000001979564812e-10
+ 5.279188206218177e-06 2.4000001826400317e-10
+ 5.2913952374681774e-06 2.3996544537098469e-10
+ 5.3036022687181777e-06 2.3996256464191007e-10
+ 5.3158092999681781e-06 2.3996062147298765e-10
+ 5.3280163312181784e-06 2.399538992151035e-10
+ 5.3402233624681788e-06 2.3990864356794482e-10
+ 5.3524303937181791e-06 2.3980391697569448e-10
+ 5.3646374249681795e-06 2.3960325885649169e-10
+ 5.3707409405931797e-06 2.3930636780140344e-10
+ 5.3768444562181798e-06 2.3825018349924986e-10
+ 5.3798962140306804e-06 2.3664385617022961e-10
+ 5.38294797184318e-06 2.313460144418538e-10
+ 5.3844738507494298e-06 2.2273712950258841e-10
+ 5.3859997296556797e-06 1.9502932447418286e-10
+ 5.3869911068891847e-06 1.3263414891107653e-10
+ 5.3872697338962416e-06 9.5672269136980181e-11
+ 5.3875483609032986e-06 4.6113023016783446e-11
+ 5.3880988356279693e-06 4.077304569289076e-11
+ 5.3908752739124348e-06 4.2347131994264368e-11
+ 5.4030823051624352e-06 4.4733371018365243e-11
+ 5.4152893364124355e-06 5.3058719093237963e-11
+ 5.4274963676624359e-06 6.5249849962529414e-11
+ 5.4397033989124362e-06 8.0586557341896391e-11
+ 5.4519104301624366e-06 9.8186059694000248e-11
+ 5.4641174614124369e-06 1.1703587328666208e-10
+ 5.4763244926624373e-06 1.3605185310399104e-10
+ 5.4885315239124376e-06 1.5414054504639482e-10
+ 5.500738555162438e-06 1.7026206156240515e-10
+ 5.5129455864124383e-06 1.8348986297121229e-10
+ 5.5251526176624386e-06 1.9306400774952091e-10
+ 5.537359648912439e-06 1.9843481134517081e-10
+ 5.5495666801624393e-06 1.9929440536940058e-10
+ 5.5617737114124397e-06 1.9559438520732841e-10
+ 5.57398074266244e-06 1.8754853451668201e-10
+ 5.5861877739124404e-06 1.7562047328816539e-10
+ 5.5983948051624407e-06 1.6049694315998822e-10
+ 5.6106018364124411e-06 1.4304826930135124e-10
+ 5.6228088676624414e-06 1.2427827523140709e-10
+ 5.6350158989124418e-06 1.052665328361379e-10
+ 5.6472229301624421e-06 8.7106269937226752e-11
+ 5.6594299614124425e-06 7.0841506734532094e-11
+ 5.6716369926624428e-06 5.7407035899497847e-11
+ 5.6838440239124432e-06 4.7574696846103914e-11
+ 5.6868957817249429e-06 4.5750674856066197e-11
+ 5.687048369615568e-06 4.5666462612461995e-11
+ 5.6874298393421305e-06 4.5458870923120094e-11
+ 5.687467986314787e-06 4.5438342991126504e-11
+ 5.6874756157093184e-06 4.5434242455099145e-11
+ 5.6874908744983814e-06 4.5426046434154427e-11
+ 5.6874969780140066e-06 4.5422769911655126e-11
+ 5.687499419420257e-06 4.542145960441293e-11
+ 5.6874996044557842e-06 4.5421360302533612e-11
+ 5.6874999745268387e-06 4.5421161701746532e-11
+ 5.6875007146689477e-06 5.7234708751505077e-08
+ 5.6875014548110567e-06 2.3609835104101694e-07
+ 5.6875088562321464e-06 8.3378657603255145e-06
+ 5.6875162576532362e-06 2.6804211983519737e-05
+ 5.687523659074326e-06 5.4212572160978158e-05
+ 5.6875310604954158e-06 8.9333429400249197e-05
+ 5.6875384619165056e-06 0.00013110387761772142
+ 5.6875475123556867e-06 0.00018988604042548046
+ 5.6875565627948677e-06 0.000255812068272275
+ 5.6875656132340488e-06 0.00032768193023753725
+ 5.6875746636732299e-06 0.00040448949601993325
+ 5.687583714112411e-06 0.00048539058840956265
+ 5.6875950445335094e-06 0.00059137048504824714
+ 5.6876063749546078e-06 0.00070151686849491022
+ 5.6876177053757063e-06 0.0008149054011463608
+ 5.6876290357968047e-06 0.00093078918228233572
+ 5.6876432146533604e-06 0.0010784080416500865
+ 5.6876573935099161e-06 0.0012280520970111633
+ 5.6876715723664718e-06 0.0013789889014004875
+ 5.6876890323969347e-06 0.0015657925325384681
+ 5.6877064924273976e-06 0.0017528666320927736
+ 5.6877239524578605e-06 0.0019395804048633696
+ 5.6877462684778302e-06 0.0021769293571718938
+ 5.6877685844977999e-06 0.0024120996791847497
+ 5.6877909005177697e-06 0.0026444704336099976
+ 5.6878190902172398e-06 0.0029332237971511233
+ 5.68784727991671e-06 0.0032158629328255771
+ 5.6878754696161801e-06 0.0034916668520790159
+ 5.6879036593156503e-06 0.0037599988278231356
+ 5.6879318490151204e-06 0.0040202830355208904
+ 5.6879600387145905e-06 0.0042719918874605982
+ 5.6879882284140607e-06 0.0045146394015623476
+ 5.688019414106472e-06 0.0047719795450323309
+ 5.6880505997988832e-06 0.0050171295125712645
+ 5.6880817854912945e-06 0.0052495906087394869
+ 5.6881129711837057e-06 0.0054689190353913904
+ 5.6881504184143359e-06 0.0057143885297757718
+ 5.688187865644966e-06 0.0059397992525804574
+ 5.6882253128755961e-06 0.006144702220679193
+ 5.6882708441958085e-06 0.0063657430322260553
+ 5.688316375516021e-06 0.0065556175023236875
+ 5.6883619068362334e-06 0.0067142112673811444
+ 5.6884074381564458e-06 0.0068416534980290083
+ 5.6884410840281113e-06 0.0069160175765833089
+ 5.6884747298997768e-06 0.0069737900261410465
+ 5.6885083757714423e-06 0.0070152594941248576
+ 5.6885420216431078e-06 0.0070407746969006688
+ 5.6885756675147732e-06 0.007050740823760393
+ 5.6886093133864387e-06 0.0070456156939712805
+ 5.6886429592581042e-06 0.007025905702338452
+ 5.6886766051297697e-06 0.0069921615895264296
+ 5.6887102510014352e-06 0.0069449740739896257
+ 5.6887368706681459e-06 0.006898526876910809
+ 5.6887634903348567e-06 0.0068443802044164921
+ 5.6887901100015674e-06 0.0067828688534493494
+ 5.6888167296682782e-06 0.0067143369242957376
+ 5.6888433493349889e-06 0.0066391364097472113
+ 5.6888699690016997e-06 0.0065576257964309343
+ 5.6888965886684104e-06 0.0064701686843428533
+ 5.6889232083351212e-06 0.0063771324303375145
+ 5.6889498280018319e-06 0.0062788868210215225
+ 5.6889764476685427e-06 0.0061758027801676225
+ 5.6890030673352534e-06 0.0060682511154162089
+ 5.6890296870019641e-06 0.0059566013086644297
+ 5.6890563066686749e-06 0.0058412203541628417
+ 5.6890829263353856e-06 0.0057224716479485063
+ 5.6891095460020964e-06 0.0056007139318451742
+ 5.6891361656688071e-06 0.0054763002948580381
+ 5.6891627853355179e-06 0.0053495772343856614
+ 5.6891894050022286e-06 0.0052208837792675896
+ 5.6892160246689394e-06 0.0050905506764474901
+ 5.6892394049352276e-06 0.0049749804171373225
+ 5.6892627852015158e-06 0.0048586054363550972
+ 5.689286165467804e-06 0.0047416314482211135
+ 5.6893095457340922e-06 0.0046242577652878883
+ 5.6893329260003804e-06 0.0045066770343838705
+ 5.6893563062666686e-06 0.0043890750025309139
+ 5.6893796865329568e-06 0.0042716303126259531
+ 5.6894030667992451e-06 0.0041545143284691553
+ 5.6894264470655333e-06 0.0040378909886185305
+ 5.6894498273318215e-06 0.0039219166884552218
+ 5.6894732075981097e-06 0.0038067401897542695
+ 5.6894965878643979e-06 0.0036925025569730643
+ 5.6895199681306861e-06 0.0035793371193940525
+ 5.6895433483969743e-06 0.0034673694581895016
+ 5.6895667286632625e-06 0.0033567174174145066
+ 5.6895901089295507e-06 0.0032474911378798247
+ 5.6896134891958389e-06 0.0031397931128086067
+ 5.6896368694621271e-06 0.0030337182641405314
+ 5.6896602497284153e-06 0.0029293540383132049
+ 5.6896836299947035e-06 0.0028267805203238136
+ 5.6897070102609918e-06 0.0027260705648536779
+ 5.6897355912375156e-06 0.0026055855381113117
+ 5.6897641722140395e-06 0.0024880893416989024
+ 5.6897927531905634e-06 0.0023736731389782805
+ 5.6898213341670872e-06 0.0022624136400195647
+ 5.6898499151436111e-06 0.0021543736566158275
+ 5.689886199806211e-06 0.0020219271947776738
+ 5.68992545337338e-06 0.0018846580284455387
+ 5.6899469772152624e-06 0.0018120618774395494
+ 5.6899736967146985e-06 0.0017245821083065652
+ 5.6900004162141346e-06 0.0016400258203643724
+ 5.6900271357135706e-06 0.0015583844444338579
+ 5.6900538552130067e-06 0.0014796423351417674
+ 5.6900805747124428e-06 0.0014037772468436488
+ 5.6901072942118789e-06 0.0013307608065583204
+ 5.690134013711315e-06 0.0012605589819463642
+ 5.690160733210751e-06 0.0011931325425094006
+ 5.6901874527101871e-06 0.0011284375123336611
+ 5.6902141722096232e-06 0.0010664256128491564
+ 5.6902408917090593e-06 0.0010070446942234952
+ 5.690262548859611e-06 0.00096080661895637035
+ 5.6902842060101628e-06 0.0009162294538821239
+ 5.6903058631607145e-06 0.00087328092606094238
+ 5.6903275203112662e-06 0.00083192771752318962
+ 5.690349177461818e-06 0.00079213559354230647
+ 5.6903708346123697e-06 0.00075386952625768001
+ 5.6903924917629215e-06 0.00071709381353394315
+ 5.6904141489134732e-06 0.00068177219296354193
+ 5.6904358060640249e-06 0.00064786795094112185
+ 5.6904574632145767e-06 0.00061534402675914772
+ 5.6904791203651284e-06 0.00058416311167918647
+ 5.6904967653996022e-06 0.00055972551886932095
+ 5.690514410434076e-06 0.00053613426244406741
+ 5.6905320554685497e-06 0.00051336904748169171
+ 5.6905497005030235e-06 0.00049140960981622914
+ 5.6905673455374973e-06 0.00047023574348777509
+ 5.690584990571971e-06 0.00044982732676715286
+ 5.6906026356064448e-06 0.00043016434677204047
+ 5.6906202806409186e-06 0.00041122692269401575
+ 5.6906379256753923e-06 0.00039299532765819798
+ 5.6906555707098661e-06 0.00037545000923921415
+ 5.6906732157443399e-06 0.00035857160865911174
+ 5.6906908607788136e-06 0.00034234097869457157
+ 5.6907085058132874e-06 0.00032673920032235228
+ 5.6907261508477612e-06 0.00031174759813332067
+ 5.6907437958822349e-06 0.00029734775454669758
+ 5.6907614409167087e-06 0.00028352152285727745
+ 5.6907790859511825e-06 0.0002702510391493668
+ 5.6907967309856562e-06 0.00025751873311203796
+ 5.69081437602013e-06 0.00024530733779101174
+ 5.6908320210546038e-06 0.00023359989831307307
+ 5.6908496660890775e-06 0.00022237977961939102
+ 5.6908673111235513e-06 0.00021163067324446447
+ 5.6908849561580251e-06 0.00020133660317765155
+ 5.6909026011924988e-06 0.00019148193084437179
+ 5.6909202462269726e-06 0.00018205135924409671
+ 5.6909378912614464e-06 0.00017302993628217709
+ 5.6909555362959202e-06 0.00016440305733239472
+ 5.6909731813303939e-06 0.00015615646706688136
+ 5.6909908263648677e-06 0.00014827626058972067
+ 5.6910084713993415e-06 0.00014074888391014853
+ 5.6910261164338152e-06 0.00013356113379079491
+ 5.691043761468289e-06 0.00012670015700587552
+ 5.6910614065027628e-06 0.00012015344904364461
+ 5.6910790515372365e-06 0.00011390885228677083
+ 5.6910966965717103e-06 0.00010795455370359766
+ 5.6911143416061841e-06 0.00010227908208250491
+ 5.6911319866406578e-06 9.687130484080241e-05
+ 5.6911496316751316e-06 9.1720424438765868e-05
+ 5.6911672767096054e-06 8.6815974428572379e-05
+ 5.6911849217440791e-06 8.2147815167013072e-05
+ 5.6912025667785529e-06 7.7706129219957601e-05
+ 5.6912202118130267e-06 7.3481416485622882e-05
+ 5.6912378568475004e-06 6.9464489062760908e-05
+ 5.6912555018819742e-06 6.5646465888930612e-05
+ 5.691273146916448e-06 6.2018767173060703e-05
+ 5.6912907919509217e-06 5.8573108645546759e-05
+ 5.6913084369853955e-06 5.5301495648160228e-05
+ 5.6913260820198693e-06 5.2196217085081444e-05
+ 5.691343727054343e-06 4.9249839255407143e-05
+ 5.6913613720888168e-06 4.6455199586526805e-05
+ 5.6913790171232906e-06 4.3805400286814076e-05
+ 5.6913966621577643e-06 4.1293801935142287e-05
+ 5.6914143071922381e-06 3.8914017023807698e-05
+ 5.6914319522267119e-06 3.6659903470533496e-05
+ 5.6914495972611856e-06 3.4525558114332587e-05
+ 5.6914672422956594e-06 3.2505310209129923e-05
+ 5.6914848873301332e-06 3.0593714928186798e-05
+ 5.691502532364607e-06 2.878554689153125e-05
+ 5.6915201773990807e-06 2.7075793727781893e-05
+ 5.6915378224335545e-06 2.5459649680957857e-05
+ 5.6915554674680283e-06 2.3932509272096093e-05
+ 5.691573112502502e-06 2.2489961024749567e-05
+ 5.6915907575369758e-06 2.1127781262716843e-05
+ 5.6916084025714496e-06 1.9841927987655173e-05
+ 5.6916260476059233e-06 1.8628534843556469e-05
+ 5.6916436926403971e-06 1.7483905174418017e-05
+ 5.6916613376748709e-06 1.6404506180818473e-05
+ 5.691682620107575e-06 1.5184596516820046e-05
+ 5.6917027452816776e-06 1.4108722156777394e-05
+ 5.6917228704557802e-06 1.3103783271809466e-05
+ 5.6917429956298828e-06 1.2165512099818384e-05
+ 5.6917631208039854e-06 1.1289867233639744e-05
+ 5.691783245978088e-06 1.0473023791237365e-05
+ 5.6918033711521906e-06 9.711363860421274e-06
+ 5.6918234963262932e-06 9.0014672215583367e-06
+ 5.6918436215003957e-06 8.3401023506671107e-06
+ 5.6918637466744983e-06 7.7242177042852387e-06
+ 5.6918881107461259e-06 7.0353574872189284e-06
+ 5.6919124748177534e-06 6.4041509733236313e-06
+ 5.6919368388893809e-06 5.8261375978047346e-06
+ 5.6919612029610084e-06 5.2971679183216326e-06
+ 5.6919855670326359e-06 4.8133849648221628e-06
+ 5.6920099311042634e-06 4.3712064413582404e-06
+ 5.6920342951758909e-06 3.9673077642003495e-06
+ 5.6920586592475184e-06 3.5986059186122073e-06
+ 5.692083023319146e-06 3.2622441148827113e-06
+ 5.6921073873907735e-06 2.955577222710442e-06
+ 5.6921367196835683e-06 2.6223173518557521e-06
+ 5.6921660519763631e-06 2.3246430183300364e-06
+ 5.6921953842691579e-06 2.0589938235170389e-06
+ 5.6922247165619528e-06 1.8221375097881734e-06
+ 5.6922540488547476e-06 1.6111428978970881e-06
+ 5.6922833811475424e-06 1.4233547079677823e-06
+ 5.6923127134403372e-06 1.2563701699769522e-06
+ 5.6923420457331321e-06 1.1080173307665688e-06
+ 5.6923778480291947e-06 9.4935328593955194e-07
+ 5.6924123354546283e-06 8.1703614317247063e-07
+ 5.6924468228800619e-06 7.0231034037170861e-07
+ 5.6924813103054954e-06 6.0295931014601184e-07
+ 5.692515797730929e-06 5.1702814794412422e-07
+ 5.6925578283212079e-06 4.2796498791424164e-07
+ 5.6925998589114867e-06 3.5358466304975593e-07
+ 5.6926418895017655e-06 2.9157919961691281e-07
+ 5.6926839200920444e-06 2.3998333476715486e-07
+ 5.6927259506823232e-06 1.9712710629082681e-07
+ 5.6927775185034229e-06 1.5442331314774624e-07
+ 5.6928281866664806e-06 1.2110746118199679e-07
+ 5.6928788548295382e-06 9.4668212428266369e-08
+ 5.6929295229925959e-06 7.3741045625230226e-08
+ 5.6929932151434603e-06 5.3572482382509411e-08
+ 5.6930569072943247e-06 3.8650410566722333e-08
+ 5.6931205994451891e-06 2.7655607125139506e-08
+ 5.6931989456107131e-06 1.80624388894615e-08
+ 5.6932786576496905e-06 1.1455385675920075e-08
+ 5.6933583696886679e-06 7.0279116712338033e-09
+ 5.6934612923707637e-06 3.42722610432318e-09
+ 5.6935695089098192e-06 1.2415251844169095e-09
+ 5.6937019148044358e-06 -1.7423168879043324e-10
+ 5.6938470650301819e-06 -9.0046498724308251e-10
+ 5.6940343152356828e-06 -1.2675598336250834e-09
+ 5.6942558650104237e-06 -1.390661486095478e-09
+ 5.6945540340925023e-06 -1.4079464626524889e-09
+ 5.694998769870886e-06 -1.3781166774969621e-09
+ 5.6958050039889933e-06 -1.313948994893242e-09
+ 5.6967117643683144e-06 -1.2450592154006523e-09
+ 5.6977374756864399e-06 -1.1711746826522686e-09
+ 5.6988011434023415e-06 -1.0985374417948889e-09
+ 5.6999447649495455e-06 -1.0244977902794022e-09
+ 5.7022316462789094e-06 -8.876839903243166e-10
+ 5.704182681216658e-06 -7.8153991862173163e-10
+ 5.706291228517249e-06 -6.7660226349856925e-10
+ 5.7085814674361589e-06 -5.7299433820914436e-10
+ 5.7109266668500228e-06 -4.7698621811411996e-10
+ 5.7132718662638866e-06 -3.901690868650475e-10
+ 5.7155905371796301e-06 -3.1248869476676087e-10
+ 5.7184745694842792e-06 -2.2600941125466692e-10
+ 5.7213586017889282e-06 -1.4953972152878652e-10
+ 5.7242426340935773e-06 -8.1909642546355165e-11
+ 5.7271266663982263e-06 -2.2097231394821104e-11
+ 5.7300106987028754e-06 3.0804763949844941e-11
+ 5.7328947310075244e-06 7.7599184420572088e-11
+ 5.7357787633121735e-06 1.1899177680085989e-10
+ 5.7393427976635931e-06 1.6360497315690482e-10
+ 5.7429068320150127e-06 2.0194460469335925e-10
+ 5.7464708663664323e-06 2.3489304324568193e-10
+ 5.7500349007178519e-06 2.6320792465228799e-10
+ 5.7535989350692715e-06 2.8754418863776942e-10
+ 5.7578999611273604e-06 3.124003450031708e-10
+ 5.7622009871854493e-06 3.3310188136055884e-10
+ 5.7665020132435382e-06 3.5034335018174361e-10
+ 5.7708030393016272e-06 3.6470346013268147e-10
+ 5.7751040653597161e-06 3.7666442373221598e-10
+ 5.7805025059869823e-06 3.8888313831481749e-10
+ 5.7859009466142486e-06 3.9859542479219459e-10
+ 5.7912993872415149e-06 4.0629545583254085e-10
+ 5.7966978278687811e-06 4.1242659596079512e-10
+ 5.8034682476574688e-06 4.1836450212166619e-10
+ 5.8102386674461564e-06 4.228142873871682e-10
+ 5.8170090872348441e-06 4.2614500842071573e-10
+ 5.8253853043439566e-06 4.2912633403108892e-10
+ 5.833761521453069e-06 4.3120345772378355e-10
+ 5.8421377385621815e-06 4.3264838822889765e-10
+ 5.8530433854886557e-06 4.3388610175178318e-10
+ 5.8639490324151299e-06 4.3464666000495187e-10
+ 5.8761560636651302e-06 4.3514763453961883e-10
+ 5.8883630949151306e-06 4.3542384097085643e-10
+ 5.9005701261651309e-06 4.3556624282357159e-10
+ 5.9127771574151313e-06 4.3562884855868211e-10
+ 5.9249841886651316e-06 4.3564390919099658e-10
+ 5.937191219915132e-06 4.3563071731303817e-10
+ 5.9493982511651323e-06 4.3560072832369711e-10
+ 5.9616052824151327e-06 4.3556071800624522e-10
+ 5.973812313665133e-06 4.3551473285478916e-10
+ 5.9860193449151334e-06 4.3546520640556509e-10
+ 5.9982263761651337e-06 4.3541358487496968e-10
+ 6.0104334074151341e-06 4.3536071753580087e-10
+ 6.0226404386651344e-06 4.353071102954193e-10
+ 6.0348474699151348e-06 4.3525307030070124e-10
+ 6.0470545011651351e-06 4.3519878102624261e-10
+ 6.0592615324151355e-06 4.3514434891989702e-10
+ 6.0714685636651358e-06 4.3508983678706616e-10
+ 6.0836755949151362e-06 4.3503528333983576e-10
+ 6.0958826261651365e-06 4.3498071205926307e-10
+ 6.1080896574151369e-06 4.3492613633167183e-10
+ 6.1202966886651372e-06 4.348715638520445e-10
+ 6.1325037199151376e-06 4.3481699946235471e-10
+ 6.1447107511651379e-06 4.3476244620745766e-10
+ 6.1569177824151383e-06 4.3470790578886986e-10
+ 6.1691248136651386e-06 4.3465337912630206e-10
+ 6.181331844915139e-06 4.3459886680952396e-10
+ 6.1935388761651393e-06 4.3454436923774573e-10
+ 6.2057459074151397e-06 4.3448988663097442e-10
+ 6.21795293866514e-06 4.3443541909242035e-10
+ 6.2301599699151404e-06 4.3438096668679938e-10
+ 6.2423670011651407e-06 4.3432652946422885e-10
+ 6.2500000000000003e-06 4.3429323819786375e-10
+ 6.2622070312500006e-06 4.3423882549145797e-10
+ 6.2744140625000002e-06 4.3418442800650571e-10
+ 6.2866210937500005e-06 4.3413004574565444e-10
+ 6.298828125e-06 4.3407567870875607e-10
+ 6.3110351562500004e-06 4.3402132689399754e-10
+ 6.3232421875000007e-06 4.3396699029857563e-10
+ 6.3354492187500002e-06 4.3391266891909689e-10
+ 6.3476562500000006e-06 4.338583627518177e-10
+ 6.3598632812500001e-06 4.338040717927861e-10
+ 6.3720703125000004e-06 4.3374979603792648e-10
+ 6.3842773437499999e-06 4.3369553548309005e-10
+ 6.3964843750000003e-06 4.3364129012408513e-10
+ 6.4086914062500006e-06 4.3358705995669485e-10
+ 6.4208984375000001e-06 4.3353284497668784e-10
+ 6.4331054687500005e-06 4.3347864517982436e-10
+ 6.4453125e-06 4.3342446056186068e-10
+ 6.4575195312500003e-06 4.3337029111855061e-10
+ 6.4697265625000007e-06 4.3331613684564742e-10
+ 6.4819335937500002e-06 4.3326199773890431e-10
+ 6.4941406250000005e-06 4.3320787379407488e-10
+ 6.50634765625e-06 4.3315376500691365e-10
+ 6.5185546875000004e-06 4.3309967137317592e-10
+ 6.5307617187500007e-06 4.3304559288861817e-10
+ 6.5429687500000002e-06 4.3299152954899793e-10
+ 6.5551757812500006e-06 4.3293748135007384e-10
+ 6.5673828125000001e-06 4.3288344828760572e-10
+ 6.5795898437500004e-06 4.3282943035735457e-10
+ 6.5917968749999999e-06 4.3277542755508266e-10
+ 6.6040039062500003e-06 4.327214398765532e-10
+ 6.6162109374999998e-06 4.3266746731753079e-10
+ 6.6284179687500001e-06 4.3261350987378112e-10
+ 6.6406250000000005e-06 4.3255956754107106e-10
+ 6.65283203125e-06 4.3250564031516869e-10
+ 6.6650390625000003e-06 4.324517281918434e-10
+ 6.6772460937499998e-06 4.3239783116686546e-10
+ 6.6894531250000002e-06 4.3234394923600652e-10
+ 6.7016601562499997e-06 4.3229008239503964e-10
+ 6.7138671875e-06 4.322362306397386e-10
+ 6.7260742187499995e-06 4.3218239396587857e-10
+ 6.7382812499999999e-06 4.3212857236923607e-10
+ 6.7504882812500002e-06 4.3207476584558855e-10
+ 6.7626953124999997e-06 4.3202097439071481e-10
+ 6.7749023437500001e-06 4.3196719800039462e-10
+ 6.7871093750000004e-06 4.3191343667040926e-10
+ 6.7993164062499999e-06 4.3185969039654094e-10
+ 6.8115234375000003e-06 4.3180595917457319e-10
+ 6.8237304687500006e-06 4.3175224300029046e-10
+ 6.8359375000000001e-06 4.3169854186947872e-10
+ 6.8481445312500005e-06 4.3164485577792515e-10
+ 6.8603515625e-06 4.3159118472141752e-10
+ 6.8725585937500003e-06 4.315375286957455e-10
+ 6.8847656250000007e-06 4.3148388769669956e-10
+ 6.8969726562500002e-06 4.3143026172007142e-10
+ 6.9091796875000005e-06 4.3137665076165393e-10
+ 6.92138671875e-06 4.3132305481724119e-10
+ 6.9335937500000004e-06 4.3126947388262849e-10
+ 6.9458007812500007e-06 4.3121590795361226e-10
+ 6.9580078125000003e-06 4.3116235702599014e-10
+ 6.9702148437500006e-06 4.311088210955608e-10
+ 6.982421875000001e-06 4.3105530015812432e-10
+ 6.9946289062500005e-06 4.3100179420948178e-10
+ 7.0068359375000008e-06 4.3094830324543561e-10
+ 7.0190429687500012e-06 4.3089482726178914e-10
+ 7.0312500000000007e-06 4.3084136625434698e-10
+ 7.043457031250001e-06 4.3078792021891527e-10
+ 7.0556640625000005e-06 4.3073448915130076e-10
+ 7.0678710937500009e-06 4.3068107304731183e-10
+ 7.0800781250000012e-06 4.3062767190275767e-10
+ 7.0922851562500007e-06 4.3057428571344897e-10
+ 7.1044921875000011e-06 4.305209144751974e-10
+ 7.1166992187500006e-06 4.3046755818381573e-10
+ 7.1289062500000009e-06 4.3041421683511815e-10
+ 7.1411132812500013e-06 4.3036089042491982e-10
+ 7.1533203125000008e-06 4.3030757894903721e-10
+ 7.1655273437500011e-06 4.3025428240328784e-10
+ 7.1777343750000015e-06 4.3020100078349046e-10
+ 7.189941406250001e-06 4.3014773408546503e-10
+ 7.2021484375000013e-06 4.3009448230503257e-10
+ 7.2143554687500017e-06 4.3004124543801536e-10
+ 7.2265625000000012e-06 4.2998802348023685e-10
+ 7.2387695312500007e-06 4.2993481642752165e-10
+ 7.250976562500001e-06 4.298816242756955e-10
+ 7.2631835937500014e-06 4.2982844702058526e-10
+ 7.2753906250000009e-06 4.2977528465801911e-10
+ 7.2875976562500004e-06 4.2972213718382639e-10
+ 7.2998046875000007e-06 4.296690045938374e-10
+ 7.3120117187500011e-06 4.2961588688388387e-10
+ 7.3242187500000006e-06 4.2956278404979846e-10
+ 7.3364257812500001e-06 4.2950969608741529e-10
+ 7.3486328125000004e-06 4.2945662299256918e-10
+ 7.3608398437500008e-06 4.2940356476109669e-10
+ 7.3730468750000003e-06 4.2935052138883517e-10
+ 7.3852539062499998e-06 4.2929749287162315e-10
+ 7.3974609375000001e-06 4.2924447920530045e-10
+ 7.4096679687500005e-06 4.2919148038570803e-10
+ 7.421875e-06 4.2913849640868801e-10
+ 7.4340820312499995e-06 4.2908552727008359e-10
+ 7.4462890624999998e-06 4.2903257296573924e-10
+ 7.4584960937500002e-06 4.2897963349150058e-10
+ 7.4707031249999997e-06 4.2892670884321429e-10
+ 7.4829101562499992e-06 4.288737990167283e-10
+ 7.4951171874999995e-06 4.2882090400789185e-10
+ 7.5073242187499999e-06 4.2876802381255504e-10
+ 7.5195312499999994e-06 4.2871515842656934e-10
+ 7.5317382812499989e-06 4.2866230784578723e-10
+ 7.5439453124999992e-06 4.2860947206606246e-10
+ 7.5561523437499996e-06 4.2855665108325002e-10
+ 7.5683593749999991e-06 4.2850384489320595e-10
+ 7.5805664062499986e-06 4.2845105349178732e-10
+ 7.592773437499999e-06 4.2839827687485269e-10
+ 7.6049804687499993e-06 4.2834551503826145e-10
+ 7.6171874999999988e-06 4.2829276797787439e-10
+ 7.6293945312499983e-06 4.2824003568955333e-10
+ 7.6416015624999987e-06 4.2818731816916134e-10
+ 7.653808593749999e-06 4.2813461541256231e-10
+ 7.6660156249999994e-06 4.2808192741562203e-10
+ 7.678222656249998e-06 4.2802925417420679e-10
+ 7.6904296874999984e-06 4.2797659568418397e-10
+ 7.7026367187499987e-06 4.2792395194142275e-10
+ 7.7148437499999974e-06 4.2787132294179297e-10
+ 7.7270507812499977e-06 4.2781870868116553e-10
+ 7.7392578124999981e-06 4.2776610915541303e-10
+ 7.7514648437499984e-06 4.2771352436040875e-10
+ 7.7636718749999988e-06 4.2766095429202714e-10
+ 7.7758789062499974e-06 4.2760839894614423e-10
+ 7.7880859374999978e-06 4.2755585831863669e-10
+ 7.8002929687499981e-06 4.2750333240538267e-10
+ 7.8124999999999968e-06 4.2745082120226136e-10
+ 7.8247070312499971e-06 4.2739832470515305e-10
+ 7.8369140624999975e-06 4.273458429099393e-10
+ 7.8491210937499978e-06 4.2729337581250278e-10
+ 7.8613281249999982e-06 4.2724092340872732e-10
+ 7.8735351562499968e-06 4.2718848569449787e-10
+ 7.8857421874999972e-06 4.2713606266570053e-10
+ 7.8979492187499975e-06 4.2708365431822263e-10
+ 7.9101562499999962e-06 4.270312606479525e-10
+ 7.9223632812499965e-06 4.2697888165077988e-10
+ 7.9345703124999969e-06 4.2692651732259529e-10
+ 7.9467773437499972e-06 4.2687416765929084e-10
+ 7.9589843749999976e-06 4.2682183265675928e-10
+ 7.9711914062499962e-06 4.2676951231089505e-10
+ 7.9833984374999966e-06 4.2671720661759342e-10
+ 7.9956054687499969e-06 4.2666491557275079e-10
+ 8.0078124999999956e-06 4.2661263917226478e-10
+ 8.0200195312499959e-06 4.265603774120343e-10
+ 8.0322265624999963e-06 4.265081302879591e-10
+ 8.0444335937499966e-06 4.2645589779594043e-10
+ 8.056640624999997e-06 4.2640367993188038e-10
+ 8.0688476562499956e-06 4.2635147669168246e-10
+ 8.081054687499996e-06 4.2629928807125108e-10
+ 8.0932617187499963e-06 4.2624711406649186e-10
+ 8.105468749999995e-06 4.2619495467331169e-10
+ 8.1176757812499954e-06 4.2614280988761856e-10
+ 8.1298828124999957e-06 4.2609067970532156e-10
+ 8.1420898437499961e-06 4.2603856412233079e-10
+ 8.1542968749999964e-06 4.2598646313455786e-10
+ 8.1665039062499951e-06 4.2593437673791515e-10
+ 8.1787109374999954e-06 4.2588230492831644e-10
+ 8.1909179687499958e-06 4.2583024770167654e-10
+ 8.2031249999999944e-06 4.2577820505391141e-10
+ 8.2153320312499948e-06 4.2572617698093814e-10
+ 8.2275390624999951e-06 4.2567416347867499e-10
+ 8.2397460937499955e-06 4.2562216454304139e-10
+ 8.2519531249999958e-06 4.2557018016995789e-10
+ 8.2641601562499945e-06 4.2551821035534623e-10
+ 8.2763671874999948e-06 4.2546625509512913e-10
+ 8.2885742187499952e-06 4.254143143852306e-10
+ 8.3007812499999938e-06 4.2536238822157581e-10
+ 8.3129882812499942e-06 4.2531047660009089e-10
+ 8.3251953124999945e-06 4.2525857951670346e-10
+ 8.3374023437499949e-06 4.252066969673418e-10
+ 8.3496093749999952e-06 4.2515482894793579e-10
+ 8.3618164062499939e-06 4.2510297545441604e-10
+ 8.3740234374999942e-06 4.2505113648271467e-10
+ 8.3862304687499946e-06 4.2499931202876474e-10
+ 8.3984374999999932e-06 4.2494750208850055e-10
+ 8.4106445312499936e-06 4.248957066578573e-10
+ 8.4228515624999939e-06 4.2482519493572964e-10
+ 8.4350585937499943e-06 4.2475256100502045e-10
+ 8.4472656249999946e-06 4.2468173951608737e-10
+ 8.4594726562499933e-06 4.2459666096075283e-10
+ 8.4716796874999936e-06 4.2448010616874532e-10
+ 8.483886718749994e-06 4.242745676347303e-10
+ 8.4899902343749933e-06 4.2406762246865748e-10
+ 8.4960937499999926e-06 4.2364446431160585e-10
+ 8.499145507812494e-06 4.2320637096990359e-10
+ 8.5021972656249937e-06 4.2237081875579266e-10
+ 8.5052490234374933e-06 4.2039912634768696e-10
+ 8.5066067907740868e-06 4.184858057925494e-10
+ 8.5069982166608614e-06 4.1769354662518729e-10
+ 8.507389642547636e-06 4.1673967866159501e-10
+ 8.5083682072645734e-06 4.1328644574257995e-10
+ 8.5094095029081855e-06 4.0647792025774505e-10
+ 8.5099705987353213e-06 4.0009399586852752e-10
+ 8.5103396292983667e-06 3.9400830485401903e-10
+ 8.5111103238158418e-06 3.7217296598144555e-10
+ 8.5117414812338482e-06 3.3482378565862255e-10
+ 8.5121130840090089e-06 2.9476725253157392e-10
+ 8.5124341937957882e-06 2.3913652951300332e-10
+ 8.5126470979254103e-06 2.1273235713088472e-10
+ 8.5128600020550324e-06 2.1207408791108858e-10
+ 8.5149890433512433e-06 2.1185023895337551e-10
+ 8.5271960746012437e-06 2.0757980032582087e-10
+ 8.539403105851244e-06 1.9827504053149293e-10
+ 8.5516101371012444e-06 1.8447156434439206e-10
+ 8.5638171683512447e-06 1.6696410651490149e-10
+ 8.5760241996012434e-06 1.4676018343964647e-10
+ 8.5882312308512438e-06 1.2502212943217047e-10
+ 8.6004382621012441e-06 1.0300022779102304e-10
+ 8.6126452933512428e-06 8.1960799754197404e-11
+ 8.6248523246012431e-06 6.311338755160194e-11
+ 8.6370593558512435e-06 4.7541218733423125e-11
+ 8.6492663871012438e-06 3.6138949326912032e-11
+ 8.6614734183512442e-06 2.9561263935700322e-11
+ 8.6736804496012428e-06 2.8185285811614418e-11
+ 8.6858874808512432e-06 3.2088955187765566e-11
+ 8.6980945121012435e-06 4.1046615499322252e-11
+ 8.7103015433512422e-06 5.4542057385810135e-11
+ 8.7225085746012425e-06 7.1798266491615728e-11
+ 8.7347156058512429e-06 9.1822160785597292e-11
+ 8.7469226371012432e-06 1.1346174161334856e-10
+ 8.7591296683512436e-06 1.3547236949090519e-10
+ 8.7713366996012422e-06 1.5658835172212636e-10
+ 8.7835437308512426e-06 1.7559572435646284e-10
+ 8.7957507621012429e-06 1.9140204326212496e-10
+ 8.8079577933512416e-06 2.030991720132836e-10
+ 8.8110095511637429e-06 2.0529687447679853e-10
+ 8.8113147269449932e-06 2.0549982177660819e-10
+ 8.8120776663981165e-06 2.0599366009052315e-10
+ 8.8124591361246798e-06 2.062333046850057e-10
+ 8.812482977982589e-06 2.0624812098499301e-10
+ 8.8124877463541726e-06 2.0625108196291897e-10
+ 8.8124972830973363e-06 2.0625700163649109e-10
+ 8.8124980460367881e-06 2.0625747507891284e-10
+ 8.8124995719156953e-06 2.0625842190532621e-10
+ 8.8124996939860077e-06 2.0625849764807365e-10
+ 8.8124999381266326e-06 2.0625864913207268e-10
+ 8.8124999576578825e-06 2.0625866125070641e-10
+ 8.8124999967203824e-06 2.0625868548793557e-10
+ 8.812500074845382e-06 8.3574849775232329e-10
+ 8.8125001529703817e-06 2.8382408459534785e-09
+ 8.8125009342203786e-06 9.7910663945931592e-08
+ 8.8125080518459746e-06 6.9281309170090845e-06
+ 8.8125151694715705e-06 2.3496919613390592e-05
+ 8.8125222870971665e-06 4.8515586154137975e-05
+ 8.8125294047227642e-06 8.0864107426474553e-05
+ 8.8125365223483601e-06 0.0001195688537478285
+ 8.8125436399739561e-06 0.00016378325676260678
+ 8.8125507575995538e-06 0.00021277103077073492
+ 8.8125578752251497e-06 0.00026589161027525284
+ 8.8125649928507457e-06 0.00032258751106878353
+ 8.8125721104763416e-06 0.00038237336083026571
+ 8.8125792281019376e-06 0.00044482637875059637
+ 8.8125878075685696e-06 0.00052313156179263198
+ 8.8125963870352017e-06 0.00060422377214069478
+ 8.8126049665018337e-06 0.00068763160407692863
+ 8.8126135459684657e-06 0.00077295453496090106
+ 8.8126221254350978e-06 0.00085985181282763258
+ 8.8126307049017298e-06 0.00094803308914625053
+ 8.8126392843683618e-06 0.0010372505228311898
+ 8.8126478638349939e-06 0.0011272921245865509
+ 8.8126581807702509e-06 0.0012364048498757886
+ 8.8126684977055046e-06 0.0013461799437633384
+ 8.8126788146407617e-06 0.0014563930288477433
+ 8.8126891315760154e-06 0.001566855276772596
+ 8.8126994485112725e-06 0.0016774068636345029
+ 8.8127097654465262e-06 0.001787911643031166
+ 8.8127200823817833e-06 0.0018982528107135616
+ 8.812730399317037e-06 0.0020083293767566338
+ 8.8127429020122577e-06 0.002141246780886198
+ 8.8127554047074768e-06 0.0022735106700283729
+ 8.8127679074026959e-06 0.0024050029041599369
+ 8.8127804100979166e-06 0.0025356196305195535
+ 8.8127929127931357e-06 0.0026652683340791378
+ 8.8128054154883547e-06 0.002793865545581445
+ 8.8128179181835738e-06 0.0029213350620943554
+ 8.8128304208787928e-06 0.0030476065669750823
+ 8.8128455922538743e-06 0.0031991277392290247
+ 8.8128607636289525e-06 0.0033486794005026179
+ 8.812875935004034e-06 0.0034961593179601309
+ 8.8128911063791121e-06 0.0036414711081661105
+ 8.8129062777541936e-06 0.0037845233735065873
+ 8.8129214491292718e-06 0.0039252290818992874
+ 8.8129366205043533e-06 0.0040635051254073566
+ 8.8129548605195593e-06 0.0042264209820281088
+ 8.812973100534767e-06 0.0043855785109888799
+ 8.8129913405499748e-06 0.004540852807539594
+ 8.8130095805651808e-06 0.0046921255232483241
+ 8.8130278205803885e-06 0.004839284756390172
+ 8.8130460605955962e-06 0.0049822250059800644
+ 8.8130681998658446e-06 0.0051499118748984281
+ 8.8130903391360929e-06 0.0053110729761570875
+ 8.813112478406343e-06 0.0054655577982168782
+ 8.8131346176765913e-06 0.0056132299331846198
+ 8.8131612930113179e-06 0.0057819364493443522
+ 8.8131878730958072e-06 0.0059398423573548687
+ 8.8132144531802964e-06 0.0060874136176253622
+ 8.8132486884843395e-06 0.0062620603819550135
+ 8.8132829237883827e-06 0.0064191641307141745
+ 8.8133153561270475e-06 0.0065517091134031152
+ 8.8133477884657107e-06 0.0066683776453289999
+ 8.8133802208043738e-06 0.0067692021882621509
+ 8.8134126531430387e-06 0.0068542763543729904
+ 8.8134450854817019e-06 0.0069237529436825757
+ 8.813477517820365e-06 0.0069778416850672731
+ 8.8135099501590282e-06 0.0070168067033145008
+ 8.8135423824976913e-06 0.0070409637367341727
+ 8.8135695849981466e-06 0.0070500711051410814
+ 8.8135967874985984e-06 0.0070492564131712353
+ 8.8136239899990536e-06 0.0070387804986578604
+ 8.8136511924995055e-06 0.0070189238317284377
+ 8.8136783949999607e-06 0.0069899850256677273
+ 8.8137055975004125e-06 0.0069522793135452206
+ 8.8137328000008678e-06 0.0069061369988542495
+ 8.8137600025013196e-06 0.0068519018883273245
+ 8.8137872050017748e-06 0.0067899297149596706
+ 8.8138144075022267e-06 0.0067205865590935169
+ 8.8138416100026819e-06 0.0066442472751925379
+ 8.8138688125031337e-06 0.006561293931672073
+ 8.8138960150035889e-06 0.0064721142708494637
+ 8.8139232175040408e-06 0.0063771001957435066
+ 8.813950420004496e-06 0.0062766462900859356
+ 8.8139776225049478e-06 0.0061711483775146155
+ 8.8140048250054031e-06 0.0060610021255013743
+ 8.8140320275058549e-06 0.0059466016991306979
+ 8.8140592300063101e-06 0.0058283384693926773
+ 8.814086432506762e-06 0.0057065997804302861
+ 8.8141153008834978e-06 0.0055740309990659331
+ 8.8141441692602336e-06 0.0054384272991202893
+ 8.8141730376369677e-06 0.0053002282345430132
+ 8.8142019060137018e-06 0.0051598626838551204
+ 8.8142307743904376e-06 0.0050177476630414884
+ 8.8142596427671734e-06 0.0048742872442221231
+ 8.8142885111439075e-06 0.0047298715812966012
+ 8.8143173795206416e-06 0.0045848760430473451
+ 8.8143462478973774e-06 0.0044396604535071188
+ 8.8143811351666814e-06 0.0042643637747592994
+ 8.8144160224359871e-06 0.0040898203879790361
+ 8.8144499855060499e-06 0.0039211359224094145
+ 8.8144839485761127e-06 0.0037541355090310092
+ 8.8145179116461755e-06 0.0035892460195200843
+ 8.8145518747162383e-06 0.0034268598627977894
+ 8.8145858377863011e-06 0.0032673350066711841
+ 8.8146273810828173e-06 0.0030765664536155394
+ 8.8146689243793318e-06 0.0028910852643209248
+ 8.814710467675848e-06 0.0027113416169293153
+ 8.8147520109723642e-06 0.0025377141992044784
+ 8.8148023225230984e-06 0.0023360685105670866
+ 8.8148531251736352e-06 0.0021424443576868821
+ 8.8149039278241703e-06 0.001959156496722657
+ 8.8149716072662465e-06 0.0017313192252947558
+ 8.815039286708321e-06 0.0015222190408349249
+ 8.8150919193965661e-06 0.001372431253814393
+ 8.8151445520848112e-06 0.0012336381966261724
+ 8.8151971847730563e-06 0.0011055447342070166
+ 8.8152498174612997e-06 0.00098778684645394604
+ 8.8152978099291029e-06 0.00088906516794052203
+ 8.8153458023969061e-06 0.00079823747715313789
+ 8.8153937948647076e-06 0.00071492972227882204
+ 8.8154417873325108e-06 0.00063875107498295779
+ 8.815489779800314e-06 0.00056929990178360005
+ 8.8155372615548634e-06 0.00050680910974394439
+ 8.8155847433094128e-06 0.00045011010916966049
+ 8.8156322250639606e-06 0.00039881145821643485
+ 8.81567970681851e-06 0.00035252854906615789
+ 8.8157271885730594e-06 0.00031088653907439246
+ 8.8157746703276071e-06 0.0002735227890958723
+ 8.8158243585833651e-06 0.00023862511600889196
+ 8.8158740468391215e-06 0.00020765025205703798
+ 8.8159237350948778e-06 0.00018023763188315632
+ 8.8159734233506359e-06 0.00015604795426756195
+ 8.8160231116063922e-06 0.0001347637411803884
+ 8.8160727998621485e-06 0.00011608953467670693
+ 8.8161279513860738e-06 9.8086983151495662e-05
+ 8.8161831029100008e-06 8.2620379659707852e-05
+ 8.8162382544339278e-06 6.937830638173144e-05
+ 8.8162934059578531e-06 5.8079646203919961e-05
+ 8.8163485574817784e-06 4.8471998343402797e-05
+ 8.8164116405205389e-06 3.9267448447275403e-05
+ 8.8164747235592976e-06 3.1683839518460041e-05
+ 8.8165378065980564e-06 2.5463033689023789e-05
+ 8.8166008896368169e-06 2.0382309617297274e-05
+ 8.8166741401464245e-06 1.5662206653736814e-05
+ 8.8167473906560355e-06 1.1971024407425274e-05
+ 8.816820641165643e-06 9.101093726216712e-06
+ 8.8169056194215831e-06 6.5781195004269459e-06
+ 8.8169905976775231e-06 4.7207090840830405e-06
+ 8.817093836844784e-06 3.1245246960755978e-06
+ 8.8171981717694137e-06 2.0371887602864823e-06
+ 8.8173025066940417e-06 1.3141391771344707e-06
+ 8.8174266644691637e-06 7.6923430377838728e-07
+ 8.8175508222442858e-06 4.435788450454647e-07
+ 8.8177058008065314e-06 2.1851475951109054e-07
+ 8.8178849371317862e-06 9.3708673373505121e-08
+ 8.8180985566023893e-06 3.2883700516734768e-08
+ 8.8183644857229527e-06 8.5309004428172277e-09
+ 8.8187179827122033e-06 1.4552417250701691e-09
+ 8.819242097564145e-06 3.0578689270965244e-10
+ 8.8201363401204749e-06 2.4569663308855879e-10
+ 8.8221328071850351e-06 2.4259754686171839e-10
+ 8.8239888168580162e-06 2.4182034068072913e-10
+ 8.8264216684430788e-06 2.4138174969930913e-10
+ 8.8288545200281432e-06 2.4076582964276258e-10
+ 8.8312873716132058e-06 2.4012576594620444e-10
+ 8.8337202231982701e-06 2.4057963384973803e-10
+ 8.8361530747833327e-06 2.4092919901400983e-10
+ 8.838585926368397e-06 2.401872610697499e-10
+ 8.8410187779534596e-06 2.3987554496708928e-10
+ 8.8434516295385239e-06 2.4037942571475707e-10
+ 8.8457677052397799e-06 2.4025247901632375e-10
+ 8.8488194404067182e-06 2.4017887589128354e-10
+ 8.8518711755736565e-06 2.4009951114703349e-10
+ 8.8549229107405965e-06 2.4004351142745323e-10
+ 8.8579746459075348e-06 2.4016098617015712e-10
+ 8.8610263810744731e-06 2.4071442426522539e-10
+ 8.8640781162414131e-06 2.3968616681674537e-10
+ 8.8677736187735984e-06 2.4003007462135484e-10
+ 8.8711342886109085e-06 2.4006402385879101e-10
+ 8.8744949584482185e-06 2.4006047129867007e-10
+ 8.8786207316902784e-06 2.4005210497337081e-10
+ 8.8827465049323366e-06 2.4004042399080182e-10
+ 8.8868722781743965e-06 2.4003044384477591e-10
+ 8.8909980514164547e-06 2.4003749578386358e-10
+ 8.8951238246585145e-06 2.4008180521387353e-10
+ 8.9002511384370958e-06 2.4016443526047099e-10
+ 8.9053784522156788e-06 2.3985136550844345e-10
+ 8.9105057659942601e-06 2.3994252727381691e-10
+ 8.9156330797728431e-06 2.4004700010028028e-10
+ 8.9219959798251518e-06 2.4004483697536087e-10
+ 8.9283588798774604e-06 2.3997024527683999e-10
+ 8.9347217799297691e-06 2.3997592655072043e-10
+ 8.9424972562545102e-06 2.4000749931504923e-10
+ 8.9502727325792514e-06 2.4001269631983051e-10
+ 8.9580482089039925e-06 2.3999782508278659e-10
+ 8.967983441936067e-06 2.3999355892689472e-10
+ 8.9779186749681415e-06 2.4000179472492324e-10
+ 8.9901257062181419e-06 2.4000339716614338e-10
+ 9.0023327374681422e-06 2.3999888202599127e-10
+ 9.0145397687181409e-06 2.3999830525938688e-10
+ 9.0267467999681412e-06 2.4000037974237526e-10
+ 9.0389538312181416e-06 2.4000087414852165e-10
+ 9.0511608624681419e-06 2.3999993966201389e-10
+ 9.0633678937181423e-06 2.3999960494882817e-10
+ 9.0755749249681409e-06 2.4000001432309894e-10
+ 9.0877819562181413e-06 2.4000021737723387e-10
+ 9.0999889874681416e-06 2.4000004462513988e-10
+ 9.1121960187181403e-06 2.3999993006727966e-10
+ 9.1244030499681406e-06 2.3999999917748096e-10
+ 9.136610081218141e-06 2.4000006049017395e-10
+ 9.1488171124681413e-06 2.4000003421757239e-10
+ 9.1610241437181417e-06 2.4000000237870328e-10
+ 9.1732311749681404e-06 2.4000001256652595e-10
+ 9.1854382062181407e-06 2.4000002745854788e-10
+ 9.1976452374681411e-06 2.4000002475271839e-10
+ 9.2098522687181397e-06 2.4000001795384735e-10
+ 9.2220592999681401e-06 2.400000173879749e-10
+ 9.2342663312181404e-06 2.4000002070407596e-10
+ 9.2464733624681408e-06 2.4000002067419452e-10
+ 9.2586803937181411e-06 2.4000001976473751e-10
+ 9.2708874249681398e-06 2.40000019362722e-10
+ 9.2830944562181401e-06 2.4000002028128461e-10
+ 9.2953014874681405e-06 2.4000002060646208e-10
+ 9.3075085187181391e-06 2.4000002008287723e-10
+ 9.3197155499681395e-06 2.4000001934276911e-10
+ 9.3319225812181398e-06 2.4000001968966948e-10
+ 9.3441296124681402e-06 2.4000002093381111e-10
+ 9.3563366437181405e-06 2.4000001965726013e-10
+ 9.3685436749681392e-06 2.4000001961507071e-10
+ 9.3807507062181395e-06 2.4000002048512451e-10
+ 9.3929577374681399e-06 2.4000001998121006e-10
+ 9.4051647687181385e-06 2.400000199764228e-10
+ 9.4173717999681389e-06 2.4000001998665694e-10
+ 9.4295788312181392e-06 2.4000001988395378e-10
+ 9.4417858624681396e-06 2.4000001969840786e-10
+ 9.4539928937181399e-06 2.4000001962628526e-10
+ 9.4661999249681386e-06 2.4000001985975601e-10
+ 9.4784069562181389e-06 2.4000001994562599e-10
+ 9.4906139874681393e-06 2.4000001873790616e-10
+ 9.5028210187181379e-06 2.400000206888198e-10
+ 9.5150280499681383e-06 2.4000002115772409e-10
+ 9.5272350812181386e-06 2.4000001926167516e-10
+ 9.539442112468139e-06 2.4000001865095655e-10
+ 9.5516491437181393e-06 2.4000002024868279e-10
+ 9.563856174968138e-06 2.4000002062807212e-10
+ 9.5760632062181383e-06 2.4000001971246058e-10
+ 9.5882702374681387e-06 2.4000001913611468e-10
+ 9.6004772687181373e-06 2.4000001939609548e-10
+ 9.6126842999681377e-06 2.4000001928925776e-10
+ 9.624891331218138e-06 2.4000002036211893e-10
+ 9.6370983624681384e-06 2.4000001948566678e-10
+ 9.6493053937181387e-06 2.40000020557049e-10
+ 9.6615124249681374e-06 2.400000203491446e-10
+ 9.6737194562181377e-06 2.4000001961720044e-10
+ 9.6859264874681381e-06 2.400000200808237e-10
+ 9.6981335187181368e-06 2.4000002006495584e-10
+ 9.7103405499681371e-06 2.4000001941755901e-10
+ 9.7225475812181375e-06 2.4000001925514504e-10
+ 9.7347546124681378e-06 2.4000001949494439e-10
+ 9.7469616437181382e-06 2.4000001987457185e-10
+ 9.7591686749681368e-06 2.4000001956535886e-10
+ 9.7713757062181372e-06 2.4000001976899341e-10
+ 9.7835827374681375e-06 2.4000001989767335e-10
+ 9.7957897687181362e-06 2.4000002010421042e-10
+ 9.8079967999681365e-06 2.4000002031692612e-10
+ 9.8202038312181369e-06 2.4000001943796074e-10
+ 9.8324108624681372e-06 2.4000001979057998e-10
+ 9.8446178937181376e-06 2.4000001994141042e-10
+ 9.8568249249681362e-06 2.4000001910787902e-10
+ 9.8690319562181366e-06 2.4000002014157438e-10
+ 9.8812389874681369e-06 2.4000002007976212e-10
+ 9.8934460187181356e-06 2.4000001897875313e-10
+ 9.9056530499681359e-06 2.4000002030066949e-10
+ 9.9178600812181363e-06 2.4000002070432142e-10
+ 9.9300671124681366e-06 2.4000001950520541e-10
+ 9.942274143718137e-06 2.4000001947980057e-10
+ 9.9544811749681356e-06 2.4000002027253361e-10
+ 9.966688206218136e-06 2.40000020609859e-10
+ 9.9788952374681363e-06 2.4000001911322354e-10
+ 9.991102268718135e-06 2.4000001969739074e-10
+ 1.0003309299968135e-05 2.4000002073053612e-10
+ 1.0015516331218136e-05 2.4000001994814067e-10
+ 1.0027723362468136e-05 2.4000001923239209e-10
+ 1.0039930393718136e-05 2.4000002015288261e-10
+ 1.0052137424968135e-05 2.4000001930210656e-10
+ 1.0064344456218135e-05 2.4000001837686493e-10
+ 1.0076551487468136e-05 2.4000001946449939e-10
+ 1.0088758518718136e-05 2.4000002038326192e-10
+ 1.0100965549968136e-05 2.400000203109469e-10
+ 1.0113172581218137e-05 2.400000203952259e-10
+ 1.0125379612468137e-05 2.4000001970496741e-10
+ 1.0137586643718137e-05 2.4000001924454606e-10
+ 1.0149793674968138e-05 2.4000001905466872e-10
+ 1.0162000706218138e-05 2.400000204518705e-10
+ 1.0174207737468139e-05 2.4000002011557764e-10
+ 1.0186414768718139e-05 2.4000001946831419e-10
+ 1.0198621799968139e-05 2.4000001925940771e-10
+ 1.021082883121814e-05 2.4000001980987061e-10
+ 1.022303586246814e-05 2.4000002089319245e-10
+ 1.023524289371814e-05 2.4000001973823067e-10
+ 1.0247449924968141e-05 2.4000001879346328e-10
+ 1.0259656956218141e-05 2.4000001869932423e-10
+ 1.0271863987468141e-05 2.4000002074828773e-10
+ 1.0284071018718142e-05 2.4000001934026167e-10
+ 1.0296278049968142e-05 2.4000001952115826e-10
+ 1.0308485081218142e-05 2.4000001987859593e-10
+ 1.0320692112468143e-05 2.400000198982881e-10
+ 1.0332899143718143e-05 2.40000018977687e-10
+ 1.0345106174968143e-05 2.4000001970468766e-10
+ 1.0357313206218144e-05 2.4000001969944985e-10
+ 1.0369520237468144e-05 2.4000002027367879e-10
+ 1.0381727268718144e-05 2.4000001840031488e-10
+ 1.0393934299968145e-05 2.4000001957318321e-10
+ 1.0406141331218145e-05 2.400000188108562e-10
+ 1.0418348362468146e-05 2.4000002046679305e-10
+ 1.0430555393718146e-05 2.4000001950571268e-10
+ 1.0442762424968146e-05 2.4000001838116472e-10
+ 1.0454969456218147e-05 2.4000001853089837e-10
+ 1.0467176487468147e-05 2.4000002004811227e-10
+ 1.0479383518718147e-05 2.4000001966057371e-10
+ 1.0491590549968148e-05 2.4000001941089245e-10
+ 1.0503797581218148e-05 2.4000001913185568e-10
+ 1.0516004612468148e-05 2.4000001954838558e-10
+ 1.0528211643718149e-05 2.4000001920964592e-10
+ 1.0540418674968149e-05 2.4000001943469307e-10
+ 1.0552625706218149e-05 2.4000001866641258e-10
+ 1.056483273746815e-05 2.4000002020897109e-10
+ 1.057703976871815e-05 2.4000001940179987e-10
+ 1.058924679996815e-05 2.4000001993507329e-10
+ 1.0601453831218151e-05 2.4000002008198123e-10
+ 1.0613660862468151e-05 2.400000198005213e-10
+ 1.0625867893718151e-05 2.4000001916301211e-10
+ 1.0638074924968152e-05 2.4000001960280073e-10
+ 1.0650281956218152e-05 2.4000001963117276e-10
+ 1.0662488987468153e-05 2.400000196254434e-10
+ 1.0674696018718153e-05 2.4000002030623543e-10
+ 1.0686903049968153e-05 2.4000001985486468e-10
+ 1.0699110081218154e-05 2.4000001975560508e-10
+ 1.0711317112468154e-05 2.4000002002563028e-10
+ 1.0723524143718154e-05 2.4000001880683233e-10
+ 1.0735731174968155e-05 2.400000186107882e-10
+ 1.0747938206218155e-05 2.4000002026174485e-10
+ 1.0760145237468155e-05 2.4000001964579944e-10
+ 1.0772352268718156e-05 2.4000001869414737e-10
+ 1.0784559299968156e-05 2.4000002024855297e-10
+ 1.0796766331218156e-05 2.4000001886895933e-10
+ 1.0808973362468157e-05 2.4000001996539064e-10
+ 1.0821180393718157e-05 2.4000001852201533e-10
+ 1.0833387424968157e-05 2.4000001995376353e-10
+ 1.0845594456218158e-05 2.4000001885033681e-10
+ 1.0857801487468158e-05 2.400000202275795e-10
+ 1.0870008518718158e-05 2.4000001938682899e-10
+ 1.0882215549968159e-05 2.400000185286626e-10
+ 1.0894422581218159e-05 2.4000002021567022e-10
+ 1.090662961246816e-05 2.4000001929093104e-10
+ 1.091883664371816e-05 2.4000001945502139e-10
+ 1.093104367496816e-05 2.4000001849176264e-10
+ 1.0943250706218161e-05 2.4000001899160695e-10
+ 1.0955457737468161e-05 2.4000001908469775e-10
+ 1.0967664768718161e-05 2.4000002021320925e-10
+ 1.0979871799968162e-05 2.4000001986077044e-10
+ 1.0992078831218162e-05 2.4000001985660228e-10
+ 1.1004285862468162e-05 2.4000001982734366e-10
+ 1.1016492893718163e-05 2.4000001909394165e-10
+ 1.1028699924968163e-05 2.4000001971428865e-10
+ 1.1040906956218163e-05 2.4000001921042243e-10
+ 1.1053113987468164e-05 2.400000190589926e-10
+ 1.1065321018718164e-05 2.400000192770844e-10
+ 1.1077528049968164e-05 2.4000001876027354e-10
+ 1.1089735081218165e-05 2.4000001963225885e-10
+ 1.1101942112468165e-05 2.4000001898595255e-10
+ 1.1114149143718165e-05 2.4000001876650681e-10
+ 1.1126356174968166e-05 2.4000001955479303e-10
+ 1.1138563206218166e-05 2.400000192149284e-10
+ 1.1150770237468167e-05 2.4000001962818762e-10
+ 1.1162977268718167e-05 2.400000192259498e-10
+ 1.1175184299968167e-05 2.4000001958046752e-10
+ 1.1187391331218168e-05 2.4000001876653049e-10
+ 1.1199598362468168e-05 2.4000001901679062e-10
+ 1.1211805393718168e-05 2.4000001929188411e-10
+ 1.1224012424968169e-05 2.4000001878460593e-10
+ 1.1236219456218169e-05 2.4000001895149019e-10
+ 1.1248426487468169e-05 2.4000001953324466e-10
+ 1.126063351871817e-05 2.4000001930179932e-10
+ 1.127284054996817e-05 2.4000001867284628e-10
+ 1.128504758121817e-05 2.4000001876404646e-10
+ 1.1297254612468171e-05 2.4000001844012502e-10
+ 1.1309461643718171e-05 2.4000001847700822e-10
+ 1.1321668674968171e-05 2.4000001848915366e-10
+ 1.1333875706218172e-05 2.4000001847211049e-10
+ 1.1346082737468172e-05 2.4000001842583542e-10
+ 1.1358289768718172e-05 2.4000001874485954e-10
+ 1.1370496799968173e-05 2.4000001864470591e-10
+ 1.1382703831218173e-05 2.400000192645186e-10
+ 1.1394910862468173e-05 2.4000001911011029e-10
+ 1.1407117893718174e-05 2.400000189594016e-10
+ 1.1419324924968174e-05 2.4000001834385696e-10
+ 1.1431531956218175e-05 2.4000001923683012e-10
+ 1.1443738987468175e-05 2.4000002008098464e-10
+ 1.1455946018718175e-05 2.400000183211859e-10
+ 1.1468153049968176e-05 2.4000001983070817e-10
+ 1.1480360081218176e-05 2.4000001841550595e-10
+ 1.1492567112468176e-05 2.4000001987140726e-10
+ 1.1504774143718177e-05 2.4000001839799459e-10
+ 1.1516981174968177e-05 2.4000001979564812e-10
+ 1.1529188206218177e-05 2.4000001826400317e-10
+ 1.1541395237468178e-05 2.3996544537098469e-10
+ 1.1553602268718178e-05 2.3996256464191007e-10
+ 1.1565809299968178e-05 2.3996062147298765e-10
+ 1.1578016331218179e-05 2.399538992151035e-10
+ 1.1590223362468179e-05 2.3990864356794482e-10
+ 1.1602430393718179e-05 2.3980391697569448e-10
+ 1.161463742496818e-05 2.3960325885649169e-10
+ 1.1620740940593179e-05 2.3930636780140344e-10
+ 1.162684445621818e-05 2.3825018349924986e-10
+ 1.1629896214030681e-05 2.3664385617022961e-10
+ 1.1632947971843181e-05 2.313460144418538e-10
+ 1.1634473850749431e-05 2.2273712950258841e-10
+ 1.1635999729655681e-05 1.9502932447418286e-10
+ 1.1636991106889184e-05 1.3263414891107653e-10
+ 1.1637269733896242e-05 9.5672269136980181e-11
+ 1.16375483609033e-05 4.6113023016783446e-11
+ 1.163809883562797e-05 4.077304569289076e-11
+ 1.1640875273912434e-05 4.2347131994264368e-11
+ 1.1653082305162436e-05 4.4733371018365243e-11
+ 1.1665289336412435e-05 5.3058719093237963e-11
+ 1.1677496367662437e-05 6.5249849962529414e-11
+ 1.1689703398912436e-05 8.0586557341896391e-11
+ 1.1701910430162438e-05 9.8186059694000248e-11
+ 1.1714117461412436e-05 1.1703587328666208e-10
+ 1.1726324492662438e-05 1.3605185310399104e-10
+ 1.1738531523912437e-05 1.5414054504639482e-10
+ 1.1750738555162439e-05 1.7026206156240515e-10
+ 1.1762945586412438e-05 1.8348986297121229e-10
+ 1.177515261766244e-05 1.9306400774952091e-10
+ 1.1787359648912438e-05 1.9843481134517081e-10
+ 1.179956668016244e-05 1.9929440536940058e-10
+ 1.1811773711412439e-05 1.9559438520732841e-10
+ 1.1823980742662441e-05 1.8754853451668201e-10
+ 1.183618777391244e-05 1.7562047328816539e-10
+ 1.1848394805162442e-05 1.6049694315998822e-10
+ 1.1860601836412441e-05 1.4304826930135124e-10
+ 1.1872808867662443e-05 1.2427827523140709e-10
+ 1.1885015898912441e-05 1.052665328361379e-10
+ 1.1897222930162443e-05 8.7106269937226752e-11
+ 1.1909429961412442e-05 7.0841506734532094e-11
+ 1.1921636992662444e-05 5.7407035899497847e-11
+ 1.1933844023912443e-05 4.7574696846103914e-11
+ 1.1936895781724942e-05 4.5750674856066197e-11
+ 1.1937048369615568e-05 4.5666462612461995e-11
+ 1.193742983934213e-05 4.5458870923120094e-11
+ 1.1937467986314788e-05 4.5438342991126504e-11
+ 1.1937475615709319e-05 4.5434242455099145e-11
+ 1.1937490874498382e-05 4.5426046434154427e-11
+ 1.1937496978014007e-05 4.5422769911655126e-11
+ 1.1937499419420257e-05 4.542145960441293e-11
+ 1.1937499604455785e-05 4.5421360302533612e-11
+ 1.1937499974526838e-05 4.5421161701746532e-11
+ 1.1937500714668947e-05 5.7234708751505077e-08
+ 1.1937501454811056e-05 2.3609835104101694e-07
+ 1.1937508856232146e-05 8.3378657603255145e-06
+ 1.1937516257653236e-05 2.6804211983519737e-05
+ 1.1937523659074325e-05 5.4212572160978158e-05
+ 1.1937531060495415e-05 8.9333429400249197e-05
+ 1.1937538461916505e-05 0.00013110387761772142
+ 1.1937547512355687e-05 0.00018988604042548046
+ 1.1937556562794869e-05 0.000255812068272275
+ 1.1937565613234049e-05 0.00032768193023753725
+ 1.1937574663673229e-05 0.00040448949601993325
+ 1.1937583714112411e-05 0.00048539058840956265
+ 1.193759504453351e-05 0.00059137048504824714
+ 1.1937606374954608e-05 0.00070151686849491022
+ 1.1937617705375707e-05 0.0008149054011463608
+ 1.1937629035796805e-05 0.00093078918228233572
+ 1.1937643214653362e-05 0.0010784080416500865
+ 1.1937657393509916e-05 0.0012280520970111633
+ 1.1937671572366471e-05 0.0013789889014004875
+ 1.1937689032396936e-05 0.0015657925325384681
+ 1.1937706492427397e-05 0.0017528666320927736
+ 1.1937723952457862e-05 0.0019395804048633696
+ 1.1937746268477831e-05 0.0021769293571718938
+ 1.1937768584497801e-05 0.0024120996791847497
+ 1.1937790900517771e-05 0.0026444704336099976
+ 1.193781909021724e-05 0.0029332237971511233
+ 1.1937847279916709e-05 0.0032158629328255771
+ 1.193787546961618e-05 0.0034916668520790159
+ 1.1937903659315651e-05 0.0037599988278231356
+ 1.1937931849015121e-05 0.0040202830355208904
+ 1.193796003871459e-05 0.0042719918874605982
+ 1.1937988228414061e-05 0.0045146394015623476
+ 1.1938019414106471e-05 0.0047719795450323309
+ 1.1938050599798884e-05 0.0050171295125712645
+ 1.1938081785491296e-05 0.0052495906087394869
+ 1.1938112971183706e-05 0.0054689190353913904
+ 1.1938150418414337e-05 0.0057143885297757718
+ 1.1938187865644966e-05 0.0059397992525804574
+ 1.1938225312875596e-05 0.006144702220679193
+ 1.1938270844195809e-05 0.0063657430322260553
+ 1.1938316375516022e-05 0.0065556175023236875
+ 1.1938361906836234e-05 0.0067142112673811444
+ 1.1938407438156445e-05 0.0068416534980290083
+ 1.1938441084028111e-05 0.0069160175765833089
+ 1.1938474729899776e-05 0.0069737900261410465
+ 1.1938508375771442e-05 0.0070152594941248576
+ 1.1938542021643107e-05 0.0070407746969006688
+ 1.1938575667514773e-05 0.007050740823760393
+ 1.1938609313386438e-05 0.0070456156939712805
+ 1.1938642959258104e-05 0.007025905702338452
+ 1.1938676605129769e-05 0.0069921615895264296
+ 1.1938710251001435e-05 0.0069449740739896257
+ 1.1938736870668146e-05 0.006898526876910809
+ 1.1938763490334858e-05 0.0068443802044164921
+ 1.1938790110001568e-05 0.0067828688534493494
+ 1.1938816729668278e-05 0.0067143369242957376
+ 1.1938843349334989e-05 0.0066391364097472113
+ 1.1938869969001701e-05 0.0065576257964309343
+ 1.1938896588668411e-05 0.0064701686843428533
+ 1.1938923208335121e-05 0.0063771324303375145
+ 1.1938949828001832e-05 0.0062788868210215225
+ 1.1938976447668544e-05 0.0061758027801676225
+ 1.1939003067335254e-05 0.0060682511154162089
+ 1.1939029687001964e-05 0.0059566013086644297
+ 1.1939056306668675e-05 0.0058412203541628417
+ 1.1939082926335387e-05 0.0057224716479485063
+ 1.1939109546002097e-05 0.0056007139318451742
+ 1.1939136165668807e-05 0.0054763002948580381
+ 1.1939162785335518e-05 0.0053495772343856614
+ 1.193918940500223e-05 0.0052208837792675896
+ 1.193921602466894e-05 0.0050905506764474901
+ 1.1939239404935228e-05 0.0049749804171373225
+ 1.1939262785201516e-05 0.0048586054363550972
+ 1.1939286165467804e-05 0.0047416314482211135
+ 1.1939309545734093e-05 0.0046242577652878883
+ 1.1939332926000381e-05 0.0045066770343838705
+ 1.1939356306266669e-05 0.0043890750025309139
+ 1.1939379686532957e-05 0.0042716303126259531
+ 1.1939403066799245e-05 0.0041545143284691553
+ 1.1939426447065534e-05 0.0040378909886185305
+ 1.1939449827331822e-05 0.0039219166884552218
+ 1.193947320759811e-05 0.0038067401897542695
+ 1.1939496587864398e-05 0.0036925025569730643
+ 1.1939519968130686e-05 0.0035793371193940525
+ 1.1939543348396975e-05 0.0034673694581895016
+ 1.1939566728663263e-05 0.0033567174174145066
+ 1.1939590108929551e-05 0.0032474911378798247
+ 1.1939613489195839e-05 0.0031397931128086067
+ 1.1939636869462127e-05 0.0030337182641405314
+ 1.1939660249728416e-05 0.0029293540383132049
+ 1.1939683629994704e-05 0.0028267805203238136
+ 1.1939707010260992e-05 0.0027260705648536779
+ 1.1939735591237516e-05 0.0026055855381113117
+ 1.193976417221404e-05 0.0024880893416989024
+ 1.1939792753190564e-05 0.0023736731389782805
+ 1.1939821334167088e-05 0.0022624136400195647
+ 1.1939849915143611e-05 0.0021543736566158275
+ 1.1939886199806211e-05 0.0020219271947776738
+ 1.1939925453373381e-05 0.0018846580284455387
+ 1.1939946977215264e-05 0.0018120618774395494
+ 1.19399736967147e-05 0.0017245821083065652
+ 1.1940000416214136e-05 0.0016400258203643724
+ 1.1940027135713572e-05 0.0015583844444338579
+ 1.1940053855213008e-05 0.0014796423351417674
+ 1.1940080574712444e-05 0.0014037772468436488
+ 1.194010729421188e-05 0.0013307608065583204
+ 1.1940134013711316e-05 0.0012605589819463642
+ 1.1940160733210752e-05 0.0011931325425094006
+ 1.1940187452710188e-05 0.0011284375123336611
+ 1.1940214172209624e-05 0.0010664256128491564
+ 1.194024089170906e-05 0.0010070446942234952
+ 1.194026254885961e-05 0.00096080661895637035
+ 1.1940284206010164e-05 0.0009162294538821239
+ 1.1940305863160714e-05 0.00087328092606094238
+ 1.1940327520311267e-05 0.00083192771752318962
+ 1.1940349177461817e-05 0.00079213559354230647
+ 1.1940370834612371e-05 0.00075386952625768001
+ 1.1940392491762921e-05 0.00071709381353394315
+ 1.1940414148913474e-05 0.00068177219296354193
+ 1.1940435806064024e-05 0.00064786795094112185
+ 1.1940457463214578e-05 0.00061534402675914772
+ 1.1940479120365128e-05 0.00058416311167918647
+ 1.1940496765399602e-05 0.00055972551886932095
+ 1.1940514410434077e-05 0.00053613426244406741
+ 1.194053205546855e-05 0.00051336904748169171
+ 1.1940549700503023e-05 0.00049140960981622914
+ 1.1940567345537498e-05 0.00047023574348777509
+ 1.1940584990571972e-05 0.00044982732676715286
+ 1.1940602635606445e-05 0.00043016434677204047
+ 1.1940620280640918e-05 0.00041122692269401575
+ 1.1940637925675393e-05 0.00039299532765819798
+ 1.1940655570709867e-05 0.00037545000923921415
+ 1.194067321574434e-05 0.00035857160865911174
+ 1.1940690860778813e-05 0.00034234097869457157
+ 1.1940708505813288e-05 0.00032673920032235228
+ 1.1940726150847762e-05 0.00031174759813332067
+ 1.1940743795882235e-05 0.00029734775454669758
+ 1.1940761440916708e-05 0.00028352152285727745
+ 1.1940779085951183e-05 0.0002702510391493668
+ 1.1940796730985657e-05 0.00025751873311203796
+ 1.194081437602013e-05 0.00024530733779101174
+ 1.1940832021054603e-05 0.00023359989831307307
+ 1.1940849666089078e-05 0.00022237977961939102
+ 1.1940867311123552e-05 0.00021163067324446447
+ 1.1940884956158025e-05 0.00020133660317765155
+ 1.1940902601192498e-05 0.00019148193084437179
+ 1.1940920246226973e-05 0.00018205135924409671
+ 1.1940937891261448e-05 0.00017302993628217709
+ 1.194095553629592e-05 0.00016440305733239472
+ 1.1940973181330393e-05 0.00015615646706688136
+ 1.1940990826364868e-05 0.00014827626058972067
+ 1.1941008471399343e-05 0.00014074888391014853
+ 1.1941026116433816e-05 0.00013356113379079491
+ 1.1941043761468288e-05 0.00012670015700587552
+ 1.1941061406502763e-05 0.00012015344904364461
+ 1.1941079051537238e-05 0.00011390885228677083
+ 1.1941096696571711e-05 0.00010795455370359766
+ 1.1941114341606184e-05 0.00010227908208250491
+ 1.1941131986640658e-05 9.687130484080241e-05
+ 1.1941149631675133e-05 9.1720424438765868e-05
+ 1.1941167276709606e-05 8.6815974428572379e-05
+ 1.1941184921744079e-05 8.2147815167013072e-05
+ 1.1941202566778553e-05 7.7706129219957601e-05
+ 1.1941220211813028e-05 7.3481416485622882e-05
+ 1.1941237856847501e-05 6.9464489062760908e-05
+ 1.1941255501881974e-05 6.5646465888930612e-05
+ 1.1941273146916448e-05 6.2018767173060703e-05
+ 1.1941290791950923e-05 5.8573108645546759e-05
+ 1.1941308436985396e-05 5.5301495648160228e-05
+ 1.1941326082019869e-05 5.2196217085081444e-05
+ 1.1941343727054343e-05 4.9249839255407143e-05
+ 1.1941361372088818e-05 4.6455199586526805e-05
+ 1.1941379017123291e-05 4.3805400286814076e-05
+ 1.1941396662157764e-05 4.1293801935142287e-05
+ 1.1941414307192238e-05 3.8914017023807698e-05
+ 1.1941431952226713e-05 3.6659903470533496e-05
+ 1.1941449597261186e-05 3.4525558114332587e-05
+ 1.1941467242295659e-05 3.2505310209129923e-05
+ 1.1941484887330133e-05 3.0593714928186798e-05
+ 1.1941502532364608e-05 2.878554689153125e-05
+ 1.1941520177399081e-05 2.7075793727781893e-05
+ 1.1941537822433554e-05 2.5459649680957857e-05
+ 1.1941555467468029e-05 2.3932509272096093e-05
+ 1.1941573112502503e-05 2.2489961024749567e-05
+ 1.1941590757536976e-05 2.1127781262716843e-05
+ 1.1941608402571449e-05 1.9841927987655173e-05
+ 1.1941626047605924e-05 1.8628534843556469e-05
+ 1.1941643692640398e-05 1.7483905174418017e-05
+ 1.1941661337674871e-05 1.6404506180818473e-05
+ 1.1941682620107574e-05 1.5184596516820046e-05
+ 1.1941702745281678e-05 1.4108722156777394e-05
+ 1.1941722870455781e-05 1.3103783271809466e-05
+ 1.1941742995629883e-05 1.2165512099818384e-05
+ 1.1941763120803985e-05 1.1289867233639744e-05
+ 1.1941783245978088e-05 1.0473023791237365e-05
+ 1.1941803371152192e-05 9.711363860421274e-06
+ 1.1941823496326293e-05 9.0014672215583367e-06
+ 1.1941843621500395e-05 8.3401023506671107e-06
+ 1.1941863746674499e-05 7.7242177042852387e-06
+ 1.1941888110746126e-05 7.0353574872189284e-06
+ 1.1941912474817754e-05 6.4041509733236313e-06
+ 1.1941936838889381e-05 5.8261375978047346e-06
+ 1.1941961202961009e-05 5.2971679183216326e-06
+ 1.1941985567032636e-05 4.8133849648221628e-06
+ 1.1942009931104264e-05 4.3712064413582404e-06
+ 1.1942034295175891e-05 3.9673077642003495e-06
+ 1.1942058659247519e-05 3.5986059186122073e-06
+ 1.1942083023319146e-05 3.2622441148827113e-06
+ 1.1942107387390774e-05 2.955577222710442e-06
+ 1.1942136719683569e-05 2.6223173518557521e-06
+ 1.1942166051976363e-05 2.3246430183300364e-06
+ 1.1942195384269158e-05 2.0589938235170389e-06
+ 1.1942224716561953e-05 1.8221375097881734e-06
+ 1.1942254048854748e-05 1.6111428978970881e-06
+ 1.1942283381147543e-05 1.4233547079677823e-06
+ 1.1942312713440338e-05 1.2563701699769522e-06
+ 1.1942342045733132e-05 1.1080173307665688e-06
+ 1.1942377848029195e-05 9.4935328593955194e-07
+ 1.1942412335454628e-05 8.1703614317247063e-07
+ 1.1942446822880062e-05 7.0231034037170861e-07
+ 1.1942481310305497e-05 6.0295931014601184e-07
+ 1.1942515797730929e-05 5.1702814794412422e-07
+ 1.1942557828321209e-05 4.2796498791424164e-07
+ 1.1942599858911487e-05 3.5358466304975593e-07
+ 1.1942641889501765e-05 2.9157919961691281e-07
+ 1.1942683920092045e-05 2.3998333476715486e-07
+ 1.1942725950682324e-05 1.9712710629082681e-07
+ 1.1942777518503423e-05 1.5442331314774624e-07
+ 1.1942828186666482e-05 1.2110746118199679e-07
+ 1.1942878854829539e-05 9.4668212428266369e-08
+ 1.1942929522992595e-05 7.3741045625230226e-08
+ 1.194299321514346e-05 5.3572482382509411e-08
+ 1.1943056907294324e-05 3.8650410566722333e-08
+ 1.1943120599445189e-05 2.7655607125139506e-08
+ 1.1943198945610713e-05 1.80624388894615e-08
+ 1.194327865764969e-05 1.1455385675920075e-08
+ 1.1943358369688668e-05 7.0279116712338033e-09
+ 1.1943461292370764e-05 3.42722610432318e-09
+ 1.1943569508909819e-05 1.2415251844169095e-09
+ 1.1943701914804436e-05 -1.7423168879043324e-10
+ 1.1943847065030183e-05 -9.0046498724308251e-10
+ 1.1944034315235684e-05 -1.2675598336250834e-09
+ 1.1944255865010424e-05 -1.390661486095478e-09
+ 1.1944554034092502e-05 -1.4079464626524889e-09
+ 1.1944998769870886e-05 -1.3781166774969621e-09
+ 1.1945805003988994e-05 -1.313948994893242e-09
+ 1.1946711764368314e-05 -1.2450592154006523e-09
+ 1.1947737475686441e-05 -1.1711746826522686e-09
+ 1.1948801143402342e-05 -1.0985374417948889e-09
+ 1.1949944764949545e-05 -1.0244977902794022e-09
+ 1.195223164627891e-05 -8.876839903243166e-10
+ 1.1954182681216658e-05 -7.8153991862173163e-10
+ 1.1956291228517249e-05 -6.7660226349856925e-10
+ 1.1958581467436159e-05 -5.7299433820914436e-10
+ 1.1960926666850022e-05 -4.7698621811411996e-10
+ 1.1963271866263887e-05 -3.901690868650475e-10
+ 1.196559053717963e-05 -3.1248869476676087e-10
+ 1.196847456948428e-05 -2.2600941125466692e-10
+ 1.1971358601788929e-05 -1.4953972152878652e-10
+ 1.1974242634093577e-05 -8.1909642546355165e-11
+ 1.1977126666398227e-05 -2.2097231394821104e-11
+ 1.1980010698702877e-05 3.0804763949844941e-11
+ 1.1982894731007525e-05 7.7599184420572088e-11
+ 1.1985778763312173e-05 1.1899177680085989e-10
+ 1.1989342797663593e-05 1.6360497315690482e-10
+ 1.1992906832015014e-05 2.0194460469335925e-10
+ 1.1996470866366433e-05 2.3489304324568193e-10
+ 1.2000034900717851e-05 2.6320792465228799e-10
+ 1.2003598935069272e-05 2.8754418863776942e-10
+ 1.2007899961127362e-05 3.124003450031708e-10
+ 1.201220098718545e-05 3.3310188136055884e-10
+ 1.2016502013243538e-05 3.5034335018174361e-10
+ 1.2020803039301627e-05 3.6470346013268147e-10
+ 1.2025104065359717e-05 3.7666442373221598e-10
+ 1.2030502505986983e-05 3.8888313831481749e-10
+ 1.2035900946614248e-05 3.9859542479219459e-10
+ 1.2041299387241515e-05 4.0629545583254085e-10
+ 1.2046697827868782e-05 4.1242659596079512e-10
+ 1.205346824765747e-05 4.1836450212166619e-10
+ 1.2060238667446158e-05 4.228142873871682e-10
+ 1.2067009087234845e-05 4.2614500842071573e-10
+ 1.2075385304343958e-05 4.2912633403108892e-10
+ 1.208376152145307e-05 4.3120345772378355e-10
+ 1.2092137738562183e-05 4.3264838822889765e-10
+ 1.2103043385488655e-05 4.3388610175178318e-10
+ 1.2113949032415131e-05 4.3464666000495187e-10
+ 1.212615606366513e-05 4.3514763453961883e-10
+ 1.2138363094915132e-05 4.3542384097085643e-10
+ 1.215057012616513e-05 4.3556624282357159e-10
+ 1.2162777157415132e-05 4.3562884855868211e-10
+ 1.2174984188665131e-05 4.3564390919099658e-10
+ 1.2187191219915133e-05 4.3563071731303817e-10
+ 1.2199398251165132e-05 4.3560072832369711e-10
+ 1.2211605282415134e-05 4.3556071800624522e-10
+ 1.2223812313665132e-05 4.3551473285478916e-10
+ 1.2236019344915135e-05 4.3546520640556509e-10
+ 1.2248226376165133e-05 4.3541358487496968e-10
+ 1.2260433407415135e-05 4.3536071753580087e-10
+ 1.2272640438665134e-05 4.353071102954193e-10
+ 1.2284847469915136e-05 4.3525307030070124e-10
+ 1.2297054501165135e-05 4.3519878102624261e-10
+ 1.2309261532415137e-05 4.3514434891989702e-10
+ 1.2321468563665135e-05 4.3508983678706616e-10
+ 1.2333675594915137e-05 4.3503528333983576e-10
+ 1.2345882626165136e-05 4.3498071205926307e-10
+ 1.2358089657415138e-05 4.3492613633167183e-10
+ 1.2370296688665137e-05 4.348715638520445e-10
+ 1.2382503719915139e-05 4.3481699946235471e-10
+ 1.2394710751165137e-05 4.3476244620745766e-10
+ 1.2406917782415139e-05 4.3470790578886986e-10
+ 1.2419124813665138e-05 4.3465337912630206e-10
+ 1.243133184491514e-05 4.3459886680952396e-10
+ 1.2443538876165139e-05 4.3454436923774573e-10
+ 1.2455745907415141e-05 4.3448988663097442e-10
+ 1.2467952938665139e-05 4.3443541909242035e-10
+ 1.2480159969915142e-05 4.3438096668679938e-10
+ 1.249236700116514e-05 4.3432652946422885e-10
+ 1.2500000000000001e-05 4.3429323819786375e-10
+ 1.2512207031250001e-05 4.3423882549145797e-10
+ 1.2524414062500001e-05 4.3418442800650571e-10
+ 1.253662109375e-05 4.3413004574565444e-10
+ 1.2548828125e-05 4.3407567870875607e-10
+ 1.2561035156250001e-05 4.3402132689399754e-10
+ 1.2573242187500001e-05 4.3396699029857563e-10
+ 1.2585449218750001e-05 4.3391266891909689e-10
+ 1.259765625e-05 4.338583627518177e-10
+ 1.260986328125e-05 4.338040717927861e-10
+ 1.2622070312500001e-05 4.3374979603792648e-10
+ 1.2634277343750001e-05 4.3369553548309005e-10
+ 1.2646484375000001e-05 4.3364129012408513e-10
+ 1.265869140625e-05 4.3358705995669485e-10
+ 1.26708984375e-05 4.3353284497668784e-10
+ 1.2683105468750001e-05 4.3347864517982436e-10
+ 1.2695312500000001e-05 4.3342446056186068e-10
+ 1.2707519531250001e-05 4.3337029111855061e-10
+ 1.27197265625e-05 4.3331613684564742e-10
+ 1.273193359375e-05 4.3326199773890431e-10
+ 1.2744140625000001e-05 4.3320787379407488e-10
+ 1.2756347656250001e-05 4.3315376500691365e-10
+ 1.27685546875e-05 4.3309967137317592e-10
+ 1.278076171875e-05 4.3304559288861817e-10
+ 1.2792968750000001e-05 4.3299152954899793e-10
+ 1.2805175781250001e-05 4.3293748135007384e-10
+ 1.2817382812500001e-05 4.3288344828760572e-10
+ 1.282958984375e-05 4.3282943035735457e-10
+ 1.2841796875e-05 4.3277542755508266e-10
+ 1.2854003906250001e-05 4.327214398765532e-10
+ 1.2866210937500001e-05 4.3266746731753079e-10
+ 1.2878417968750001e-05 4.3261350987378112e-10
+ 1.2890625e-05 4.3255956754107106e-10
+ 1.290283203125e-05 4.3250564031516869e-10
+ 1.2915039062500001e-05 4.324517281918434e-10
+ 1.2927246093750001e-05 4.3239783116686546e-10
+ 1.2939453125e-05 4.3234394923600652e-10
+ 1.295166015625e-05 4.3229008239503964e-10
+ 1.29638671875e-05 4.322362306397386e-10
+ 1.2976074218750001e-05 4.3218239396587857e-10
+ 1.2988281250000001e-05 4.3212857236923607e-10
+ 1.300048828125e-05 4.3207476584558855e-10
+ 1.30126953125e-05 4.3202097439071481e-10
+ 1.302490234375e-05 4.3196719800039462e-10
+ 1.3037109375000001e-05 4.3191343667040926e-10
+ 1.3049316406250001e-05 4.3185969039654094e-10
+ 1.30615234375e-05 4.3180595917457319e-10
+ 1.307373046875e-05 4.3175224300029046e-10
+ 1.30859375e-05 4.3169854186947872e-10
+ 1.3098144531250001e-05 4.3164485577792515e-10
+ 1.3110351562500001e-05 4.3159118472141752e-10
+ 1.3122558593750001e-05 4.315375286957455e-10
+ 1.3134765625e-05 4.3148388769669956e-10
+ 1.314697265625e-05 4.3143026172007142e-10
+ 1.3159179687500001e-05 4.3137665076165393e-10
+ 1.3171386718750001e-05 4.3132305481724119e-10
+ 1.3183593750000002e-05 4.3126947388262849e-10
+ 1.319580078125e-05 4.3121590795361226e-10
+ 1.3208007812500001e-05 4.3116235702599014e-10
+ 1.3220214843750001e-05 4.311088210955608e-10
+ 1.3232421875000001e-05 4.3105530015812432e-10
+ 1.3244628906250002e-05 4.3100179420948178e-10
+ 1.32568359375e-05 4.3094830324543561e-10
+ 1.3269042968750001e-05 4.3089482726178914e-10
+ 1.3281250000000001e-05 4.3084136625434698e-10
+ 1.3293457031250001e-05 4.3078792021891527e-10
+ 1.3305664062500002e-05 4.3073448915130076e-10
+ 1.331787109375e-05 4.3068107304731183e-10
+ 1.3330078125000001e-05 4.3062767190275767e-10
+ 1.3342285156250001e-05 4.3057428571344897e-10
+ 1.3354492187500001e-05 4.305209144751974e-10
+ 1.3366699218750002e-05 4.3046755818381573e-10
+ 1.3378906250000002e-05 4.3041421683511815e-10
+ 1.3391113281250001e-05 4.3036089042491982e-10
+ 1.3403320312500001e-05 4.3030757894903721e-10
+ 1.3415527343750001e-05 4.3025428240328784e-10
+ 1.3427734375000002e-05 4.3020100078349046e-10
+ 1.3439941406250002e-05 4.3014773408546503e-10
+ 1.3452148437500001e-05 4.3009448230503257e-10
+ 1.3464355468750001e-05 4.3004124543801536e-10
+ 1.3476562500000001e-05 4.2998802348023685e-10
+ 1.3488769531250002e-05 4.2993481642752165e-10
+ 1.35009765625e-05 4.298816242756955e-10
+ 1.3513183593750001e-05 4.2982844702058526e-10
+ 1.3525390625000001e-05 4.2977528465801911e-10
+ 1.3537597656250002e-05 4.2972213718382639e-10
+ 1.3549804687500002e-05 4.296690045938374e-10
+ 1.3562011718750001e-05 4.2961588688388387e-10
+ 1.3574218750000001e-05 4.2956278404979846e-10
+ 1.3586425781250001e-05 4.2950969608741529e-10
+ 1.35986328125e-05 4.2945662299256918e-10
+ 1.361083984375e-05 4.2940356476109669e-10
+ 1.3623046875000001e-05 4.2935052138883517e-10
+ 1.3635253906250001e-05 4.2929749287162315e-10
+ 1.3647460937500001e-05 4.2924447920530045e-10
+ 1.365966796875e-05 4.2919148038570803e-10
+ 1.3671875e-05 4.2913849640868801e-10
+ 1.3684082031250001e-05 4.2908552727008359e-10
+ 1.3696289062499999e-05 4.2903257296573924e-10
+ 1.370849609375e-05 4.2897963349150058e-10
+ 1.3720703125e-05 4.2892670884321429e-10
+ 1.373291015625e-05 4.288737990167283e-10
+ 1.3745117187500001e-05 4.2882090400789185e-10
+ 1.3757324218749999e-05 4.2876802381255504e-10
+ 1.376953125e-05 4.2871515842656934e-10
+ 1.378173828125e-05 4.2866230784578723e-10
+ 1.3793945312499999e-05 4.2860947206606246e-10
+ 1.3806152343749999e-05 4.2855665108325002e-10
+ 1.3818359374999999e-05 4.2850384489320595e-10
+ 1.383056640625e-05 4.2845105349178732e-10
+ 1.38427734375e-05 4.2839827687485269e-10
+ 1.3854980468749999e-05 4.2834551503826145e-10
+ 1.3867187499999999e-05 4.2829276797787439e-10
+ 1.3879394531249999e-05 4.2824003568955333e-10
+ 1.3891601562499998e-05 4.2818731816916134e-10
+ 1.3903808593749998e-05 4.2813461541256231e-10
+ 1.3916015624999999e-05 4.2808192741562203e-10
+ 1.3928222656249999e-05 4.2802925417420679e-10
+ 1.39404296875e-05 4.2797659568418397e-10
+ 1.3952636718749998e-05 4.2792395194142275e-10
+ 1.3964843749999999e-05 4.2787132294179297e-10
+ 1.3977050781249999e-05 4.2781870868116553e-10
+ 1.3989257812499998e-05 4.2776610915541303e-10
+ 1.4001464843749998e-05 4.2771352436040875e-10
+ 1.4013671874999998e-05 4.2766095429202714e-10
+ 1.4025878906249999e-05 4.2760839894614423e-10
+ 1.4038085937499999e-05 4.2755585831863669e-10
+ 1.4050292968749998e-05 4.2750333240538267e-10
+ 1.4062499999999998e-05 4.2745082120226136e-10
+ 1.4074707031249998e-05 4.2739832470515305e-10
+ 1.4086914062499997e-05 4.273458429099393e-10
+ 1.4099121093749997e-05 4.2729337581250278e-10
+ 1.4111328124999998e-05 4.2724092340872732e-10
+ 1.4123535156249998e-05 4.2718848569449787e-10
+ 1.4135742187499998e-05 4.2713606266570053e-10
+ 1.4147949218749997e-05 4.2708365431822263e-10
+ 1.4160156249999997e-05 4.270312606479525e-10
+ 1.4172363281249998e-05 4.2697888165077988e-10
+ 1.4184570312499996e-05 4.2692651732259529e-10
+ 1.4196777343749997e-05 4.2687416765929084e-10
+ 1.4208984374999997e-05 4.2682183265675928e-10
+ 1.4221191406249997e-05 4.2676951231089505e-10
+ 1.4233398437499998e-05 4.2671720661759342e-10
+ 1.4245605468749996e-05 4.2666491557275079e-10
+ 1.4257812499999997e-05 4.2661263917226478e-10
+ 1.4270019531249997e-05 4.265603774120343e-10
+ 1.4282226562499996e-05 4.265081302879591e-10
+ 1.4294433593749996e-05 4.2645589779594043e-10
+ 1.4306640624999996e-05 4.2640367993188038e-10
+ 1.4318847656249997e-05 4.2635147669168246e-10
+ 1.4331054687499997e-05 4.2629928807125108e-10
+ 1.4343261718749996e-05 4.2624711406649186e-10
+ 1.4355468749999996e-05 4.2619495467331169e-10
+ 1.4367675781249996e-05 4.2614280988761856e-10
+ 1.4379882812499995e-05 4.2609067970532156e-10
+ 1.4392089843749996e-05 4.2603856412233079e-10
+ 1.4404296874999996e-05 4.2598646313455786e-10
+ 1.4416503906249996e-05 4.2593437673791515e-10
+ 1.4428710937499997e-05 4.2588230492831644e-10
+ 1.4440917968749995e-05 4.2583024770167654e-10
+ 1.4453124999999996e-05 4.2577820505391141e-10
+ 1.4465332031249996e-05 4.2572617698093814e-10
+ 1.4477539062499995e-05 4.2567416347867499e-10
+ 1.4489746093749995e-05 4.2562216454304139e-10
+ 1.4501953124999995e-05 4.2557018016995789e-10
+ 1.4514160156249996e-05 4.2551821035534623e-10
+ 1.4526367187499996e-05 4.2546625509512913e-10
+ 1.4538574218749995e-05 4.254143143852306e-10
+ 1.4550781249999995e-05 4.2536238822157581e-10
+ 1.4562988281249995e-05 4.2531047660009089e-10
+ 1.4575195312499994e-05 4.2525857951670346e-10
+ 1.4587402343749994e-05 4.252066969673418e-10
+ 1.4599609374999995e-05 4.2515482894793579e-10
+ 1.4611816406249995e-05 4.2510297545441604e-10
+ 1.4624023437499995e-05 4.2505113648271467e-10
+ 1.4636230468749994e-05 4.2499931202876474e-10
+ 1.4648437499999994e-05 4.2494750208850055e-10
+ 1.4660644531249995e-05 4.248957066578573e-10
+ 1.4672851562499993e-05 4.2482519493572964e-10
+ 1.4685058593749994e-05 4.2475256100502045e-10
+ 1.4697265624999994e-05 4.2468173951608737e-10
+ 1.4709472656249994e-05 4.2459666096075283e-10
+ 1.4721679687499995e-05 4.2448010616874532e-10
+ 1.4733886718749993e-05 4.242745676347303e-10
+ 1.4739990234374993e-05 4.2406762246865748e-10
+ 1.4746093749999994e-05 4.2364446431160585e-10
+ 1.4749145507812493e-05 4.2320637096990359e-10
+ 1.4752197265624995e-05 4.2237081875579266e-10
+ 1.4755249023437494e-05 4.2039912634768696e-10
+ 1.4756606790774086e-05 4.184858057925494e-10
+ 1.4756998216660861e-05 4.1769354662518729e-10
+ 1.4757389642547635e-05 4.1673967866159501e-10
+ 1.4758368207264575e-05 4.1328644574257995e-10
+ 1.4759409502908185e-05 4.0647792025774505e-10
+ 1.4759970598735322e-05 4.0009399586852752e-10
+ 1.4760339629298368e-05 3.9400830485401903e-10
+ 1.4761110323815841e-05 3.7217296598144555e-10
+ 1.4761741481233848e-05 3.3482378565862255e-10
+ 1.476211308400901e-05 2.9476725253157392e-10
+ 1.4762434193795789e-05 2.3913652951300332e-10
+ 1.476264709792541e-05 2.1273235713088472e-10
+ 1.4762860002055032e-05 2.1207408791108858e-10
+ 1.4764989043351244e-05 2.1185023895337551e-10
+ 1.4777196074601245e-05 2.0757980032582087e-10
+ 1.4789403105851243e-05 1.9827504053149293e-10
+ 1.4801610137101244e-05 1.8447156434439206e-10
+ 1.4813817168351244e-05 1.6696410651490149e-10
+ 1.4826024199601245e-05 1.4676018343964647e-10
+ 1.4838231230851245e-05 1.2502212943217047e-10
+ 1.4850438262101244e-05 1.0300022779102304e-10
+ 1.4862645293351244e-05 8.1960799754197404e-11
+ 1.4874852324601244e-05 6.311338755160194e-11
+ 1.4887059355851243e-05 4.7541218733423125e-11
+ 1.4899266387101243e-05 3.6138949326912032e-11
+ 1.4911473418351244e-05 2.9561263935700322e-11
+ 1.4923680449601244e-05 2.8185285811614418e-11
+ 1.4935887480851244e-05 3.2088955187765566e-11
+ 1.4948094512101243e-05 4.1046615499322252e-11
+ 1.4960301543351243e-05 5.4542057385810135e-11
+ 1.4972508574601244e-05 7.1798266491615728e-11
+ 1.4984715605851242e-05 9.1822160785597292e-11
+ 1.4996922637101243e-05 1.1346174161334856e-10
+ 1.5009129668351243e-05 1.3547236949090519e-10
+ 1.5021336699601243e-05 1.5658835172212636e-10
+ 1.5033543730851244e-05 1.7559572435646284e-10
+ 1.5045750762101242e-05 1.9140204326212496e-10
+ 1.5057957793351243e-05 2.030991720132836e-10
+ 1.5061009551163742e-05 2.0529687447679853e-10
+ 1.5061314726944993e-05 2.0549982177660819e-10
+ 1.5062077666398118e-05 2.0599366009052315e-10
+ 1.5062459136124681e-05 2.062333046850057e-10
+ 1.506248297798259e-05 2.0624812098499301e-10
+ 1.5062487746354172e-05 2.0625108196291897e-10
+ 1.5062497283097336e-05 2.0625700163649109e-10
+ 1.5062498046036789e-05 2.0625747507891284e-10
+ 1.5062499571915695e-05 2.0625842190532621e-10
+ 1.5062499693986007e-05 2.0625849764807365e-10
+ 1.5062499938126632e-05 2.0625864913207268e-10
+ 1.5062499957657882e-05 2.0625866125070641e-10
+ 1.5062499996720382e-05 2.0625868548793557e-10
+ 1.5062500074845381e-05 8.3574849775232329e-10
+ 1.5062500152970381e-05 2.8382408459534785e-09
+ 1.5062500934220378e-05 9.7910663945931592e-08
+ 1.5062508051845974e-05 6.9281309170090845e-06
+ 1.5062515169471572e-05 2.3496919613390592e-05
+ 1.5062522287097168e-05 4.8515586154137975e-05
+ 1.5062529404722764e-05 8.0864107426474553e-05
+ 1.5062536522348361e-05 0.0001195688537478285
+ 1.5062543639973957e-05 0.00016378325676260678
+ 1.5062550757599553e-05 0.00021277103077073492
+ 1.5062557875225149e-05 0.00026589161027525284
+ 1.5062564992850745e-05 0.00032258751106878353
+ 1.5062572110476343e-05 0.00038237336083026571
+ 1.5062579228101939e-05 0.00044482637875059637
+ 1.5062587807568571e-05 0.00052313156179263198
+ 1.5062596387035203e-05 0.00060422377214069478
+ 1.5062604966501835e-05 0.00068763160407692863
+ 1.5062613545968467e-05 0.00077295453496090106
+ 1.5062622125435099e-05 0.00085985181282763258
+ 1.5062630704901731e-05 0.00094803308914625053
+ 1.5062639284368363e-05 0.0010372505228311898
+ 1.5062647863834995e-05 0.0011272921245865509
+ 1.506265818077025e-05 0.0012364048498757886
+ 1.5062668497705506e-05 0.0013461799437633384
+ 1.5062678814640761e-05 0.0014563930288477433
+ 1.5062689131576017e-05 0.001566855276772596
+ 1.5062699448511272e-05 0.0016774068636345029
+ 1.5062709765446527e-05 0.001787911643031166
+ 1.5062720082381783e-05 0.0018982528107135616
+ 1.5062730399317038e-05 0.0020083293767566338
+ 1.5062742902012257e-05 0.002141246780886198
+ 1.5062755404707478e-05 0.0022735106700283729
+ 1.5062767907402697e-05 0.0024050029041599369
+ 1.5062780410097916e-05 0.0025356196305195535
+ 1.5062792912793135e-05 0.0026652683340791378
+ 1.5062805415488354e-05 0.002793865545581445
+ 1.5062817918183575e-05 0.0029213350620943554
+ 1.5062830420878794e-05 0.0030476065669750823
+ 1.5062845592253874e-05 0.0031991277392290247
+ 1.5062860763628954e-05 0.0033486794005026179
+ 1.5062875935004033e-05 0.0034961593179601309
+ 1.5062891106379113e-05 0.0036414711081661105
+ 1.5062906277754193e-05 0.0037845233735065873
+ 1.5062921449129273e-05 0.0039252290818992874
+ 1.5062936620504353e-05 0.0040635051254073566
+ 1.506295486051956e-05 0.0042264209820281088
+ 1.5062973100534768e-05 0.0043855785109888799
+ 1.5062991340549974e-05 0.004540852807539594
+ 1.5063009580565182e-05 0.0046921255232483241
+ 1.506302782058039e-05 0.004839284756390172
+ 1.5063046060595596e-05 0.0049822250059800644
+ 1.5063068199865846e-05 0.0051499118748984281
+ 1.5063090339136094e-05 0.0053110729761570875
+ 1.5063112478406342e-05 0.0054655577982168782
+ 1.5063134617676592e-05 0.0056132299331846198
+ 1.5063161293011317e-05 0.0057819364493443522
+ 1.5063187873095807e-05 0.0059398423573548687
+ 1.5063214453180296e-05 0.0060874136176253622
+ 1.5063248688484341e-05 0.0062620603819550135
+ 1.5063282923788384e-05 0.0064191641307141745
+ 1.5063315356127047e-05 0.0065517091134031152
+ 1.5063347788465712e-05 0.0066683776453289999
+ 1.5063380220804375e-05 0.0067692021882621509
+ 1.5063412653143038e-05 0.0068542763543729904
+ 1.5063445085481701e-05 0.0069237529436825757
+ 1.5063477517820364e-05 0.0069778416850672731
+ 1.5063509950159029e-05 0.0070168067033145008
+ 1.5063542382497692e-05 0.0070409637367341727
+ 1.5063569584998146e-05 0.0070500711051410814
+ 1.50635967874986e-05 0.0070492564131712353
+ 1.5063623989999053e-05 0.0070387804986578604
+ 1.5063651192499507e-05 0.0070189238317284377
+ 1.506367839499996e-05 0.0069899850256677273
+ 1.5063705597500414e-05 0.0069522793135452206
+ 1.5063732800000867e-05 0.0069061369988542495
+ 1.5063760002501321e-05 0.0068519018883273245
+ 1.5063787205001774e-05 0.0067899297149596706
+ 1.5063814407502228e-05 0.0067205865590935169
+ 1.5063841610002681e-05 0.0066442472751925379
+ 1.5063868812503135e-05 0.006561293931672073
+ 1.5063896015003588e-05 0.0064721142708494637
+ 1.5063923217504042e-05 0.0063771001957435066
+ 1.5063950420004495e-05 0.0062766462900859356
+ 1.5063977622504949e-05 0.0061711483775146155
+ 1.5064004825005403e-05 0.0060610021255013743
+ 1.5064032027505856e-05 0.0059466016991306979
+ 1.506405923000631e-05 0.0058283384693926773
+ 1.5064086432506763e-05 0.0057065997804302861
+ 1.5064115300883499e-05 0.0055740309990659331
+ 1.5064144169260233e-05 0.0054384272991202893
+ 1.5064173037636967e-05 0.0053002282345430132
+ 1.5064201906013703e-05 0.0051598626838551204
+ 1.5064230774390439e-05 0.0050177476630414884
+ 1.5064259642767173e-05 0.0048742872442221231
+ 1.5064288511143907e-05 0.0047298715812966012
+ 1.5064317379520643e-05 0.0045848760430473451
+ 1.5064346247897379e-05 0.0044396604535071188
+ 1.5064381135166683e-05 0.0042643637747592994
+ 1.5064416022435987e-05 0.0040898203879790361
+ 1.5064449985506051e-05 0.0039211359224094145
+ 1.5064483948576112e-05 0.0037541355090310092
+ 1.5064517911646177e-05 0.0035892460195200843
+ 1.5064551874716238e-05 0.0034268598627977894
+ 1.5064585837786302e-05 0.0032673350066711841
+ 1.5064627381082817e-05 0.0030765664536155394
+ 1.5064668924379333e-05 0.0028910852643209248
+ 1.5064710467675849e-05 0.0027113416169293153
+ 1.5064752010972364e-05 0.0025377141992044784
+ 1.5064802322523098e-05 0.0023360685105670866
+ 1.5064853125173635e-05 0.0021424443576868821
+ 1.5064903927824171e-05 0.001959156496722657
+ 1.5064971607266246e-05 0.0017313192252947558
+ 1.5065039286708322e-05 0.0015222190408349249
+ 1.5065091919396566e-05 0.001372431253814393
+ 1.5065144552084811e-05 0.0012336381966261724
+ 1.5065197184773056e-05 0.0011055447342070166
+ 1.5065249817461301e-05 0.00098778684645394604
+ 1.5065297809929104e-05 0.00088906516794052203
+ 1.5065345802396906e-05 0.00079823747715313789
+ 1.5065393794864709e-05 0.00071492972227882204
+ 1.5065441787332512e-05 0.00063875107498295779
+ 1.5065489779800313e-05 0.00056929990178360005
+ 1.5065537261554863e-05 0.00050680910974394439
+ 1.5065584743309412e-05 0.00045011010916966049
+ 1.5065632225063962e-05 0.00039881145821643485
+ 1.5065679706818511e-05 0.00035252854906615789
+ 1.5065727188573059e-05 0.00031088653907439246
+ 1.5065774670327608e-05 0.0002735227890958723
+ 1.5065824358583365e-05 0.00023862511600889196
+ 1.5065874046839123e-05 0.00020765025205703798
+ 1.5065923735094879e-05 0.00018023763188315632
+ 1.5065973423350635e-05 0.00015604795426756195
+ 1.5066023111606392e-05 0.0001347637411803884
+ 1.5066072799862148e-05 0.00011608953467670693
+ 1.5066127951386075e-05 9.8086983151495662e-05
+ 1.5066183102910002e-05 8.2620379659707852e-05
+ 1.5066238254433927e-05 6.937830638173144e-05
+ 1.5066293405957853e-05 5.8079646203919961e-05
+ 1.506634855748178e-05 4.8471998343402797e-05
+ 1.5066411640520538e-05 3.9267448447275403e-05
+ 1.5066474723559299e-05 3.1683839518460041e-05
+ 1.5066537806598058e-05 2.5463033689023789e-05
+ 1.5066600889636816e-05 2.0382309617297274e-05
+ 1.5066674140146426e-05 1.5662206653736814e-05
+ 1.5066747390656035e-05 1.1971024407425274e-05
+ 1.5066820641165644e-05 9.101093726216712e-06
+ 1.5066905619421584e-05 6.5781195004269459e-06
+ 1.5066990597677523e-05 4.7207090840830405e-06
+ 1.5067093836844785e-05 3.1245246960755978e-06
+ 1.5067198171769413e-05 2.0371887602864823e-06
+ 1.5067302506694043e-05 1.3141391771344707e-06
+ 1.5067426664469163e-05 7.6923430377838728e-07
+ 1.5067550822244285e-05 4.435788450454647e-07
+ 1.5067705800806533e-05 2.1851475951109054e-07
+ 1.5067884937131787e-05 9.3708673373505121e-08
+ 1.5068098556602389e-05 3.2883700516734768e-08
+ 1.5068364485722952e-05 8.5309004428172277e-09
+ 1.5068717982712204e-05 1.4552417250701691e-09
+ 1.5069242097564144e-05 3.0578689270965244e-10
+ 1.5070136340120474e-05 2.4569663308855879e-10
+ 1.5072132807185035e-05 2.4259754686171839e-10
+ 1.5073988816858016e-05 2.4182034068072913e-10
+ 1.507642166844308e-05 2.4138174969930913e-10
+ 1.5078854520028143e-05 2.4076582964276258e-10
+ 1.5081287371613207e-05 2.4012576594620444e-10
+ 1.508372022319827e-05 2.4057963384973803e-10
+ 1.5086153074783334e-05 2.4092919901400983e-10
+ 1.5088585926368396e-05 2.401872610697499e-10
+ 1.5091018777953461e-05 2.3987554496708928e-10
+ 1.5093451629538523e-05 2.4037942571475707e-10
+ 1.5095767705239779e-05 2.4025247901632375e-10
+ 1.5098819440406719e-05 2.4017887589128354e-10
+ 1.5101871175573658e-05 2.4009951114703349e-10
+ 1.5104922910740596e-05 2.4004351142745323e-10
+ 1.5107974645907536e-05 2.4016098617015712e-10
+ 1.5111026381074474e-05 2.4071442426522539e-10
+ 1.5114078116241413e-05 2.3968616681674537e-10
+ 1.51177736187736e-05 2.4003007462135484e-10
+ 1.512113428861091e-05 2.4006402385879101e-10
+ 1.512449495844822e-05 2.4006047129867007e-10
+ 1.5128620731690278e-05 2.4005210497337081e-10
+ 1.5132746504932338e-05 2.4004042399080182e-10
+ 1.5136872278174396e-05 2.4003044384477591e-10
+ 1.5140998051416456e-05 2.4003749578386358e-10
+ 1.5145123824658514e-05 2.4008180521387353e-10
+ 1.5150251138437097e-05 2.4016443526047099e-10
+ 1.5155378452215678e-05 2.3985136550844345e-10
+ 1.5160505765994261e-05 2.3994252727381691e-10
+ 1.5165633079772843e-05 2.4004700010028028e-10
+ 1.5171995979825151e-05 2.4004483697536087e-10
+ 1.517835887987746e-05 2.3997024527683999e-10
+ 1.5184721779929769e-05 2.3997592655072043e-10
+ 1.519249725625451e-05 2.4000749931504923e-10
+ 1.5200272732579251e-05 2.4001269631983051e-10
+ 1.5208048208903992e-05 2.3999782508278659e-10
+ 1.5217983441936068e-05 2.3999355892689472e-10
+ 1.5227918674968143e-05 2.4000179472492324e-10
+ 1.5240125706218143e-05 2.4000339716614338e-10
+ 1.5252332737468142e-05 2.3999888202599127e-10
+ 1.526453976871814e-05 2.3999830525938688e-10
+ 1.5276746799968142e-05 2.4000037974237526e-10
+ 1.5288953831218141e-05 2.4000087414852165e-10
+ 1.5301160862468143e-05 2.3999993966201389e-10
+ 1.5313367893718142e-05 2.3999960494882817e-10
+ 1.532557492496814e-05 2.4000001432309894e-10
+ 1.5337781956218142e-05 2.4000021737723387e-10
+ 1.5349988987468141e-05 2.4000004462513988e-10
+ 1.5362196018718143e-05 2.3999993006727966e-10
+ 1.5374403049968142e-05 2.3999999917748096e-10
+ 1.538661008121814e-05 2.4000006049017395e-10
+ 1.5398817112468142e-05 2.4000003421757239e-10
+ 1.5411024143718141e-05 2.4000000237870328e-10
+ 1.542323117496814e-05 2.4000001256652595e-10
+ 1.5435438206218142e-05 2.4000002745854788e-10
+ 1.5447645237468141e-05 2.4000002475271839e-10
+ 1.5459852268718139e-05 2.4000001795384735e-10
+ 1.5472059299968141e-05 2.400000173879749e-10
+ 1.548426633121814e-05 2.4000002070407596e-10
+ 1.5496473362468142e-05 2.4000002067419452e-10
+ 1.5508680393718141e-05 2.4000001976473751e-10
+ 1.5520887424968139e-05 2.40000019362722e-10
+ 1.5533094456218141e-05 2.4000002028128461e-10
+ 1.554530148746814e-05 2.4000002060646208e-10
+ 1.5557508518718142e-05 2.4000002008287723e-10
+ 1.5569715549968141e-05 2.4000001934276911e-10
+ 1.5581922581218139e-05 2.4000001968966948e-10
+ 1.5594129612468141e-05 2.4000002093381111e-10
+ 1.560633664371814e-05 2.4000001965726013e-10
+ 1.5618543674968139e-05 2.4000001961507071e-10
+ 1.5630750706218141e-05 2.4000002048512451e-10
+ 1.5642957737468139e-05 2.4000001998121006e-10
+ 1.5655164768718138e-05 2.400000199764228e-10
+ 1.566737179996814e-05 2.4000001998665694e-10
+ 1.5679578831218139e-05 2.4000001988395378e-10
+ 1.5691785862468141e-05 2.4000001969840786e-10
+ 1.5703992893718139e-05 2.4000001962628526e-10
+ 1.5716199924968138e-05 2.4000001985975601e-10
+ 1.572840695621814e-05 2.4000001994562599e-10
+ 1.5740613987468139e-05 2.4000001873790616e-10
+ 1.5752821018718141e-05 2.400000206888198e-10
+ 1.5765028049968139e-05 2.4000002115772409e-10
+ 1.5777235081218138e-05 2.4000001926167516e-10
+ 1.578944211246814e-05 2.4000001865095655e-10
+ 1.5801649143718139e-05 2.4000002024868279e-10
+ 1.5813856174968137e-05 2.4000002062807212e-10
+ 1.5826063206218139e-05 2.4000001971246058e-10
+ 1.5838270237468138e-05 2.4000001913611468e-10
+ 1.5850477268718137e-05 2.4000001939609548e-10
+ 1.5862684299968139e-05 2.4000001928925776e-10
+ 1.5874891331218137e-05 2.4000002036211893e-10
+ 1.588709836246814e-05 2.4000001948566678e-10
+ 1.5899305393718138e-05 2.40000020557049e-10
+ 1.5911512424968137e-05 2.400000203491446e-10
+ 1.5923719456218139e-05 2.4000001961720044e-10
+ 1.5935926487468138e-05 2.400000200808237e-10
+ 1.594813351871814e-05 2.4000002006495584e-10
+ 1.5960340549968138e-05 2.4000001941755901e-10
+ 1.5972547581218137e-05 2.4000001925514504e-10
+ 1.5984754612468139e-05 2.4000001949494439e-10
+ 1.5996961643718138e-05 2.4000001987457185e-10
+ 1.6009168674968136e-05 2.4000001956535886e-10
+ 1.6021375706218138e-05 2.4000001976899341e-10
+ 1.6033582737468137e-05 2.4000001989767335e-10
+ 1.6045789768718136e-05 2.4000002010421042e-10
+ 1.6057996799968138e-05 2.4000002031692612e-10
+ 1.6070203831218136e-05 2.4000001943796074e-10
+ 1.6082410862468138e-05 2.4000001979057998e-10
+ 1.6094617893718137e-05 2.4000001994141042e-10
+ 1.6106824924968136e-05 2.4000001910787902e-10
+ 1.6119031956218138e-05 2.4000002014157438e-10
+ 1.6131238987468136e-05 2.4000002007976212e-10
+ 1.6143446018718138e-05 2.4000001897875313e-10
+ 1.6155653049968137e-05 2.4000002030066949e-10
+ 1.6167860081218136e-05 2.4000002070432142e-10
+ 1.6180067112468138e-05 2.4000001950520541e-10
+ 1.6192274143718136e-05 2.4000001947980057e-10
+ 1.6204481174968135e-05 2.4000002027253361e-10
+ 1.6216688206218137e-05 2.40000020609859e-10
+ 1.6228895237468136e-05 2.4000001911322354e-10
+ 1.6241102268718134e-05 2.4000001969739074e-10
+ 1.6253309299968136e-05 2.4000002073053612e-10
+ 1.6265516331218135e-05 2.4000001994814067e-10
+ 1.6277723362468137e-05 2.4000001923239209e-10
+ 1.6289930393718136e-05 2.4000002015288261e-10
+ 1.6302137424968134e-05 2.4000001930210656e-10
+ 1.6314344456218137e-05 2.4000001837686493e-10
+ 1.6326551487468135e-05 2.4000001946449939e-10
+ 1.6338758518718137e-05 2.4000002038326192e-10
+ 1.6350965549968136e-05 2.400000203109469e-10
+ 1.6363172581218138e-05 2.400000203952259e-10
+ 1.6375379612468137e-05 2.4000001970496741e-10
+ 1.6387586643718139e-05 2.4000001924454606e-10
+ 1.6399793674968137e-05 2.4000001905466872e-10
+ 1.6412000706218139e-05 2.400000204518705e-10
+ 1.6424207737468138e-05 2.4000002011557764e-10
+ 1.643641476871814e-05 2.4000001946831419e-10
+ 1.6448621799968139e-05 2.4000001925940771e-10
+ 1.6460828831218141e-05 2.4000001980987061e-10
+ 1.6473035862468139e-05 2.4000002089319245e-10
+ 1.6485242893718141e-05 2.4000001973823067e-10
+ 1.649744992496814e-05 2.4000001879346328e-10
+ 1.6509656956218142e-05 2.4000001869932423e-10
+ 1.6521863987468141e-05 2.4000002074828773e-10
+ 1.6534071018718143e-05 2.4000001934026167e-10
+ 1.6546278049968141e-05 2.4000001952115826e-10
+ 1.6558485081218144e-05 2.4000001987859593e-10
+ 1.6570692112468142e-05 2.400000198982881e-10
+ 1.6582899143718144e-05 2.40000018977687e-10
+ 1.6595106174968143e-05 2.4000001970468766e-10
+ 1.6607313206218145e-05 2.4000001969944985e-10
+ 1.6619520237468144e-05 2.4000002027367879e-10
+ 1.6631727268718146e-05 2.4000001840031488e-10
+ 1.6643934299968144e-05 2.4000001957318321e-10
+ 1.6656141331218146e-05 2.400000188108562e-10
+ 1.6668348362468145e-05 2.4000002046679305e-10
+ 1.6680555393718147e-05 2.4000001950571268e-10
+ 1.6692762424968146e-05 2.4000001838116472e-10
+ 1.6704969456218148e-05 2.4000001853089837e-10
+ 1.6717176487468146e-05 2.4000002004811227e-10
+ 1.6729383518718148e-05 2.4000001966057371e-10
+ 1.6741590549968147e-05 2.4000001941089245e-10
+ 1.6753797581218149e-05 2.4000001913185568e-10
+ 1.6766004612468148e-05 2.4000001954838558e-10
+ 1.677821164371815e-05 2.4000001920964592e-10
+ 1.6790418674968148e-05 2.4000001943469307e-10
+ 1.6802625706218151e-05 2.4000001866641258e-10
+ 1.6814832737468149e-05 2.4000002020897109e-10
+ 1.6827039768718151e-05 2.4000001940179987e-10
+ 1.683924679996815e-05 2.4000001993507329e-10
+ 1.6851453831218152e-05 2.4000002008198123e-10
+ 1.6863660862468151e-05 2.400000198005213e-10
+ 1.6875867893718153e-05 2.4000001916301211e-10
+ 1.6888074924968151e-05 2.4000001960280073e-10
+ 1.6900281956218153e-05 2.4000001963117276e-10
+ 1.6912488987468152e-05 2.400000196254434e-10
+ 1.6924696018718154e-05 2.4000002030623543e-10
+ 1.6936903049968153e-05 2.4000001985486468e-10
+ 1.6949110081218155e-05 2.4000001975560508e-10
+ 1.6961317112468153e-05 2.4000002002563028e-10
+ 1.6973524143718155e-05 2.4000001880683233e-10
+ 1.6985731174968154e-05 2.400000186107882e-10
+ 1.6997938206218156e-05 2.4000002026174485e-10
+ 1.7010145237468155e-05 2.4000001964579944e-10
+ 1.7022352268718157e-05 2.4000001869414737e-10
+ 1.7034559299968155e-05 2.4000002024855297e-10
+ 1.7046766331218158e-05 2.4000001886895933e-10
+ 1.7058973362468156e-05 2.4000001996539064e-10
+ 1.7071180393718158e-05 2.4000001852201533e-10
+ 1.7083387424968157e-05 2.4000001995376353e-10
+ 1.7095594456218159e-05 2.4000001885033681e-10
+ 1.7107801487468158e-05 2.400000202275795e-10
+ 1.712000851871816e-05 2.4000001938682899e-10
+ 1.7132215549968158e-05 2.400000185286626e-10
+ 1.714442258121816e-05 2.4000002021567022e-10
+ 1.7156629612468159e-05 2.4000001929093104e-10
+ 1.7168836643718161e-05 2.4000001945502139e-10
+ 1.718104367496816e-05 2.4000001849176264e-10
+ 1.7193250706218162e-05 2.4000001899160695e-10
+ 1.720545773746816e-05 2.4000001908469775e-10
+ 1.7217664768718162e-05 2.4000002021320925e-10
+ 1.7229871799968161e-05 2.4000001986077044e-10
+ 1.7242078831218163e-05 2.4000001985660228e-10
+ 1.7254285862468162e-05 2.4000001982734366e-10
+ 1.7266492893718164e-05 2.4000001909394165e-10
+ 1.7278699924968162e-05 2.4000001971428865e-10
+ 1.7290906956218165e-05 2.4000001921042243e-10
+ 1.7303113987468163e-05 2.400000190589926e-10
+ 1.7315321018718165e-05 2.400000192770844e-10
+ 1.7327528049968164e-05 2.4000001876027354e-10
+ 1.7339735081218166e-05 2.4000001963225885e-10
+ 1.7351942112468165e-05 2.4000001898595255e-10
+ 1.7364149143718167e-05 2.4000001876650681e-10
+ 1.7376356174968165e-05 2.4000001955479303e-10
+ 1.7388563206218167e-05 2.400000192149284e-10
+ 1.7400770237468166e-05 2.4000001962818762e-10
+ 1.7412977268718168e-05 2.400000192259498e-10
+ 1.7425184299968167e-05 2.4000001958046752e-10
+ 1.7437391331218169e-05 2.4000001876653049e-10
+ 1.7449598362468167e-05 2.4000001901679062e-10
+ 1.7461805393718169e-05 2.4000001929188411e-10
+ 1.7474012424968168e-05 2.4000001878460593e-10
+ 1.748621945621817e-05 2.4000001895149019e-10
+ 1.7498426487468169e-05 2.4000001953324466e-10
+ 1.7510633518718171e-05 2.4000001930179932e-10
+ 1.7522840549968169e-05 2.4000001867284628e-10
+ 1.7535047581218171e-05 2.4000001876404646e-10
+ 1.754725461246817e-05 2.4000001844012502e-10
+ 1.7559461643718172e-05 2.4000001847700822e-10
+ 1.7571668674968171e-05 2.4000001848915366e-10
+ 1.7583875706218173e-05 2.4000001847211049e-10
+ 1.7596082737468172e-05 2.4000001842583542e-10
+ 1.7608289768718174e-05 2.4000001874485954e-10
+ 1.7620496799968172e-05 2.4000001864470591e-10
+ 1.7632703831218174e-05 2.400000192645186e-10
+ 1.7644910862468173e-05 2.4000001911011029e-10
+ 1.7657117893718175e-05 2.400000189594016e-10
+ 1.7669324924968174e-05 2.4000001834385696e-10
+ 1.7681531956218176e-05 2.4000001923683012e-10
+ 1.7693738987468174e-05 2.4000002008098464e-10
+ 1.7705946018718176e-05 2.400000183211859e-10
+ 1.7718153049968175e-05 2.4000001983070817e-10
+ 1.7730360081218177e-05 2.4000001841550595e-10
+ 1.7742567112468176e-05 2.4000001987140726e-10
+ 1.7754774143718178e-05 2.4000001839799459e-10
+ 1.7766981174968176e-05 2.4000001979564812e-10
+ 1.7779188206218178e-05 2.4000001826400317e-10
+ 1.7791395237468177e-05 2.3996544537098469e-10
+ 1.7803602268718179e-05 2.3996256464191007e-10
+ 1.7815809299968178e-05 2.3996062147298765e-10
+ 1.782801633121818e-05 2.399538992151035e-10
+ 1.7840223362468179e-05 2.3990864356794482e-10
+ 1.7852430393718181e-05 2.3980391697569448e-10
+ 1.7864637424968179e-05 2.3960325885649169e-10
+ 1.7870740940593179e-05 2.3930636780140344e-10
+ 1.7876844456218181e-05 2.3825018349924986e-10
+ 1.7879896214030681e-05 2.3664385617022961e-10
+ 1.7882947971843181e-05 2.313460144418538e-10
+ 1.788447385074943e-05 2.2273712950258841e-10
+ 1.788599972965568e-05 1.9502932447418286e-10
+ 1.7886991106889184e-05 1.3263414891107653e-10
+ 1.7887269733896243e-05 9.5672269136980181e-11
+ 1.7887548360903299e-05 4.6113023016783446e-11
+ 1.7888098835627971e-05 4.077304569289076e-11
+ 1.7890875273912437e-05 4.2347131994264368e-11
+ 1.7903082305162436e-05 4.4733371018365243e-11
+ 1.7915289336412434e-05 5.3058719093237963e-11
+ 1.7927496367662436e-05 6.5249849962529414e-11
+ 1.7939703398912438e-05 8.0586557341896391e-11
+ 1.7951910430162437e-05 9.8186059694000248e-11
+ 1.7964117461412436e-05 1.1703587328666208e-10
+ 1.7976324492662438e-05 1.3605185310399104e-10
+ 1.798853152391244e-05 1.5414054504639482e-10
+ 1.8000738555162439e-05 1.7026206156240515e-10
+ 1.8012945586412437e-05 1.8348986297121229e-10
+ 1.8025152617662439e-05 1.9306400774952091e-10
+ 1.8037359648912441e-05 1.9843481134517081e-10
+ 1.804956668016244e-05 1.9929440536940058e-10
+ 1.8061773711412439e-05 1.9559438520732841e-10
+ 1.8073980742662441e-05 1.8754853451668201e-10
+ 1.8086187773912443e-05 1.7562047328816539e-10
+ 1.8098394805162441e-05 1.6049694315998822e-10
+ 1.811060183641244e-05 1.4304826930135124e-10
+ 1.8122808867662442e-05 1.2427827523140709e-10
+ 1.8135015898912444e-05 1.052665328361379e-10
+ 1.8147222930162443e-05 8.7106269937226752e-11
+ 1.8159429961412441e-05 7.0841506734532094e-11
+ 1.8171636992662443e-05 5.7407035899497847e-11
+ 1.8183844023912445e-05 4.7574696846103914e-11
+ 1.8186895781724945e-05 4.5750674856066197e-11
+ 1.8187048369615568e-05 4.5666462612461995e-11
+ 1.8187429839342133e-05 4.5458870923120094e-11
+ 1.8187467986314788e-05 4.5438342991126504e-11
+ 1.818747561570932e-05 4.5434242455099145e-11
+ 1.8187490874498381e-05 4.5426046434154427e-11
+ 1.8187496978014006e-05 4.5422769911655126e-11
+ 1.8187499419420258e-05 4.542145960441293e-11
+ 1.8187499604455785e-05 4.5421360302533612e-11
+ 1.8187499974526841e-05 4.5421161701746532e-11
+ 1.8187500714668947e-05 5.7234708751505077e-08
+ 1.8187501454811059e-05 2.3609835104101694e-07
+ 1.8187508856232149e-05 8.3378657603255145e-06
+ 1.8187516257653239e-05 2.6804211983519737e-05
+ 1.8187523659074328e-05 5.4212572160978158e-05
+ 1.8187531060495418e-05 8.9333429400249197e-05
+ 1.8187538461916508e-05 0.00013110387761772142
+ 1.8187547512355688e-05 0.00018988604042548046
+ 1.8187556562794868e-05 0.000255812068272275
+ 1.8187565613234049e-05 0.00032768193023753725
+ 1.8187574663673229e-05 0.00040448949601993325
+ 1.8187583714112412e-05 0.00048539058840956265
+ 1.8187595044533511e-05 0.00059137048504824714
+ 1.8187606374954609e-05 0.00070151686849491022
+ 1.8187617705375708e-05 0.0008149054011463608
+ 1.8187629035796806e-05 0.00093078918228233572
+ 1.8187643214653361e-05 0.0010784080416500865
+ 1.8187657393509916e-05 0.0012280520970111633
+ 1.8187671572366471e-05 0.0013789889014004875
+ 1.8187689032396935e-05 0.0015657925325384681
+ 1.81877064924274e-05 0.0017528666320927736
+ 1.8187723952457861e-05 0.0019395804048633696
+ 1.8187746268477831e-05 0.0021769293571718938
+ 1.8187768584497801e-05 0.0024120996791847497
+ 1.818779090051777e-05 0.0026444704336099976
+ 1.818781909021724e-05 0.0029332237971511233
+ 1.8187847279916712e-05 0.0032158629328255771
+ 1.8187875469616182e-05 0.0034916668520790159
+ 1.8187903659315651e-05 0.0037599988278231356
+ 1.818793184901512e-05 0.0040202830355208904
+ 1.8187960038714589e-05 0.0042719918874605982
+ 1.8187988228414062e-05 0.0045146394015623476
+ 1.8188019414106474e-05 0.0047719795450323309
+ 1.8188050599798883e-05 0.0050171295125712645
+ 1.8188081785491295e-05 0.0052495906087394869
+ 1.8188112971183707e-05 0.0054689190353913904
+ 1.8188150418414336e-05 0.0057143885297757718
+ 1.8188187865644966e-05 0.0059397992525804574
+ 1.8188225312875598e-05 0.006144702220679193
+ 1.8188270844195808e-05 0.0063657430322260553
+ 1.8188316375516022e-05 0.0065556175023236875
+ 1.8188361906836235e-05 0.0067142112673811444
+ 1.8188407438156445e-05 0.0068416534980290083
+ 1.818844108402811e-05 0.0069160175765833089
+ 1.8188474729899776e-05 0.0069737900261410465
+ 1.8188508375771441e-05 0.0070152594941248576
+ 1.8188542021643107e-05 0.0070407746969006688
+ 1.8188575667514772e-05 0.007050740823760393
+ 1.8188609313386438e-05 0.0070456156939712805
+ 1.8188642959258103e-05 0.007025905702338452
+ 1.8188676605129769e-05 0.0069921615895264296
+ 1.8188710251001434e-05 0.0069449740739896257
+ 1.8188736870668147e-05 0.006898526876910809
+ 1.8188763490334857e-05 0.0068443802044164921
+ 1.8188790110001567e-05 0.0067828688534493494
+ 1.818881672966828e-05 0.0067143369242957376
+ 1.818884334933499e-05 0.0066391364097472113
+ 1.81888699690017e-05 0.0065576257964309343
+ 1.818889658866841e-05 0.0064701686843428533
+ 1.818892320833512e-05 0.0063771324303375145
+ 1.8188949828001833e-05 0.0062788868210215225
+ 1.8188976447668543e-05 0.0061758027801676225
+ 1.8189003067335253e-05 0.0060682511154162089
+ 1.8189029687001966e-05 0.0059566013086644297
+ 1.8189056306668676e-05 0.0058412203541628417
+ 1.8189082926335386e-05 0.0057224716479485063
+ 1.8189109546002096e-05 0.0056007139318451742
+ 1.8189136165668806e-05 0.0054763002948580381
+ 1.8189162785335519e-05 0.0053495772343856614
+ 1.8189189405002229e-05 0.0052208837792675896
+ 1.8189216024668939e-05 0.0050905506764474901
+ 1.8189239404935229e-05 0.0049749804171373225
+ 1.8189262785201516e-05 0.0048586054363550972
+ 1.8189286165467805e-05 0.0047416314482211135
+ 1.8189309545734092e-05 0.0046242577652878883
+ 1.8189332926000382e-05 0.0045066770343838705
+ 1.8189356306266668e-05 0.0043890750025309139
+ 1.8189379686532958e-05 0.0042716303126259531
+ 1.8189403066799245e-05 0.0041545143284691553
+ 1.8189426447065535e-05 0.0040378909886185305
+ 1.8189449827331821e-05 0.0039219166884552218
+ 1.8189473207598111e-05 0.0038067401897542695
+ 1.8189496587864398e-05 0.0036925025569730643
+ 1.8189519968130688e-05 0.0035793371193940525
+ 1.8189543348396974e-05 0.0034673694581895016
+ 1.8189566728663264e-05 0.0033567174174145066
+ 1.818959010892955e-05 0.0032474911378798247
+ 1.818961348919584e-05 0.0031397931128086067
+ 1.8189636869462127e-05 0.0030337182641405314
+ 1.8189660249728417e-05 0.0029293540383132049
+ 1.8189683629994703e-05 0.0028267805203238136
+ 1.8189707010260993e-05 0.0027260705648536779
+ 1.8189735591237517e-05 0.0026055855381113117
+ 1.8189764172214041e-05 0.0024880893416989024
+ 1.8189792753190565e-05 0.0023736731389782805
+ 1.8189821334167089e-05 0.0022624136400195647
+ 1.8189849915143613e-05 0.0021543736566158275
+ 1.8189886199806211e-05 0.0020219271947776738
+ 1.8189925453373381e-05 0.0018846580284455387
+ 1.8189946977215263e-05 0.0018120618774395494
+ 1.8189973696714699e-05 0.0017245821083065652
+ 1.8190000416214135e-05 0.0016400258203643724
+ 1.8190027135713571e-05 0.0015583844444338579
+ 1.8190053855213007e-05 0.0014796423351417674
+ 1.8190080574712443e-05 0.0014037772468436488
+ 1.8190107294211879e-05 0.0013307608065583204
+ 1.8190134013711316e-05 0.0012605589819463642
+ 1.8190160733210752e-05 0.0011931325425094006
+ 1.8190187452710188e-05 0.0011284375123336611
+ 1.8190214172209624e-05 0.0010664256128491564
+ 1.819024089170906e-05 0.0010070446942234952
+ 1.8190262548859613e-05 0.00096080661895637035
+ 1.8190284206010163e-05 0.0009162294538821239
+ 1.8190305863160713e-05 0.00087328092606094238
+ 1.8190327520311267e-05 0.00083192771752318962
+ 1.819034917746182e-05 0.00079213559354230647
+ 1.819037083461237e-05 0.00075386952625768001
+ 1.819039249176292e-05 0.00071709381353394315
+ 1.8190414148913474e-05 0.00068177219296354193
+ 1.8190435806064027e-05 0.00064786795094112185
+ 1.8190457463214577e-05 0.00061534402675914772
+ 1.8190479120365127e-05 0.00058416311167918647
+ 1.8190496765399602e-05 0.00055972551886932095
+ 1.8190514410434077e-05 0.00053613426244406741
+ 1.8190532055468551e-05 0.00051336904748169171
+ 1.8190549700503026e-05 0.00049140960981622914
+ 1.8190567345537497e-05 0.00047023574348777509
+ 1.8190584990571972e-05 0.00044982732676715286
+ 1.8190602635606446e-05 0.00043016434677204047
+ 1.8190620280640917e-05 0.00041122692269401575
+ 1.8190637925675392e-05 0.00039299532765819798
+ 1.8190655570709867e-05 0.00037545000923921415
+ 1.8190673215744341e-05 0.00035857160865911174
+ 1.8190690860778816e-05 0.00034234097869457157
+ 1.8190708505813287e-05 0.00032673920032235228
+ 1.8190726150847762e-05 0.00031174759813332067
+ 1.8190743795882236e-05 0.00029734775454669758
+ 1.8190761440916708e-05 0.00028352152285727745
+ 1.8190779085951182e-05 0.0002702510391493668
+ 1.8190796730985657e-05 0.00025751873311203796
+ 1.8190814376020131e-05 0.00024530733779101174
+ 1.8190832021054606e-05 0.00023359989831307307
+ 1.8190849666089077e-05 0.00022237977961939102
+ 1.8190867311123552e-05 0.00021163067324446447
+ 1.8190884956158027e-05 0.00020133660317765155
+ 1.8190902601192498e-05 0.00019148193084437179
+ 1.8190920246226972e-05 0.00018205135924409671
+ 1.8190937891261447e-05 0.00017302993628217709
+ 1.8190955536295922e-05 0.00016440305733239472
+ 1.8190973181330396e-05 0.00015615646706688136
+ 1.8190990826364867e-05 0.00014827626058972067
+ 1.8191008471399342e-05 0.00014074888391014853
+ 1.8191026116433817e-05 0.00013356113379079491
+ 1.8191043761468288e-05 0.00012670015700587552
+ 1.8191061406502763e-05 0.00012015344904364461
+ 1.8191079051537237e-05 0.00011390885228677083
+ 1.8191096696571712e-05 0.00010795455370359766
+ 1.8191114341606186e-05 0.00010227908208250491
+ 1.8191131986640658e-05 9.687130484080241e-05
+ 1.8191149631675132e-05 9.1720424438765868e-05
+ 1.8191167276709607e-05 8.6815974428572379e-05
+ 1.8191184921744078e-05 8.2147815167013072e-05
+ 1.8191202566778553e-05 7.7706129219957601e-05
+ 1.8191220211813027e-05 7.3481416485622882e-05
+ 1.8191237856847502e-05 6.9464489062760908e-05
+ 1.8191255501881976e-05 6.5646465888930612e-05
+ 1.8191273146916448e-05 6.2018767173060703e-05
+ 1.8191290791950922e-05 5.8573108645546759e-05
+ 1.8191308436985397e-05 5.5301495648160228e-05
+ 1.8191326082019868e-05 5.2196217085081444e-05
+ 1.8191343727054343e-05 4.9249839255407143e-05
+ 1.8191361372088817e-05 4.6455199586526805e-05
+ 1.8191379017123292e-05 4.3805400286814076e-05
+ 1.8191396662157767e-05 4.1293801935142287e-05
+ 1.8191414307192238e-05 3.8914017023807698e-05
+ 1.8191431952226712e-05 3.6659903470533496e-05
+ 1.8191449597261187e-05 3.4525558114332587e-05
+ 1.8191467242295658e-05 3.2505310209129923e-05
+ 1.8191484887330133e-05 3.0593714928186798e-05
+ 1.8191502532364608e-05 2.878554689153125e-05
+ 1.8191520177399082e-05 2.7075793727781893e-05
+ 1.8191537822433557e-05 2.5459649680957857e-05
+ 1.8191555467468028e-05 2.3932509272096093e-05
+ 1.8191573112502503e-05 2.2489961024749567e-05
+ 1.8191590757536977e-05 2.1127781262716843e-05
+ 1.8191608402571448e-05 1.9841927987655173e-05
+ 1.8191626047605923e-05 1.8628534843556469e-05
+ 1.8191643692640398e-05 1.7483905174418017e-05
+ 1.8191661337674872e-05 1.6404506180818473e-05
+ 1.8191682620107577e-05 1.5184596516820046e-05
+ 1.8191702745281677e-05 1.4108722156777394e-05
+ 1.8191722870455781e-05 1.3103783271809466e-05
+ 1.8191742995629884e-05 1.2165512099818384e-05
+ 1.8191763120803984e-05 1.1289867233639744e-05
+ 1.8191783245978088e-05 1.0473023791237365e-05
+ 1.8191803371152191e-05 9.711363860421274e-06
+ 1.8191823496326295e-05 9.0014672215583367e-06
+ 1.8191843621500398e-05 8.3401023506671107e-06
+ 1.8191863746674498e-05 7.7242177042852387e-06
+ 1.8191888110746127e-05 7.0353574872189284e-06
+ 1.8191912474817753e-05 6.4041509733236313e-06
+ 1.8191936838889382e-05 5.8261375978047346e-06
+ 1.8191961202961008e-05 5.2971679183216326e-06
+ 1.8191985567032637e-05 4.8133849648221628e-06
+ 1.8192009931104263e-05 4.3712064413582404e-06
+ 1.8192034295175892e-05 3.9673077642003495e-06
+ 1.8192058659247518e-05 3.5986059186122073e-06
+ 1.8192083023319147e-05 3.2622441148827113e-06
+ 1.8192107387390773e-05 2.955577222710442e-06
+ 1.819213671968357e-05 2.6223173518557521e-06
+ 1.8192166051976363e-05 2.3246430183300364e-06
+ 1.8192195384269159e-05 2.0589938235170389e-06
+ 1.8192224716561953e-05 1.8221375097881734e-06
+ 1.8192254048854749e-05 1.6111428978970881e-06
+ 1.8192283381147542e-05 1.4233547079677823e-06
+ 1.8192312713440339e-05 1.2563701699769522e-06
+ 1.8192342045733132e-05 1.1080173307665688e-06
+ 1.8192377848029196e-05 9.4935328593955194e-07
+ 1.8192412335454631e-05 8.1703614317247063e-07
+ 1.8192446822880062e-05 7.0231034037170861e-07
+ 1.8192481310305496e-05 6.0295931014601184e-07
+ 1.819251579773093e-05 5.1702814794412422e-07
+ 1.8192557828321208e-05 4.2796498791424164e-07
+ 1.8192599858911486e-05 3.5358466304975593e-07
+ 1.8192641889501768e-05 2.9157919961691281e-07
+ 1.8192683920092046e-05 2.3998333476715486e-07
+ 1.8192725950682324e-05 1.9712710629082681e-07
+ 1.8192777518503423e-05 1.5442331314774624e-07
+ 1.8192828186666481e-05 1.2110746118199679e-07
+ 1.819287885482954e-05 9.4668212428266369e-08
+ 1.8192929522992598e-05 7.3741045625230226e-08
+ 1.8192993215143463e-05 5.3572482382509411e-08
+ 1.8193056907294327e-05 3.8650410566722333e-08
+ 1.8193120599445191e-05 2.7655607125139506e-08
+ 1.8193198945610715e-05 1.80624388894615e-08
+ 1.8193278657649689e-05 1.1455385675920075e-08
+ 1.8193358369688668e-05 7.0279116712338033e-09
+ 1.8193461292370763e-05 3.42722610432318e-09
+ 1.8193569508909819e-05 1.2415251844169095e-09
+ 1.8193701914804437e-05 -1.7423168879043324e-10
+ 1.8193847065030182e-05 -9.0046498724308251e-10
+ 1.8194034315235683e-05 -1.2675598336250834e-09
+ 1.8194255865010425e-05 -1.390661486095478e-09
+ 1.8194554034092505e-05 -1.4079464626524889e-09
+ 1.8194998769870887e-05 -1.3781166774969621e-09
+ 1.8195805003988993e-05 -1.313948994893242e-09
+ 1.8196711764368317e-05 -1.2450592154006523e-09
+ 1.8197737475686441e-05 -1.1711746826522686e-09
+ 1.8198801143402341e-05 -1.0985374417948889e-09
+ 1.8199944764949548e-05 -1.0244977902794022e-09
+ 1.820223164627891e-05 -8.876839903243166e-10
+ 1.8204182681216658e-05 -7.8153991862173163e-10
+ 1.8206291228517249e-05 -6.7660226349856925e-10
+ 1.820858146743616e-05 -5.7299433820914436e-10
+ 1.8210926666850022e-05 -4.7698621811411996e-10
+ 1.8213271866263886e-05 -3.901690868650475e-10
+ 1.821559053717963e-05 -3.1248869476676087e-10
+ 1.821847456948428e-05 -2.2600941125466692e-10
+ 1.822135860178893e-05 -1.4953972152878652e-10
+ 1.8224242634093576e-05 -8.1909642546355165e-11
+ 1.8227126666398226e-05 -2.2097231394821104e-11
+ 1.8230010698702876e-05 3.0804763949844941e-11
+ 1.8232894731007526e-05 7.7599184420572088e-11
+ 1.8235778763312176e-05 1.1899177680085989e-10
+ 1.8239342797663593e-05 1.6360497315690482e-10
+ 1.8242906832015013e-05 2.0194460469335925e-10
+ 1.8246470866366434e-05 2.3489304324568193e-10
+ 1.8250034900717851e-05 2.6320792465228799e-10
+ 1.8253598935069271e-05 2.8754418863776942e-10
+ 1.8257899961127361e-05 3.124003450031708e-10
+ 1.8262200987185451e-05 3.3310188136055884e-10
+ 1.8266502013243541e-05 3.5034335018174361e-10
+ 1.8270803039301627e-05 3.6470346013268147e-10
+ 1.8275104065359717e-05 3.7666442373221598e-10
+ 1.8280502505986984e-05 3.8888313831481749e-10
+ 1.8285900946614247e-05 3.9859542479219459e-10
+ 1.8291299387241515e-05 4.0629545583254085e-10
+ 1.8296697827868782e-05 4.1242659596079512e-10
+ 1.8303468247657469e-05 4.1836450212166619e-10
+ 1.8310238667446157e-05 4.228142873871682e-10
+ 1.8317009087234845e-05 4.2614500842071573e-10
+ 1.8325385304343957e-05 4.2912633403108892e-10
+ 1.833376152145307e-05 4.3120345772378355e-10
+ 1.8342137738562182e-05 4.3264838822889765e-10
+ 1.8353043385488655e-05 4.3388610175178318e-10
+ 1.836394903241513e-05 4.3464666000495187e-10
+ 1.8376156063665133e-05 4.3514763453961883e-10
+ 1.8388363094915131e-05 4.3542384097085643e-10
+ 1.840057012616513e-05 4.3556624282357159e-10
+ 1.8412777157415132e-05 4.3562884855868211e-10
+ 1.8424984188665134e-05 4.3564390919099658e-10
+ 1.8437191219915133e-05 4.3563071731303817e-10
+ 1.8449398251165131e-05 4.3560072832369711e-10
+ 1.8461605282415133e-05 4.3556071800624522e-10
+ 1.8473812313665135e-05 4.3551473285478916e-10
+ 1.8486019344915134e-05 4.3546520640556509e-10
+ 1.8498226376165133e-05 4.3541358487496968e-10
+ 1.8510433407415135e-05 4.3536071753580087e-10
+ 1.8522640438665137e-05 4.353071102954193e-10
+ 1.8534847469915135e-05 4.3525307030070124e-10
+ 1.8547054501165134e-05 4.3519878102624261e-10
+ 1.8559261532415136e-05 4.3514434891989702e-10
+ 1.8571468563665138e-05 4.3508983678706616e-10
+ 1.8583675594915137e-05 4.3503528333983576e-10
+ 1.8595882626165135e-05 4.3498071205926307e-10
+ 1.8608089657415137e-05 4.3492613633167183e-10
+ 1.862029668866514e-05 4.348715638520445e-10
+ 1.8632503719915138e-05 4.3481699946235471e-10
+ 1.8644710751165137e-05 4.3476244620745766e-10
+ 1.8656917782415139e-05 4.3470790578886986e-10
+ 1.8669124813665141e-05 4.3465337912630206e-10
+ 1.868133184491514e-05 4.3459886680952396e-10
+ 1.8693538876165138e-05 4.3454436923774573e-10
+ 1.870574590741514e-05 4.3448988663097442e-10
+ 1.8717952938665142e-05 4.3443541909242035e-10
+ 1.8730159969915141e-05 4.3438096668679938e-10
+ 1.874236700116514e-05 4.3432652946422885e-10
+ 1.8750000000000002e-05 4.3429323819786375e-10
+ 1.876220703125e-05 4.3423882549145797e-10
+ 1.8774414062500002e-05 4.3418442800650571e-10
+ 1.8786621093750001e-05 4.3413004574565444e-10
+ 1.8798828125000003e-05 4.3407567870875607e-10
+ 1.8811035156250002e-05 4.3402132689399754e-10
+ 1.88232421875e-05 4.3396699029857563e-10
+ 1.8835449218750002e-05 4.3391266891909689e-10
+ 1.8847656250000001e-05 4.338583627518177e-10
+ 1.8859863281250003e-05 4.338040717927861e-10
+ 1.8872070312500002e-05 4.3374979603792648e-10
+ 1.8884277343750001e-05 4.3369553548309005e-10
+ 1.8896484375000003e-05 4.3364129012408513e-10
+ 1.8908691406250001e-05 4.3358705995669485e-10
+ 1.8920898437500003e-05 4.3353284497668784e-10
+ 1.8933105468750002e-05 4.3347864517982436e-10
+ 1.8945312500000001e-05 4.3342446056186068e-10
+ 1.8957519531250003e-05 4.3337029111855061e-10
+ 1.8969726562500001e-05 4.3331613684564742e-10
+ 1.8981933593750003e-05 4.3326199773890431e-10
+ 1.8994140625000002e-05 4.3320787379407488e-10
+ 1.9006347656250001e-05 4.3315376500691365e-10
+ 1.9018554687500003e-05 4.3309967137317592e-10
+ 1.9030761718750001e-05 4.3304559288861817e-10
+ 1.9042968750000003e-05 4.3299152954899793e-10
+ 1.9055175781250002e-05 4.3293748135007384e-10
+ 1.9067382812500001e-05 4.3288344828760572e-10
+ 1.9079589843750003e-05 4.3282943035735457e-10
+ 1.9091796875000001e-05 4.3277542755508266e-10
+ 1.910400390625e-05 4.327214398765532e-10
+ 1.9116210937500002e-05 4.3266746731753079e-10
+ 1.9128417968750001e-05 4.3261350987378112e-10
+ 1.9140625000000003e-05 4.3255956754107106e-10
+ 1.9152832031250001e-05 4.3250564031516869e-10
+ 1.91650390625e-05 4.324517281918434e-10
+ 1.9177246093750002e-05 4.3239783116686546e-10
+ 1.9189453125000001e-05 4.3234394923600652e-10
+ 1.9201660156250003e-05 4.3229008239503964e-10
+ 1.9213867187500001e-05 4.322362306397386e-10
+ 1.922607421875e-05 4.3218239396587857e-10
+ 1.9238281250000002e-05 4.3212857236923607e-10
+ 1.9250488281250001e-05 4.3207476584558855e-10
+ 1.9262695312500003e-05 4.3202097439071481e-10
+ 1.9274902343750002e-05 4.3196719800039462e-10
+ 1.9287109375e-05 4.3191343667040926e-10
+ 1.9299316406250002e-05 4.3185969039654094e-10
+ 1.9311523437500001e-05 4.3180595917457319e-10
+ 1.9323730468750003e-05 4.3175224300029046e-10
+ 1.9335937500000002e-05 4.3169854186947872e-10
+ 1.934814453125e-05 4.3164485577792515e-10
+ 1.9360351562500002e-05 4.3159118472141752e-10
+ 1.9372558593750001e-05 4.315375286957455e-10
+ 1.9384765625000003e-05 4.3148388769669956e-10
+ 1.9396972656250002e-05 4.3143026172007142e-10
+ 1.94091796875e-05 4.3137665076165393e-10
+ 1.9421386718750002e-05 4.3132305481724119e-10
+ 1.9433593750000001e-05 4.3126947388262849e-10
+ 1.9445800781250003e-05 4.3121590795361226e-10
+ 1.9458007812500002e-05 4.3116235702599014e-10
+ 1.9470214843750004e-05 4.311088210955608e-10
+ 1.9482421875000002e-05 4.3105530015812432e-10
+ 1.9494628906250001e-05 4.3100179420948178e-10
+ 1.9506835937500003e-05 4.3094830324543561e-10
+ 1.9519042968750002e-05 4.3089482726178914e-10
+ 1.9531250000000004e-05 4.3084136625434698e-10
+ 1.9543457031250002e-05 4.3078792021891527e-10
+ 1.9555664062500001e-05 4.3073448915130076e-10
+ 1.9567871093750003e-05 4.3068107304731183e-10
+ 1.9580078125000002e-05 4.3062767190275767e-10
+ 1.9592285156250004e-05 4.3057428571344897e-10
+ 1.9604492187500003e-05 4.305209144751974e-10
+ 1.9616699218750001e-05 4.3046755818381573e-10
+ 1.9628906250000003e-05 4.3041421683511815e-10
+ 1.9641113281250002e-05 4.3036089042491982e-10
+ 1.9653320312500004e-05 4.3030757894903721e-10
+ 1.9665527343750003e-05 4.3025428240328784e-10
+ 1.9677734375000001e-05 4.3020100078349046e-10
+ 1.9689941406250003e-05 4.3014773408546503e-10
+ 1.9702148437500002e-05 4.3009448230503257e-10
+ 1.9714355468750004e-05 4.3004124543801536e-10
+ 1.9726562500000003e-05 4.2998802348023685e-10
+ 1.9738769531250001e-05 4.2993481642752165e-10
+ 1.9750976562500003e-05 4.298816242756955e-10
+ 1.9763183593750002e-05 4.2982844702058526e-10
+ 1.9775390625000004e-05 4.2977528465801911e-10
+ 1.9787597656250003e-05 4.2972213718382639e-10
+ 1.9799804687500001e-05 4.296690045938374e-10
+ 1.9812011718750003e-05 4.2961588688388387e-10
+ 1.9824218750000002e-05 4.2956278404979846e-10
+ 1.9836425781250001e-05 4.2950969608741529e-10
+ 1.9848632812500003e-05 4.2945662299256918e-10
+ 1.9860839843750001e-05 4.2940356476109669e-10
+ 1.9873046875e-05 4.2935052138883517e-10
+ 1.9885253906250002e-05 4.2929749287162315e-10
+ 1.9897460937500001e-05 4.2924447920530045e-10
+ 1.9909667968750003e-05 4.2919148038570803e-10
+ 1.9921875000000001e-05 4.2913849640868801e-10
+ 1.993408203125e-05 4.2908552727008359e-10
+ 1.9946289062500002e-05 4.2903257296573924e-10
+ 1.9958496093750001e-05 4.2897963349150058e-10
+ 1.9970703125000003e-05 4.2892670884321429e-10
+ 1.9982910156250001e-05 4.288737990167283e-10
+ 1.99951171875e-05 4.2882090400789185e-10
+ 2.0007324218750002e-05 4.2876802381255504e-10
+ 2.0019531250000001e-05 4.2871515842656934e-10
+ 2.0031738281249999e-05 4.2866230784578723e-10
+ 2.0043945312500002e-05 4.2860947206606246e-10
+ 2.005615234375e-05 4.2855665108325002e-10
+ 2.0068359374999999e-05 4.2850384489320595e-10
+ 2.0080566406250001e-05 4.2845105349178732e-10
+ 2.00927734375e-05 4.2839827687485269e-10
+ 2.0104980468750002e-05 4.2834551503826145e-10
+ 2.01171875e-05 4.2829276797787439e-10
+ 2.0129394531249999e-05 4.2824003568955333e-10
+ 2.0141601562500001e-05 4.2818731816916134e-10
+ 2.015380859375e-05 4.2813461541256231e-10
+ 2.0166015625000002e-05 4.2808192741562203e-10
+ 2.017822265625e-05 4.2802925417420679e-10
+ 2.0190429687499999e-05 4.2797659568418397e-10
+ 2.0202636718750001e-05 4.2792395194142275e-10
+ 2.021484375e-05 4.2787132294179297e-10
+ 2.0227050781249998e-05 4.2781870868116553e-10
+ 2.02392578125e-05 4.2776610915541303e-10
+ 2.0251464843749999e-05 4.2771352436040875e-10
+ 2.0263671874999998e-05 4.2766095429202714e-10
+ 2.027587890625e-05 4.2760839894614423e-10
+ 2.0288085937499998e-05 4.2755585831863669e-10
+ 2.030029296875e-05 4.2750333240538267e-10
+ 2.0312499999999999e-05 4.2745082120226136e-10
+ 2.0324707031249998e-05 4.2739832470515305e-10
+ 2.03369140625e-05 4.273458429099393e-10
+ 2.0349121093749998e-05 4.2729337581250278e-10
+ 2.0361328125e-05 4.2724092340872732e-10
+ 2.0373535156249999e-05 4.2718848569449787e-10
+ 2.0385742187499998e-05 4.2713606266570053e-10
+ 2.039794921875e-05 4.2708365431822263e-10
+ 2.0410156249999998e-05 4.270312606479525e-10
+ 2.0422363281249997e-05 4.2697888165077988e-10
+ 2.0434570312499999e-05 4.2692651732259529e-10
+ 2.0446777343749998e-05 4.2687416765929084e-10
+ 2.0458984374999996e-05 4.2682183265675928e-10
+ 2.0471191406249999e-05 4.2676951231089505e-10
+ 2.0483398437499997e-05 4.2671720661759342e-10
+ 2.0495605468749999e-05 4.2666491557275079e-10
+ 2.0507812499999998e-05 4.2661263917226478e-10
+ 2.0520019531249997e-05 4.265603774120343e-10
+ 2.0532226562499999e-05 4.265081302879591e-10
+ 2.0544433593749997e-05 4.2645589779594043e-10
+ 2.0556640624999999e-05 4.2640367993188038e-10
+ 2.0568847656249998e-05 4.2635147669168246e-10
+ 2.0581054687499997e-05 4.2629928807125108e-10
+ 2.0593261718749999e-05 4.2624711406649186e-10
+ 2.0605468749999997e-05 4.2619495467331169e-10
+ 2.0617675781249996e-05 4.2614280988761856e-10
+ 2.0629882812499998e-05 4.2609067970532156e-10
+ 2.0642089843749997e-05 4.2603856412233079e-10
+ 2.0654296874999995e-05 4.2598646313455786e-10
+ 2.0666503906249997e-05 4.2593437673791515e-10
+ 2.0678710937499996e-05 4.2588230492831644e-10
+ 2.0690917968749998e-05 4.2583024770167654e-10
+ 2.0703124999999997e-05 4.2577820505391141e-10
+ 2.0715332031249995e-05 4.2572617698093814e-10
+ 2.0727539062499997e-05 4.2567416347867499e-10
+ 2.0739746093749996e-05 4.2562216454304139e-10
+ 2.0751953124999998e-05 4.2557018016995789e-10
+ 2.0764160156249997e-05 4.2551821035534623e-10
+ 2.0776367187499995e-05 4.2546625509512913e-10
+ 2.0788574218749997e-05 4.254143143852306e-10
+ 2.0800781249999996e-05 4.2536238822157581e-10
+ 2.0812988281249995e-05 4.2531047660009089e-10
+ 2.0825195312499997e-05 4.2525857951670346e-10
+ 2.0837402343749995e-05 4.252066969673418e-10
+ 2.0849609374999994e-05 4.2515482894793579e-10
+ 2.0861816406249996e-05 4.2510297545441604e-10
+ 2.0874023437499995e-05 4.2505113648271467e-10
+ 2.0886230468749997e-05 4.2499931202876474e-10
+ 2.0898437499999996e-05 4.2494750208850055e-10
+ 2.0910644531249994e-05 4.248957066578573e-10
+ 2.0922851562499996e-05 4.2482519493572964e-10
+ 2.0935058593749995e-05 4.2475256100502045e-10
+ 2.0947265624999997e-05 4.2468173951608737e-10
+ 2.0959472656249996e-05 4.2459666096075283e-10
+ 2.0971679687499994e-05 4.2448010616874532e-10
+ 2.0983886718749996e-05 4.242745676347303e-10
+ 2.0989990234374996e-05 4.2406762246865748e-10
+ 2.0996093749999995e-05 4.2364446431160585e-10
+ 2.0999145507812495e-05 4.2320637096990359e-10
+ 2.1002197265624994e-05 4.2237081875579266e-10
+ 2.1005249023437494e-05 4.2039912634768696e-10
+ 2.1006606790774089e-05 4.184858057925494e-10
+ 2.1006998216660862e-05 4.1769354662518729e-10
+ 2.1007389642547638e-05 4.1673967866159501e-10
+ 2.1008368207264574e-05 4.1328644574257995e-10
+ 2.1009409502908188e-05 4.0647792025774505e-10
+ 2.1009970598735324e-05 4.0009399586852752e-10
+ 2.1010339629298369e-05 3.9400830485401903e-10
+ 2.1011110323815844e-05 3.7217296598144555e-10
+ 2.101174148123385e-05 3.3482378565862255e-10
+ 2.1012113084009009e-05 2.9476725253157392e-10
+ 2.101243419379579e-05 2.3913652951300332e-10
+ 2.1012647097925413e-05 2.1273235713088472e-10
+ 2.1012860002055031e-05 2.1207408791108858e-10
+ 2.1014989043351246e-05 2.1185023895337551e-10
+ 2.1027196074601244e-05 2.0757980032582087e-10
+ 2.1039403105851246e-05 1.9827504053149293e-10
+ 2.1051610137101245e-05 1.8447156434439206e-10
+ 2.1063817168351247e-05 1.6696410651490149e-10
+ 2.1076024199601246e-05 1.4676018343964647e-10
+ 2.1088231230851244e-05 1.2502212943217047e-10
+ 2.1100438262101246e-05 1.0300022779102304e-10
+ 2.1112645293351245e-05 8.1960799754197404e-11
+ 2.1124852324601244e-05 6.311338755160194e-11
+ 2.1137059355851246e-05 4.7541218733423125e-11
+ 2.1149266387101244e-05 3.6138949326912032e-11
+ 2.1161473418351243e-05 2.9561263935700322e-11
+ 2.1173680449601245e-05 2.8185285811614418e-11
+ 2.1185887480851244e-05 3.2088955187765566e-11
+ 2.1198094512101246e-05 4.1046615499322252e-11
+ 2.1210301543351244e-05 5.4542057385810135e-11
+ 2.1222508574601243e-05 7.1798266491615728e-11
+ 2.1234715605851245e-05 9.1822160785597292e-11
+ 2.1246922637101244e-05 1.1346174161334856e-10
+ 2.1259129668351246e-05 1.3547236949090519e-10
+ 2.1271336699601245e-05 1.5658835172212636e-10
+ 2.1283543730851243e-05 1.7559572435646284e-10
+ 2.1295750762101245e-05 1.9140204326212496e-10
+ 2.1307957793351244e-05 2.030991720132836e-10
+ 2.1311009551163744e-05 2.0529687447679853e-10
+ 2.1311314726944992e-05 2.0549982177660819e-10
+ 2.1312077666398119e-05 2.0599366009052315e-10
+ 2.131245913612468e-05 2.062333046850057e-10
+ 2.1312482977982591e-05 2.0624812098499301e-10
+ 2.1312487746354171e-05 2.0625108196291897e-10
+ 2.1312497283097339e-05 2.0625700163649109e-10
+ 2.131249804603679e-05 2.0625747507891284e-10
+ 2.1312499571915698e-05 2.0625842190532621e-10
+ 2.131249969398601e-05 2.0625849764807365e-10
+ 2.1312499938126635e-05 2.0625864913207268e-10
+ 2.1312499957657883e-05 2.0625866125070641e-10
+ 2.1312499996720383e-05 2.0625868548793557e-10
+ 2.1312500074845383e-05 8.3574849775232329e-10
+ 2.1312500152970382e-05 2.8382408459534785e-09
+ 2.1312500934220379e-05 9.7910663945931592e-08
+ 2.1312508051845977e-05 6.9281309170090845e-06
+ 2.1312515169471571e-05 2.3496919613390592e-05
+ 2.1312522287097169e-05 4.8515586154137975e-05
+ 2.1312529404722766e-05 8.0864107426474553e-05
+ 2.1312536522348361e-05 0.0001195688537478285
+ 2.1312543639973958e-05 0.00016378325676260678
+ 2.1312550757599556e-05 0.00021277103077073492
+ 2.131255787522515e-05 0.00026589161027525284
+ 2.1312564992850748e-05 0.00032258751106878353
+ 2.1312572110476342e-05 0.00038237336083026571
+ 2.131257922810194e-05 0.00044482637875059637
+ 2.1312587807568572e-05 0.00052313156179263198
+ 2.1312596387035204e-05 0.00060422377214069478
+ 2.1312604966501836e-05 0.00068763160407692863
+ 2.1312613545968468e-05 0.00077295453496090106
+ 2.13126221254351e-05 0.00085985181282763258
+ 2.1312630704901732e-05 0.00094803308914625053
+ 2.1312639284368364e-05 0.0010372505228311898
+ 2.1312647863834996e-05 0.0011272921245865509
+ 2.131265818077025e-05 0.0012364048498757886
+ 2.1312668497705507e-05 0.0013461799437633384
+ 2.1312678814640764e-05 0.0014563930288477433
+ 2.1312689131576018e-05 0.001566855276772596
+ 2.1312699448511271e-05 0.0016774068636345029
+ 2.1312709765446529e-05 0.001787911643031166
+ 2.1312720082381786e-05 0.0018982528107135616
+ 2.1312730399317039e-05 0.0020083293767566338
+ 2.1312742902012258e-05 0.002141246780886198
+ 2.1312755404707477e-05 0.0022735106700283729
+ 2.1312767907402696e-05 0.0024050029041599369
+ 2.1312780410097916e-05 0.0025356196305195535
+ 2.1312792912793138e-05 0.0026652683340791378
+ 2.1312805415488357e-05 0.002793865545581445
+ 2.1312817918183576e-05 0.0029213350620943554
+ 2.1312830420878795e-05 0.0030476065669750823
+ 2.1312845592253873e-05 0.0031991277392290247
+ 2.1312860763628955e-05 0.0033486794005026179
+ 2.1312875935004036e-05 0.0034961593179601309
+ 2.1312891106379114e-05 0.0036414711081661105
+ 2.1312906277754193e-05 0.0037845233735065873
+ 2.1312921449129274e-05 0.0039252290818992874
+ 2.1312936620504356e-05 0.0040635051254073566
+ 2.131295486051956e-05 0.0042264209820281088
+ 2.1312973100534768e-05 0.0043855785109888799
+ 2.1312991340549975e-05 0.004540852807539594
+ 2.1313009580565183e-05 0.0046921255232483241
+ 2.1313027820580391e-05 0.004839284756390172
+ 2.1313046060595599e-05 0.0049822250059800644
+ 2.1313068199865847e-05 0.0051499118748984281
+ 2.1313090339136095e-05 0.0053110729761570875
+ 2.1313112478406344e-05 0.0054655577982168782
+ 2.1313134617676592e-05 0.0056132299331846198
+ 2.131316129301132e-05 0.0057819364493443522
+ 2.1313187873095808e-05 0.0059398423573548687
+ 2.1313214453180299e-05 0.0060874136176253622
+ 2.131324868848434e-05 0.0062620603819550135
+ 2.1313282923788385e-05 0.0064191641307141745
+ 2.131331535612705e-05 0.0065517091134031152
+ 2.1313347788465711e-05 0.0066683776453289999
+ 2.1313380220804376e-05 0.0067692021882621509
+ 2.1313412653143038e-05 0.0068542763543729904
+ 2.1313445085481702e-05 0.0069237529436825757
+ 2.1313477517820367e-05 0.0069778416850672731
+ 2.1313509950159029e-05 0.0070168067033145008
+ 2.1313542382497694e-05 0.0070409637367341727
+ 2.1313569584998149e-05 0.0070500711051410814
+ 2.1313596787498601e-05 0.0070492564131712353
+ 2.1313623989999053e-05 0.0070387804986578604
+ 2.1313651192499508e-05 0.0070189238317284377
+ 2.1313678394999963e-05 0.0069899850256677273
+ 2.1313705597500415e-05 0.0069522793135452206
+ 2.1313732800000867e-05 0.0069061369988542495
+ 2.1313760002501322e-05 0.0068519018883273245
+ 2.1313787205001777e-05 0.0067899297149596706
+ 2.1313814407502229e-05 0.0067205865590935169
+ 2.1313841610002681e-05 0.0066442472751925379
+ 2.1313868812503136e-05 0.006561293931672073
+ 2.1313896015003591e-05 0.0064721142708494637
+ 2.1313923217504043e-05 0.0063771001957435066
+ 2.1313950420004495e-05 0.0062766462900859356
+ 2.131397762250495e-05 0.0061711483775146155
+ 2.1314004825005405e-05 0.0060610021255013743
+ 2.1314032027505857e-05 0.0059466016991306979
+ 2.1314059230006309e-05 0.0058283384693926773
+ 2.1314086432506764e-05 0.0057065997804302861
+ 2.1314115300883498e-05 0.0055740309990659331
+ 2.1314144169260236e-05 0.0054384272991202893
+ 2.131417303763697e-05 0.0053002282345430132
+ 2.1314201906013704e-05 0.0051598626838551204
+ 2.1314230774390438e-05 0.0050177476630414884
+ 2.1314259642767172e-05 0.0048742872442221231
+ 2.131428851114391e-05 0.0047298715812966012
+ 2.1314317379520644e-05 0.0045848760430473451
+ 2.1314346247897378e-05 0.0044396604535071188
+ 2.1314381135166684e-05 0.0042643637747592994
+ 2.1314416022435989e-05 0.0040898203879790361
+ 2.131444998550605e-05 0.0039211359224094145
+ 2.1314483948576115e-05 0.0037541355090310092
+ 2.1314517911646176e-05 0.0035892460195200843
+ 2.1314551874716241e-05 0.0034268598627977894
+ 2.1314585837786302e-05 0.0032673350066711841
+ 2.1314627381082818e-05 0.0030765664536155394
+ 2.1314668924379334e-05 0.0028910852643209248
+ 2.131471046767585e-05 0.0027113416169293153
+ 2.1314752010972367e-05 0.0025377141992044784
+ 2.1314802322523099e-05 0.0023360685105670866
+ 2.1314853125173634e-05 0.0021424443576868821
+ 2.1314903927824173e-05 0.001959156496722657
+ 2.1314971607266247e-05 0.0017313192252947558
+ 2.1315039286708322e-05 0.0015222190408349249
+ 2.1315091919396568e-05 0.001372431253814393
+ 2.1315144552084812e-05 0.0012336381966261724
+ 2.1315197184773055e-05 0.0011055447342070166
+ 2.1315249817461302e-05 0.00098778684645394604
+ 2.1315297809929104e-05 0.00088906516794052203
+ 2.1315345802396908e-05 0.00079823747715313789
+ 2.131539379486471e-05 0.00071492972227882204
+ 2.1315441787332511e-05 0.00063875107498295779
+ 2.1315489779800316e-05 0.00056929990178360005
+ 2.1315537261554864e-05 0.00050680910974394439
+ 2.1315584743309412e-05 0.00045011010916966049
+ 2.1315632225063963e-05 0.00039881145821643485
+ 2.1315679706818511e-05 0.00035252854906615789
+ 2.1315727188573062e-05 0.00031088653907439246
+ 2.1315774670327609e-05 0.0002735227890958723
+ 2.1315824358583367e-05 0.00023862511600889196
+ 2.1315874046839122e-05 0.00020765025205703798
+ 2.131592373509488e-05 0.00018023763188315632
+ 2.1315973423350635e-05 0.00015604795426756195
+ 2.1316023111606393e-05 0.0001347637411803884
+ 2.1316072799862151e-05 0.00011608953467670693
+ 2.1316127951386076e-05 9.8086983151495662e-05
+ 2.1316183102910001e-05 8.2620379659707852e-05
+ 2.1316238254433927e-05 6.937830638173144e-05
+ 2.1316293405957855e-05 5.8079646203919961e-05
+ 2.1316348557481781e-05 4.8471998343402797e-05
+ 2.1316411640520539e-05 3.9267448447275403e-05
+ 2.1316474723559298e-05 3.1683839518460041e-05
+ 2.1316537806598057e-05 2.5463033689023789e-05
+ 2.1316600889636819e-05 2.0382309617297274e-05
+ 2.1316674140146427e-05 1.5662206653736814e-05
+ 2.1316747390656034e-05 1.1971024407425274e-05
+ 2.1316820641165645e-05 9.101093726216712e-06
+ 2.1316905619421584e-05 6.5781195004269459e-06
+ 2.1316990597677525e-05 4.7207090840830405e-06
+ 2.1317093836844785e-05 3.1245246960755978e-06
+ 2.1317198171769416e-05 2.0371887602864823e-06
+ 2.1317302506694044e-05 1.3141391771344707e-06
+ 2.1317426664469166e-05 7.6923430377838728e-07
+ 2.1317550822244288e-05 4.435788450454647e-07
+ 2.1317705800806532e-05 2.1851475951109054e-07
+ 2.1317884937131789e-05 9.3708673373505121e-08
+ 2.1318098556602388e-05 3.2883700516734768e-08
+ 2.1318364485722953e-05 8.5309004428172277e-09
+ 2.1318717982712206e-05 1.4552417250701691e-09
+ 2.1319242097564147e-05 3.0578689270965244e-10
+ 2.1320136340120474e-05 2.4569663308855879e-10
+ 2.1322132807185036e-05 2.4259754686171839e-10
+ 2.1323988816858017e-05 2.4182034068072913e-10
+ 2.1326421668443081e-05 2.4138174969930913e-10
+ 2.1328854520028145e-05 2.4076582964276258e-10
+ 2.1331287371613206e-05 2.4012576594620444e-10
+ 2.1333720223198271e-05 2.4057963384973803e-10
+ 2.1336153074783335e-05 2.4092919901400983e-10
+ 2.1338585926368399e-05 2.401872610697499e-10
+ 2.134101877795346e-05 2.3987554496708928e-10
+ 2.1343451629538525e-05 2.4037942571475707e-10
+ 2.1345767705239782e-05 2.4025247901632375e-10
+ 2.1348819440406721e-05 2.4017887589128354e-10
+ 2.1351871175573659e-05 2.4009951114703349e-10
+ 2.1354922910740597e-05 2.4004351142745323e-10
+ 2.1357974645907535e-05 2.4016098617015712e-10
+ 2.1361026381074474e-05 2.4071442426522539e-10
+ 2.1364078116241415e-05 2.3968616681674537e-10
+ 2.1367773618773599e-05 2.4003007462135484e-10
+ 2.1371134288610911e-05 2.4006402385879101e-10
+ 2.1374494958448219e-05 2.4006047129867007e-10
+ 2.1378620731690279e-05 2.4005210497337081e-10
+ 2.1382746504932339e-05 2.4004042399080182e-10
+ 2.1386872278174399e-05 2.4003044384477591e-10
+ 2.1390998051416455e-05 2.4003749578386358e-10
+ 2.1395123824658515e-05 2.4008180521387353e-10
+ 2.1400251138437098e-05 2.4016443526047099e-10
+ 2.1405378452215681e-05 2.3985136550844345e-10
+ 2.1410505765994261e-05 2.3994252727381691e-10
+ 2.1415633079772844e-05 2.4004700010028028e-10
+ 2.1421995979825154e-05 2.4004483697536087e-10
+ 2.1428358879877461e-05 2.3997024527683999e-10
+ 2.1434721779929771e-05 2.3997592655072043e-10
+ 2.1442497256254513e-05 2.4000749931504923e-10
+ 2.1450272732579254e-05 2.4001269631983051e-10
+ 2.1458048208903995e-05 2.3999782508278659e-10
+ 2.1467983441936068e-05 2.3999355892689472e-10
+ 2.1477918674968144e-05 2.4000179472492324e-10
+ 2.1490125706218142e-05 2.4000339716614338e-10
+ 2.1502332737468145e-05 2.3999888202599127e-10
+ 2.1514539768718143e-05 2.3999830525938688e-10
+ 2.1526746799968142e-05 2.4000037974237526e-10
+ 2.1538953831218144e-05 2.4000087414852165e-10
+ 2.1551160862468143e-05 2.3999993966201389e-10
+ 2.1563367893718145e-05 2.3999960494882817e-10
+ 2.1575574924968143e-05 2.4000001432309894e-10
+ 2.1587781956218142e-05 2.4000021737723387e-10
+ 2.1599988987468144e-05 2.4000004462513988e-10
+ 2.1612196018718143e-05 2.3999993006727966e-10
+ 2.1624403049968141e-05 2.3999999917748096e-10
+ 2.1636610081218143e-05 2.4000006049017395e-10
+ 2.1648817112468142e-05 2.4000003421757239e-10
+ 2.1661024143718141e-05 2.4000000237870328e-10
+ 2.1673231174968143e-05 2.4000001256652595e-10
+ 2.1685438206218141e-05 2.4000002745854788e-10
+ 2.1697645237468143e-05 2.4000002475271839e-10
+ 2.1709852268718142e-05 2.4000001795384735e-10
+ 2.1722059299968141e-05 2.400000173879749e-10
+ 2.1734266331218143e-05 2.4000002070407596e-10
+ 2.1746473362468141e-05 2.4000002067419452e-10
+ 2.1758680393718143e-05 2.4000001976473751e-10
+ 2.1770887424968142e-05 2.40000019362722e-10
+ 2.1783094456218141e-05 2.4000002028128461e-10
+ 2.1795301487468143e-05 2.4000002060646208e-10
+ 2.1807508518718141e-05 2.4000002008287723e-10
+ 2.181971554996814e-05 2.4000001934276911e-10
+ 2.1831922581218142e-05 2.4000001968966948e-10
+ 2.1844129612468141e-05 2.4000002093381111e-10
+ 2.1856336643718139e-05 2.4000001965726013e-10
+ 2.1868543674968141e-05 2.4000001961507071e-10
+ 2.188075070621814e-05 2.4000002048512451e-10
+ 2.1892957737468142e-05 2.4000001998121006e-10
+ 2.1905164768718141e-05 2.400000199764228e-10
+ 2.1917371799968139e-05 2.4000001998665694e-10
+ 2.1929578831218142e-05 2.4000001988395378e-10
+ 2.194178586246814e-05 2.4000001969840786e-10
+ 2.1953992893718142e-05 2.4000001962628526e-10
+ 2.1966199924968141e-05 2.4000001985975601e-10
+ 2.197840695621814e-05 2.4000001994562599e-10
+ 2.1990613987468142e-05 2.4000001873790616e-10
+ 2.200282101871814e-05 2.400000206888198e-10
+ 2.2015028049968139e-05 2.4000002115772409e-10
+ 2.2027235081218141e-05 2.4000001926167516e-10
+ 2.203944211246814e-05 2.4000001865095655e-10
+ 2.2051649143718138e-05 2.4000002024868279e-10
+ 2.206385617496814e-05 2.4000002062807212e-10
+ 2.2076063206218139e-05 2.4000001971246058e-10
+ 2.2088270237468141e-05 2.4000001913611468e-10
+ 2.210047726871814e-05 2.4000001939609548e-10
+ 2.2112684299968138e-05 2.4000001928925776e-10
+ 2.212489133121814e-05 2.4000002036211893e-10
+ 2.2137098362468139e-05 2.4000001948566678e-10
+ 2.2149305393718141e-05 2.40000020557049e-10
+ 2.216151242496814e-05 2.400000203491446e-10
+ 2.2173719456218138e-05 2.4000001961720044e-10
+ 2.218592648746814e-05 2.400000200808237e-10
+ 2.2198133518718139e-05 2.4000002006495584e-10
+ 2.2210340549968138e-05 2.4000001941755901e-10
+ 2.222254758121814e-05 2.4000001925514504e-10
+ 2.2234754612468138e-05 2.4000001949494439e-10
+ 2.2246961643718137e-05 2.4000001987457185e-10
+ 2.2259168674968139e-05 2.4000001956535886e-10
+ 2.2271375706218138e-05 2.4000001976899341e-10
+ 2.228358273746814e-05 2.4000001989767335e-10
+ 2.2295789768718138e-05 2.4000002010421042e-10
+ 2.2307996799968137e-05 2.4000002031692612e-10
+ 2.2320203831218139e-05 2.4000001943796074e-10
+ 2.2332410862468138e-05 2.4000001979057998e-10
+ 2.234461789371814e-05 2.4000001994141042e-10
+ 2.2356824924968139e-05 2.4000001910787902e-10
+ 2.2369031956218137e-05 2.4000002014157438e-10
+ 2.2381238987468139e-05 2.4000002007976212e-10
+ 2.2393446018718138e-05 2.4000001897875313e-10
+ 2.2405653049968137e-05 2.4000002030066949e-10
+ 2.2417860081218139e-05 2.4000002070432142e-10
+ 2.2430067112468137e-05 2.4000001950520541e-10
+ 2.2442274143718136e-05 2.4000001947980057e-10
+ 2.2454481174968138e-05 2.4000002027253361e-10
+ 2.2466688206218137e-05 2.40000020609859e-10
+ 2.2478895237468139e-05 2.4000001911322354e-10
+ 2.2491102268718137e-05 2.4000001969739074e-10
+ 2.2503309299968136e-05 2.4000002073053612e-10
+ 2.2515516331218138e-05 2.4000001994814067e-10
+ 2.2527723362468137e-05 2.4000001923239209e-10
+ 2.2539930393718139e-05 2.4000002015288261e-10
+ 2.2552137424968137e-05 2.4000001930210656e-10
+ 2.2564344456218136e-05 2.4000001837686493e-10
+ 2.2576551487468138e-05 2.4000001946449939e-10
+ 2.2588758518718137e-05 2.4000002038326192e-10
+ 2.2600965549968139e-05 2.400000203109469e-10
+ 2.2613172581218137e-05 2.400000203952259e-10
+ 2.2625379612468139e-05 2.4000001970496741e-10
+ 2.2637586643718138e-05 2.4000001924454606e-10
+ 2.264979367496814e-05 2.4000001905466872e-10
+ 2.2662000706218139e-05 2.400000204518705e-10
+ 2.2674207737468141e-05 2.4000002011557764e-10
+ 2.2686414768718139e-05 2.4000001946831419e-10
+ 2.2698621799968142e-05 2.4000001925940771e-10
+ 2.271082883121814e-05 2.4000001980987061e-10
+ 2.2723035862468142e-05 2.4000002089319245e-10
+ 2.2735242893718141e-05 2.4000001973823067e-10
+ 2.2747449924968143e-05 2.4000001879346328e-10
+ 2.2759656956218142e-05 2.4000001869932423e-10
+ 2.2771863987468144e-05 2.4000002074828773e-10
+ 2.2784071018718142e-05 2.4000001934026167e-10
+ 2.2796278049968144e-05 2.4000001952115826e-10
+ 2.2808485081218143e-05 2.4000001987859593e-10
+ 2.2820692112468145e-05 2.400000198982881e-10
+ 2.2832899143718144e-05 2.40000018977687e-10
+ 2.2845106174968146e-05 2.4000001970468766e-10
+ 2.2857313206218144e-05 2.4000001969944985e-10
+ 2.2869520237468146e-05 2.4000002027367879e-10
+ 2.2881727268718145e-05 2.4000001840031488e-10
+ 2.2893934299968147e-05 2.4000001957318321e-10
+ 2.2906141331218146e-05 2.400000188108562e-10
+ 2.2918348362468148e-05 2.4000002046679305e-10
+ 2.2930555393718146e-05 2.4000001950571268e-10
+ 2.2942762424968149e-05 2.4000001838116472e-10
+ 2.2954969456218147e-05 2.4000001853089837e-10
+ 2.2967176487468149e-05 2.4000002004811227e-10
+ 2.2979383518718148e-05 2.4000001966057371e-10
+ 2.299159054996815e-05 2.4000001941089245e-10
+ 2.3003797581218149e-05 2.4000001913185568e-10
+ 2.3016004612468151e-05 2.4000001954838558e-10
+ 2.3028211643718149e-05 2.4000001920964592e-10
+ 2.3040418674968151e-05 2.4000001943469307e-10
+ 2.305262570621815e-05 2.4000001866641258e-10
+ 2.3064832737468152e-05 2.4000002020897109e-10
+ 2.3077039768718151e-05 2.4000001940179987e-10
+ 2.3089246799968153e-05 2.4000001993507329e-10
+ 2.3101453831218151e-05 2.4000002008198123e-10
+ 2.3113660862468153e-05 2.400000198005213e-10
+ 2.3125867893718152e-05 2.4000001916301211e-10
+ 2.3138074924968154e-05 2.4000001960280073e-10
+ 2.3150281956218153e-05 2.4000001963117276e-10
+ 2.3162488987468155e-05 2.400000196254434e-10
+ 2.3174696018718153e-05 2.4000002030623543e-10
+ 2.3186903049968156e-05 2.4000001985486468e-10
+ 2.3199110081218154e-05 2.4000001975560508e-10
+ 2.3211317112468156e-05 2.4000002002563028e-10
+ 2.3223524143718155e-05 2.4000001880683233e-10
+ 2.3235731174968157e-05 2.400000186107882e-10
+ 2.3247938206218156e-05 2.4000002026174485e-10
+ 2.3260145237468158e-05 2.4000001964579944e-10
+ 2.3272352268718156e-05 2.4000001869414737e-10
+ 2.3284559299968158e-05 2.4000002024855297e-10
+ 2.3296766331218157e-05 2.4000001886895933e-10
+ 2.3308973362468159e-05 2.4000001996539064e-10
+ 2.3321180393718158e-05 2.4000001852201533e-10
+ 2.333338742496816e-05 2.4000001995376353e-10
+ 2.3345594456218158e-05 2.4000001885033681e-10
+ 2.335780148746816e-05 2.400000202275795e-10
+ 2.3370008518718159e-05 2.4000001938682899e-10
+ 2.3382215549968161e-05 2.400000185286626e-10
+ 2.339442258121816e-05 2.4000002021567022e-10
+ 2.3406629612468162e-05 2.4000001929093104e-10
+ 2.341883664371816e-05 2.4000001945502139e-10
+ 2.3431043674968163e-05 2.4000001849176264e-10
+ 2.3443250706218161e-05 2.4000001899160695e-10
+ 2.3455457737468163e-05 2.4000001908469775e-10
+ 2.3467664768718162e-05 2.4000002021320925e-10
+ 2.3479871799968164e-05 2.4000001986077044e-10
+ 2.3492078831218163e-05 2.4000001985660228e-10
+ 2.3504285862468165e-05 2.4000001982734366e-10
+ 2.3516492893718163e-05 2.4000001909394165e-10
+ 2.3528699924968165e-05 2.4000001971428865e-10
+ 2.3540906956218164e-05 2.4000001921042243e-10
+ 2.3553113987468166e-05 2.400000190589926e-10
+ 2.3565321018718165e-05 2.400000192770844e-10
+ 2.3577528049968167e-05 2.4000001876027354e-10
+ 2.3589735081218165e-05 2.4000001963225885e-10
+ 2.3601942112468167e-05 2.4000001898595255e-10
+ 2.3614149143718166e-05 2.4000001876650681e-10
+ 2.3626356174968168e-05 2.4000001955479303e-10
+ 2.3638563206218167e-05 2.400000192149284e-10
+ 2.3650770237468169e-05 2.4000001962818762e-10
+ 2.3662977268718167e-05 2.400000192259498e-10
+ 2.3675184299968169e-05 2.4000001958046752e-10
+ 2.3687391331218168e-05 2.4000001876653049e-10
+ 2.369959836246817e-05 2.4000001901679062e-10
+ 2.3711805393718169e-05 2.4000001929188411e-10
+ 2.3724012424968171e-05 2.4000001878460593e-10
+ 2.373621945621817e-05 2.4000001895149019e-10
+ 2.3748426487468172e-05 2.4000001953324466e-10
+ 2.376063351871817e-05 2.4000001930179932e-10
+ 2.3772840549968172e-05 2.4000001867284628e-10
+ 2.3785047581218171e-05 2.4000001876404646e-10
+ 2.3797254612468173e-05 2.4000001844012502e-10
+ 2.3809461643718172e-05 2.4000001847700822e-10
+ 2.3821668674968174e-05 2.4000001848915366e-10
+ 2.3833875706218172e-05 2.4000001847211049e-10
+ 2.3846082737468174e-05 2.4000001842583542e-10
+ 2.3858289768718173e-05 2.4000001874485954e-10
+ 2.3870496799968175e-05 2.4000001864470591e-10
+ 2.3882703831218174e-05 2.400000192645186e-10
+ 2.3894910862468176e-05 2.4000001911011029e-10
+ 2.3907117893718174e-05 2.400000189594016e-10
+ 2.3919324924968176e-05 2.4000001834385696e-10
+ 2.3931531956218175e-05 2.4000001923683012e-10
+ 2.3943738987468177e-05 2.4000002008098464e-10
+ 2.3955946018718176e-05 2.400000183211859e-10
+ 2.3968153049968178e-05 2.4000001983070817e-10
+ 2.3980360081218177e-05 2.4000001841550595e-10
+ 2.3992567112468179e-05 2.4000001987140726e-10
+ 2.4004774143718177e-05 2.4000001839799459e-10
+ 2.4016981174968179e-05 2.4000001979564812e-10
+ 2.4029188206218178e-05 2.4000001826400317e-10
+ 2.404139523746818e-05 2.3996544537098469e-10
+ 2.4053602268718179e-05 2.3996256464191007e-10
+ 2.4065809299968181e-05 2.3996062147298765e-10
+ 2.4078016331218179e-05 2.399538992151035e-10
+ 2.4090223362468181e-05 2.3990864356794482e-10
+ 2.410243039371818e-05 2.3980391697569448e-10
+ 2.4114637424968182e-05 2.3960325885649169e-10
+ 2.4120740940593181e-05 2.3930636780140344e-10
+ 2.4126844456218181e-05 2.3825018349924986e-10
+ 2.412989621403068e-05 2.3664385617022961e-10
+ 2.413294797184318e-05 2.313460144418538e-10
+ 2.4134473850749433e-05 2.2273712950258841e-10
+ 2.413599972965568e-05 1.9502932447418286e-10
+ 2.4136991106889186e-05 1.3263414891107653e-10
+ 2.4137269733896243e-05 9.5672269136980181e-11
+ 2.4137548360903299e-05 4.6113023016783446e-11
+ 2.413809883562797e-05 4.077304569289076e-11
+ 2.4140875273912437e-05 4.2347131994264368e-11
+ 2.4153082305162439e-05 4.4733371018365243e-11
+ 2.4165289336412437e-05 5.3058719093237963e-11
+ 2.4177496367662436e-05 6.5249849962529414e-11
+ 2.4189703398912438e-05 8.0586557341896391e-11
+ 2.420191043016244e-05 9.8186059694000248e-11
+ 2.4214117461412439e-05 1.1703587328666208e-10
+ 2.4226324492662437e-05 1.3605185310399104e-10
+ 2.4238531523912439e-05 1.5414054504639482e-10
+ 2.4250738555162441e-05 1.7026206156240515e-10
+ 2.426294558641244e-05 1.8348986297121229e-10
+ 2.4275152617662439e-05 1.9306400774952091e-10
+ 2.4287359648912441e-05 1.9843481134517081e-10
+ 2.4299566680162443e-05 1.9929440536940058e-10
+ 2.4311773711412441e-05 1.9559438520732841e-10
+ 2.432398074266244e-05 1.8754853451668201e-10
+ 2.4336187773912442e-05 1.7562047328816539e-10
+ 2.4348394805162444e-05 1.6049694315998822e-10
+ 2.4360601836412443e-05 1.4304826930135124e-10
+ 2.4372808867662441e-05 1.2427827523140709e-10
+ 2.4385015898912444e-05 1.052665328361379e-10
+ 2.4397222930162446e-05 8.7106269937226752e-11
+ 2.4409429961412444e-05 7.0841506734532094e-11
+ 2.4421636992662443e-05 5.7407035899497847e-11
+ 2.4433844023912445e-05 4.7574696846103914e-11
+ 2.4436895781724945e-05 4.5750674856066197e-11
+ 2.4437048369615571e-05 4.5666462612461995e-11
+ 2.4437429839342132e-05 4.5458870923120094e-11
+ 2.443746798631479e-05 4.5438342991126504e-11
+ 2.4437475615709319e-05 4.5434242455099145e-11
+ 2.4437490874498384e-05 4.5426046434154427e-11
+ 2.4437496978014009e-05 4.5422769911655126e-11
+ 2.4437499419420258e-05 4.542145960441293e-11
+ 2.4437499604455784e-05 4.5421360302533612e-11
+ 2.443749997452684e-05 4.5421161701746532e-11
+ 2.4437500714668949e-05 5.7234708751505077e-08
+ 2.4437501454811058e-05 2.3609835104101694e-07
+ 2.4437508856232148e-05 8.3378657603255145e-06
+ 2.4437516257653238e-05 2.6804211983519737e-05
+ 2.4437523659074328e-05 5.4212572160978158e-05
+ 2.4437531060495418e-05 8.9333429400249197e-05
+ 2.4437538461916507e-05 0.00013110387761772142
+ 2.4437547512355688e-05 0.00018988604042548046
+ 2.4437556562794871e-05 0.000255812068272275
+ 2.4437565613234051e-05 0.00032768193023753725
+ 2.4437574663673232e-05 0.00040448949601993325
+ 2.4437583714112412e-05 0.00048539058840956265
+ 2.443759504453351e-05 0.00059137048504824714
+ 2.4437606374954609e-05 0.00070151686849491022
+ 2.4437617705375707e-05 0.0008149054011463608
+ 2.4437629035796806e-05 0.00093078918228233572
+ 2.4437643214653364e-05 0.0010784080416500865
+ 2.4437657393509919e-05 0.0012280520970111633
+ 2.4437671572366474e-05 0.0013789889014004875
+ 2.4437689032396938e-05 0.0015657925325384681
+ 2.4437706492427399e-05 0.0017528666320927736
+ 2.4437723952457861e-05 0.0019395804048633696
+ 2.443774626847783e-05 0.0021769293571718938
+ 2.44377685844978e-05 0.0024120996791847497
+ 2.443779090051777e-05 0.0026444704336099976
+ 2.4437819090217242e-05 0.0029332237971511233
+ 2.4437847279916712e-05 0.0032158629328255771
+ 2.4437875469616181e-05 0.0034916668520790159
+ 2.4437903659315654e-05 0.0037599988278231356
+ 2.4437931849015123e-05 0.0040202830355208904
+ 2.4437960038714592e-05 0.0042719918874605982
+ 2.4437988228414062e-05 0.0045146394015623476
+ 2.4438019414106474e-05 0.0047719795450323309
+ 2.4438050599798886e-05 0.0050171295125712645
+ 2.4438081785491295e-05 0.0052495906087394869
+ 2.4438112971183707e-05 0.0054689190353913904
+ 2.4438150418414336e-05 0.0057143885297757718
+ 2.4438187865644969e-05 0.0059397992525804574
+ 2.4438225312875598e-05 0.006144702220679193
+ 2.4438270844195811e-05 0.0063657430322260553
+ 2.4438316375516021e-05 0.0065556175023236875
+ 2.4438361906836234e-05 0.0067142112673811444
+ 2.4438407438156448e-05 0.0068416534980290083
+ 2.4438441084028113e-05 0.0069160175765833089
+ 2.4438474729899779e-05 0.0069737900261410465
+ 2.4438508375771444e-05 0.0070152594941248576
+ 2.443854202164311e-05 0.0070407746969006688
+ 2.4438575667514775e-05 0.007050740823760393
+ 2.443860931338644e-05 0.0070456156939712805
+ 2.4438642959258106e-05 0.007025905702338452
+ 2.4438676605129771e-05 0.0069921615895264296
+ 2.4438710251001437e-05 0.0069449740739896257
+ 2.4438736870668147e-05 0.006898526876910809
+ 2.4438763490334857e-05 0.0068443802044164921
+ 2.443879011000157e-05 0.0067828688534493494
+ 2.443881672966828e-05 0.0067143369242957376
+ 2.443884334933499e-05 0.0066391364097472113
+ 2.4438869969001703e-05 0.0065576257964309343
+ 2.4438896588668413e-05 0.0064701686843428533
+ 2.4438923208335123e-05 0.0063771324303375145
+ 2.4438949828001833e-05 0.0062788868210215225
+ 2.4438976447668543e-05 0.0061758027801676225
+ 2.4439003067335256e-05 0.0060682511154162089
+ 2.4439029687001966e-05 0.0059566013086644297
+ 2.4439056306668676e-05 0.0058412203541628417
+ 2.4439082926335389e-05 0.0057224716479485063
+ 2.4439109546002099e-05 0.0056007139318451742
+ 2.4439136165668809e-05 0.0054763002948580381
+ 2.4439162785335519e-05 0.0053495772343856614
+ 2.4439189405002229e-05 0.0052208837792675896
+ 2.4439216024668942e-05 0.0050905506764474901
+ 2.4439239404935228e-05 0.0049749804171373225
+ 2.4439262785201518e-05 0.0048586054363550972
+ 2.4439286165467805e-05 0.0047416314482211135
+ 2.4439309545734095e-05 0.0046242577652878883
+ 2.4439332926000381e-05 0.0045066770343838705
+ 2.4439356306266671e-05 0.0043890750025309139
+ 2.4439379686532958e-05 0.0042716303126259531
+ 2.4439403066799248e-05 0.0041545143284691553
+ 2.4439426447065534e-05 0.0040378909886185305
+ 2.4439449827331824e-05 0.0039219166884552218
+ 2.4439473207598111e-05 0.0038067401897542695
+ 2.44394965878644e-05 0.0036925025569730643
+ 2.4439519968130687e-05 0.0035793371193940525
+ 2.4439543348396977e-05 0.0034673694581895016
+ 2.4439566728663263e-05 0.0033567174174145066
+ 2.4439590108929553e-05 0.0032474911378798247
+ 2.443961348919584e-05 0.0031397931128086067
+ 2.443963686946213e-05 0.0030337182641405314
+ 2.4439660249728416e-05 0.0029293540383132049
+ 2.4439683629994706e-05 0.0028267805203238136
+ 2.4439707010260993e-05 0.0027260705648536779
+ 2.4439735591237517e-05 0.0026055855381113117
+ 2.443976417221404e-05 0.0024880893416989024
+ 2.4439792753190564e-05 0.0023736731389782805
+ 2.4439821334167088e-05 0.0022624136400195647
+ 2.4439849915143612e-05 0.0021543736566158275
+ 2.4439886199806214e-05 0.0020219271947776738
+ 2.443992545337338e-05 0.0018846580284455387
+ 2.4439946977215266e-05 0.0018120618774395494
+ 2.4439973696714702e-05 0.0017245821083065652
+ 2.4440000416214138e-05 0.0016400258203643724
+ 2.4440027135713574e-05 0.0015583844444338579
+ 2.444005385521301e-05 0.0014796423351417674
+ 2.4440080574712446e-05 0.0014037772468436488
+ 2.4440107294211882e-05 0.0013307608065583204
+ 2.4440134013711318e-05 0.0012605589819463642
+ 2.4440160733210754e-05 0.0011931325425094006
+ 2.4440187452710191e-05 0.0011284375123336611
+ 2.4440214172209627e-05 0.0010664256128491564
+ 2.4440240891709063e-05 0.0010070446942234952
+ 2.4440262548859613e-05 0.00096080661895637035
+ 2.4440284206010163e-05 0.0009162294538821239
+ 2.4440305863160716e-05 0.00087328092606094238
+ 2.444032752031127e-05 0.00083192771752318962
+ 2.444034917746182e-05 0.00079213559354230647
+ 2.444037083461237e-05 0.00075386952625768001
+ 2.4440392491762923e-05 0.00071709381353394315
+ 2.4440414148913477e-05 0.00068177219296354193
+ 2.4440435806064027e-05 0.00064786795094112185
+ 2.4440457463214577e-05 0.00061534402675914772
+ 2.444047912036513e-05 0.00058416311167918647
+ 2.4440496765399605e-05 0.00055972551886932095
+ 2.4440514410434079e-05 0.00053613426244406741
+ 2.4440532055468551e-05 0.00051336904748169171
+ 2.4440549700503025e-05 0.00049140960981622914
+ 2.44405673455375e-05 0.00047023574348777509
+ 2.4440584990571971e-05 0.00044982732676715286
+ 2.4440602635606446e-05 0.00043016434677204047
+ 2.444062028064092e-05 0.00041122692269401575
+ 2.4440637925675395e-05 0.00039299532765819798
+ 2.444065557070987e-05 0.00037545000923921415
+ 2.4440673215744341e-05 0.00035857160865911174
+ 2.4440690860778815e-05 0.00034234097869457157
+ 2.444070850581329e-05 0.00032673920032235228
+ 2.4440726150847761e-05 0.00031174759813332067
+ 2.4440743795882236e-05 0.00029734775454669758
+ 2.444076144091671e-05 0.00028352152285727745
+ 2.4440779085951185e-05 0.0002702510391493668
+ 2.444079673098566e-05 0.00025751873311203796
+ 2.4440814376020131e-05 0.00024530733779101174
+ 2.4440832021054606e-05 0.00023359989831307307
+ 2.444084966608908e-05 0.00022237977961939102
+ 2.4440867311123551e-05 0.00021163067324446447
+ 2.4440884956158026e-05 0.00020133660317765155
+ 2.4440902601192501e-05 0.00019148193084437179
+ 2.4440920246226975e-05 0.00018205135924409671
+ 2.444093789126145e-05 0.00017302993628217709
+ 2.4440955536295921e-05 0.00016440305733239472
+ 2.4440973181330396e-05 0.00015615646706688136
+ 2.444099082636487e-05 0.00014827626058972067
+ 2.4441008471399342e-05 0.00014074888391014853
+ 2.4441026116433816e-05 0.00013356113379079491
+ 2.4441043761468291e-05 0.00012670015700587552
+ 2.4441061406502765e-05 0.00012015344904364461
+ 2.444107905153724e-05 0.00011390885228677083
+ 2.4441096696571711e-05 0.00010795455370359766
+ 2.4441114341606186e-05 0.00010227908208250491
+ 2.444113198664066e-05 9.687130484080241e-05
+ 2.4441149631675132e-05 9.1720424438765868e-05
+ 2.4441167276709606e-05 8.6815974428572379e-05
+ 2.4441184921744081e-05 8.2147815167013072e-05
+ 2.4441202566778555e-05 7.7706129219957601e-05
+ 2.444122021181303e-05 7.3481416485622882e-05
+ 2.4441237856847501e-05 6.9464489062760908e-05
+ 2.4441255501881976e-05 6.5646465888930612e-05
+ 2.4441273146916451e-05 6.2018767173060703e-05
+ 2.4441290791950922e-05 5.8573108645546759e-05
+ 2.4441308436985396e-05 5.5301495648160228e-05
+ 2.4441326082019871e-05 5.2196217085081444e-05
+ 2.4441343727054346e-05 4.9249839255407143e-05
+ 2.444136137208882e-05 4.6455199586526805e-05
+ 2.4441379017123291e-05 4.3805400286814076e-05
+ 2.4441396662157766e-05 4.1293801935142287e-05
+ 2.4441414307192241e-05 3.8914017023807698e-05
+ 2.4441431952226712e-05 3.6659903470533496e-05
+ 2.4441449597261187e-05 3.4525558114332587e-05
+ 2.4441467242295661e-05 3.2505310209129923e-05
+ 2.4441484887330136e-05 3.0593714928186798e-05
+ 2.444150253236461e-05 2.878554689153125e-05
+ 2.4441520177399082e-05 2.7075793727781893e-05
+ 2.4441537822433556e-05 2.5459649680957857e-05
+ 2.4441555467468031e-05 2.3932509272096093e-05
+ 2.4441573112502502e-05 2.2489961024749567e-05
+ 2.4441590757536977e-05 2.1127781262716843e-05
+ 2.4441608402571451e-05 1.9841927987655173e-05
+ 2.4441626047605926e-05 1.8628534843556469e-05
+ 2.4441643692640401e-05 1.7483905174418017e-05
+ 2.4441661337674872e-05 1.6404506180818473e-05
+ 2.4441682620107577e-05 1.5184596516820046e-05
+ 2.444170274528168e-05 1.4108722156777394e-05
+ 2.444172287045578e-05 1.3103783271809466e-05
+ 2.4441742995629884e-05 1.2165512099818384e-05
+ 2.4441763120803987e-05 1.1289867233639744e-05
+ 2.4441783245978091e-05 1.0473023791237365e-05
+ 2.4441803371152194e-05 9.711363860421274e-06
+ 2.4441823496326294e-05 9.0014672215583367e-06
+ 2.4441843621500397e-05 8.3401023506671107e-06
+ 2.4441863746674501e-05 7.7242177042852387e-06
+ 2.4441888110746127e-05 7.0353574872189284e-06
+ 2.4441912474817756e-05 6.4041509733236313e-06
+ 2.4441936838889382e-05 5.8261375978047346e-06
+ 2.4441961202961011e-05 5.2971679183216326e-06
+ 2.4441985567032637e-05 4.8133849648221628e-06
+ 2.4442009931104266e-05 4.3712064413582404e-06
+ 2.4442034295175892e-05 3.9673077642003495e-06
+ 2.4442058659247521e-05 3.5986059186122073e-06
+ 2.4442083023319147e-05 3.2622441148827113e-06
+ 2.4442107387390776e-05 2.955577222710442e-06
+ 2.4442136719683569e-05 2.6223173518557521e-06
+ 2.4442166051976366e-05 2.3246430183300364e-06
+ 2.4442195384269159e-05 2.0589938235170389e-06
+ 2.4442224716561955e-05 1.8221375097881734e-06
+ 2.4442254048854748e-05 1.6111428978970881e-06
+ 2.4442283381147545e-05 1.4233547079677823e-06
+ 2.4442312713440338e-05 1.2563701699769522e-06
+ 2.4442342045733135e-05 1.1080173307665688e-06
+ 2.4442377848029196e-05 9.4935328593955194e-07
+ 2.444241233545463e-05 8.1703614317247063e-07
+ 2.4442446822880064e-05 7.0231034037170861e-07
+ 2.4442481310305495e-05 6.0295931014601184e-07
+ 2.444251579773093e-05 5.1702814794412422e-07
+ 2.4442557828321208e-05 4.2796498791424164e-07
+ 2.4442599858911489e-05 3.5358466304975593e-07
+ 2.4442641889501767e-05 2.9157919961691281e-07
+ 2.4442683920092045e-05 2.3998333476715486e-07
+ 2.4442725950682327e-05 1.9712710629082681e-07
+ 2.4442777518503426e-05 1.5442331314774624e-07
+ 2.4442828186666484e-05 1.2110746118199679e-07
+ 2.4442878854829539e-05 9.4668212428266369e-08
+ 2.4442929522992598e-05 7.3741045625230226e-08
+ 2.4442993215143462e-05 5.3572482382509411e-08
+ 2.4443056907294326e-05 3.8650410566722333e-08
+ 2.4443120599445191e-05 2.7655607125139506e-08
+ 2.4443198945610714e-05 1.80624388894615e-08
+ 2.4443278657649692e-05 1.1455385675920075e-08
+ 2.4443358369688671e-05 7.0279116712338033e-09
+ 2.4443461292370766e-05 3.42722610432318e-09
+ 2.4443569508909822e-05 1.2415251844169095e-09
+ 2.4443701914804437e-05 -1.7423168879043324e-10
+ 2.4443847065030182e-05 -9.0046498724308251e-10
+ 2.4444034315235683e-05 -1.2675598336250834e-09
+ 2.4444255865010425e-05 -1.390661486095478e-09
+ 2.4444554034092504e-05 -1.4079464626524889e-09
+ 2.4444998769870887e-05 -1.3781166774969621e-09
+ 2.4445805003988996e-05 -1.313948994893242e-09
+ 2.4446711764368316e-05 -1.2450592154006523e-09
+ 2.444773747568644e-05 -1.1711746826522686e-09
+ 2.4448801143402344e-05 -1.0985374417948889e-09
+ 2.4449944764949547e-05 -1.0244977902794022e-09
+ 2.4452231646278909e-05 -8.876839903243166e-10
+ 2.4454182681216661e-05 -7.8153991862173163e-10
+ 2.4456291228517252e-05 -6.7660226349856925e-10
+ 2.445858146743616e-05 -5.7299433820914436e-10
+ 2.4460926666850024e-05 -4.7698621811411996e-10
+ 2.4463271866263889e-05 -3.901690868650475e-10
+ 2.4465590537179633e-05 -3.1248869476676087e-10
+ 2.4468474569484279e-05 -2.2600941125466692e-10
+ 2.4471358601788929e-05 -1.4953972152878652e-10
+ 2.4474242634093579e-05 -8.1909642546355165e-11
+ 2.4477126666398229e-05 -2.2097231394821104e-11
+ 2.4480010698702879e-05 3.0804763949844941e-11
+ 2.4482894731007525e-05 7.7599184420572088e-11
+ 2.4485778763312175e-05 1.1899177680085989e-10
+ 2.4489342797663596e-05 1.6360497315690482e-10
+ 2.4492906832015013e-05 2.0194460469335925e-10
+ 2.4496470866366433e-05 2.3489304324568193e-10
+ 2.4500034900717854e-05 2.6320792465228799e-10
+ 2.4503598935069274e-05 2.8754418863776942e-10
+ 2.4507899961127364e-05 3.124003450031708e-10
+ 2.451220098718545e-05 3.3310188136055884e-10
+ 2.451650201324354e-05 3.5034335018174361e-10
+ 2.452080303930163e-05 3.6470346013268147e-10
+ 2.4525104065359716e-05 3.7666442373221598e-10
+ 2.4530502505986983e-05 3.8888313831481749e-10
+ 2.453590094661425e-05 3.9859542479219459e-10
+ 2.4541299387241517e-05 4.0629545583254085e-10
+ 2.4546697827868785e-05 4.1242659596079512e-10
+ 2.4553468247657472e-05 4.1836450212166619e-10
+ 2.456023866744616e-05 4.228142873871682e-10
+ 2.4567009087234848e-05 4.2614500842071573e-10
+ 2.457538530434396e-05 4.2912633403108892e-10
+ 2.4583761521453072e-05 4.3120345772378355e-10
+ 2.4592137738562185e-05 4.3264838822889765e-10
+ 2.4603043385488657e-05 4.3388610175178318e-10
+ 2.461394903241513e-05 4.3464666000495187e-10
+ 2.4626156063665132e-05 4.3514763453961883e-10
+ 2.4638363094915134e-05 4.3542384097085643e-10
+ 2.4650570126165133e-05 4.3556624282357159e-10
+ 2.4662777157415131e-05 4.3562884855868211e-10
+ 2.4674984188665133e-05 4.3564390919099658e-10
+ 2.4687191219915135e-05 4.3563071731303817e-10
+ 2.4699398251165134e-05 4.3560072832369711e-10
+ 2.4711605282415133e-05 4.3556071800624522e-10
+ 2.4723812313665135e-05 4.3551473285478916e-10
+ 2.4736019344915137e-05 4.3546520640556509e-10
+ 2.4748226376165135e-05 4.3541358487496968e-10
+ 2.4760433407415134e-05 4.3536071753580087e-10
+ 2.4772640438665136e-05 4.353071102954193e-10
+ 2.4784847469915138e-05 4.3525307030070124e-10
+ 2.4797054501165137e-05 4.3519878102624261e-10
+ 2.4809261532415136e-05 4.3514434891989702e-10
+ 2.4821468563665138e-05 4.3508983678706616e-10
+ 2.483367559491514e-05 4.3503528333983576e-10
+ 2.4845882626165138e-05 4.3498071205926307e-10
+ 2.4858089657415137e-05 4.3492613633167183e-10
+ 2.4870296688665139e-05 4.348715638520445e-10
+ 2.4882503719915141e-05 4.3481699946235471e-10
+ 2.489471075116514e-05 4.3476244620745766e-10
+ 2.4906917782415138e-05 4.3470790578886986e-10
+ 2.491912481366514e-05 4.3465337912630206e-10
+ 2.4931331844915142e-05 4.3459886680952396e-10
+ 2.4943538876165141e-05 4.3454436923774573e-10
+ 2.495574590741514e-05 4.3448988663097442e-10
+ 2.4967952938665142e-05 4.3443541909242035e-10
+ 2.4980159969915144e-05 4.3438096668679938e-10
+ 2.4992367001165142e-05 4.3432652946422885e-10
+ 2.5000000000000001e-05 4.3429323819786375e-10
+ 2.501220703125e-05 4.3423882549145797e-10
+ 2.5024414062500002e-05 4.3418442800650571e-10
+ 2.5036621093750001e-05 4.3413004574565444e-10
+ 2.5048828125000003e-05 4.3407567870875607e-10
+ 2.5061035156250001e-05 4.3402132689399754e-10
+ 2.50732421875e-05 4.3396699029857563e-10
+ 2.5085449218750002e-05 4.3391266891909689e-10
+ 2.5097656250000001e-05 4.338583627518177e-10
+ 2.5109863281250003e-05 4.338040717927861e-10
+ 2.5122070312500001e-05 4.3374979603792648e-10
+ 2.513427734375e-05 4.3369553548309005e-10
+ 2.5146484375000002e-05 4.3364129012408513e-10
+ 2.5158691406250001e-05 4.3358705995669485e-10
+ 2.5170898437500003e-05 4.3353284497668784e-10
+ 2.5183105468750001e-05 4.3347864517982436e-10
+ 2.51953125e-05 4.3342446056186068e-10
+ 2.5207519531250002e-05 4.3337029111855061e-10
+ 2.5219726562500001e-05 4.3331613684564742e-10
+ 2.5231933593750003e-05 4.3326199773890431e-10
+ 2.5244140625000001e-05 4.3320787379407488e-10
+ 2.525634765625e-05 4.3315376500691365e-10
+ 2.5268554687500002e-05 4.3309967137317592e-10
+ 2.5280761718750001e-05 4.3304559288861817e-10
+ 2.5292968750000003e-05 4.3299152954899793e-10
+ 2.5305175781250001e-05 4.3293748135007384e-10
+ 2.53173828125e-05 4.3288344828760572e-10
+ 2.5329589843750002e-05 4.3282943035735457e-10
+ 2.5341796875000001e-05 4.3277542755508266e-10
+ 2.5354003906249999e-05 4.327214398765532e-10
+ 2.5366210937500002e-05 4.3266746731753079e-10
+ 2.537841796875e-05 4.3261350987378112e-10
+ 2.5390625000000002e-05 4.3255956754107106e-10
+ 2.5402832031250001e-05 4.3250564031516869e-10
+ 2.54150390625e-05 4.324517281918434e-10
+ 2.5427246093750002e-05 4.3239783116686546e-10
+ 2.5439453125e-05 4.3234394923600652e-10
+ 2.5451660156250002e-05 4.3229008239503964e-10
+ 2.5463867187500001e-05 4.322362306397386e-10
+ 2.547607421875e-05 4.3218239396587857e-10
+ 2.5488281250000002e-05 4.3212857236923607e-10
+ 2.550048828125e-05 4.3207476584558855e-10
+ 2.5512695312500002e-05 4.3202097439071481e-10
+ 2.5524902343750001e-05 4.3196719800039462e-10
+ 2.5537109375e-05 4.3191343667040926e-10
+ 2.5549316406250002e-05 4.3185969039654094e-10
+ 2.55615234375e-05 4.3180595917457319e-10
+ 2.5573730468750002e-05 4.3175224300029046e-10
+ 2.5585937500000001e-05 4.3169854186947872e-10
+ 2.559814453125e-05 4.3164485577792515e-10
+ 2.5610351562500002e-05 4.3159118472141752e-10
+ 2.562255859375e-05 4.315375286957455e-10
+ 2.5634765625000002e-05 4.3148388769669956e-10
+ 2.5646972656250001e-05 4.3143026172007142e-10
+ 2.56591796875e-05 4.3137665076165393e-10
+ 2.5671386718750002e-05 4.3132305481724119e-10
+ 2.568359375e-05 4.3126947388262849e-10
+ 2.5695800781250002e-05 4.3121590795361226e-10
+ 2.5708007812500001e-05 4.3116235702599014e-10
+ 2.572021484375e-05 4.311088210955608e-10
+ 2.5732421875000002e-05 4.3105530015812432e-10
+ 2.5744628906250001e-05 4.3100179420948178e-10
+ 2.5756835937500003e-05 4.3094830324543561e-10
+ 2.5769042968750001e-05 4.3089482726178914e-10
+ 2.5781250000000003e-05 4.3084136625434698e-10
+ 2.5793457031250002e-05 4.3078792021891527e-10
+ 2.5805664062500001e-05 4.3073448915130076e-10
+ 2.5817871093750003e-05 4.3068107304731183e-10
+ 2.5830078125000001e-05 4.3062767190275767e-10
+ 2.5842285156250003e-05 4.3057428571344897e-10
+ 2.5854492187500002e-05 4.305209144751974e-10
+ 2.5866699218750001e-05 4.3046755818381573e-10
+ 2.5878906250000003e-05 4.3041421683511815e-10
+ 2.5891113281250001e-05 4.3036089042491982e-10
+ 2.5903320312500003e-05 4.3030757894903721e-10
+ 2.5915527343750002e-05 4.3025428240328784e-10
+ 2.5927734375000001e-05 4.3020100078349046e-10
+ 2.5939941406250003e-05 4.3014773408546503e-10
+ 2.5952148437500001e-05 4.3009448230503257e-10
+ 2.5964355468750003e-05 4.3004124543801536e-10
+ 2.5976562500000002e-05 4.2998802348023685e-10
+ 2.5988769531250001e-05 4.2993481642752165e-10
+ 2.6000976562500003e-05 4.298816242756955e-10
+ 2.6013183593750001e-05 4.2982844702058526e-10
+ 2.6025390625e-05 4.2977528465801911e-10
+ 2.6037597656250002e-05 4.2972213718382639e-10
+ 2.6049804687500001e-05 4.296690045938374e-10
+ 2.6062011718750003e-05 4.2961588688388387e-10
+ 2.6074218750000001e-05 4.2956278404979846e-10
+ 2.608642578125e-05 4.2950969608741529e-10
+ 2.6098632812500002e-05 4.2945662299256918e-10
+ 2.6110839843750001e-05 4.2940356476109669e-10
+ 2.6123046875000003e-05 4.2935052138883517e-10
+ 2.6135253906250002e-05 4.2929749287162315e-10
+ 2.61474609375e-05 4.2924447920530045e-10
+ 2.6159667968750002e-05 4.2919148038570803e-10
+ 2.6171875000000001e-05 4.2913849640868801e-10
+ 2.618408203125e-05 4.2908552727008359e-10
+ 2.6196289062500002e-05 4.2903257296573924e-10
+ 2.620849609375e-05 4.2897963349150058e-10
+ 2.6220703124999999e-05 4.2892670884321429e-10
+ 2.6232910156250001e-05 4.288737990167283e-10
+ 2.62451171875e-05 4.2882090400789185e-10
+ 2.6257324218750002e-05 4.2876802381255504e-10
+ 2.626953125e-05 4.2871515842656934e-10
+ 2.6281738281249999e-05 4.2866230784578723e-10
+ 2.6293945312500001e-05 4.2860947206606246e-10
+ 2.630615234375e-05 4.2855665108325002e-10
+ 2.6318359375000002e-05 4.2850384489320595e-10
+ 2.633056640625e-05 4.2845105349178732e-10
+ 2.6342773437499999e-05 4.2839827687485269e-10
+ 2.6354980468750001e-05 4.2834551503826145e-10
+ 2.63671875e-05 4.2829276797787439e-10
+ 2.6379394531249998e-05 4.2824003568955333e-10
+ 2.63916015625e-05 4.2818731816916134e-10
+ 2.6403808593749999e-05 4.2813461541256231e-10
+ 2.6416015624999998e-05 4.2808192741562203e-10
+ 2.642822265625e-05 4.2802925417420679e-10
+ 2.6440429687499998e-05 4.2797659568418397e-10
+ 2.645263671875e-05 4.2792395194142275e-10
+ 2.6464843749999999e-05 4.2787132294179297e-10
+ 2.6477050781249998e-05 4.2781870868116553e-10
+ 2.64892578125e-05 4.2776610915541303e-10
+ 2.6501464843749998e-05 4.2771352436040875e-10
+ 2.6513671875000001e-05 4.2766095429202714e-10
+ 2.6525878906249999e-05 4.2760839894614423e-10
+ 2.6538085937499998e-05 4.2755585831863669e-10
+ 2.655029296875e-05 4.2750333240538267e-10
+ 2.6562499999999999e-05 4.2745082120226136e-10
+ 2.6574707031249997e-05 4.2739832470515305e-10
+ 2.6586914062499999e-05 4.273458429099393e-10
+ 2.6599121093749998e-05 4.2729337581250278e-10
+ 2.6611328124999997e-05 4.2724092340872732e-10
+ 2.6623535156249999e-05 4.2718848569449787e-10
+ 2.6635742187499997e-05 4.2713606266570053e-10
+ 2.6647949218749999e-05 4.2708365431822263e-10
+ 2.6660156249999998e-05 4.270312606479525e-10
+ 2.6672363281249997e-05 4.2697888165077988e-10
+ 2.6684570312499999e-05 4.2692651732259529e-10
+ 2.6696777343749997e-05 4.2687416765929084e-10
+ 2.6708984374999999e-05 4.2682183265675928e-10
+ 2.6721191406249998e-05 4.2676951231089505e-10
+ 2.6733398437499997e-05 4.2671720661759342e-10
+ 2.6745605468749999e-05 4.2666491557275079e-10
+ 2.6757812499999997e-05 4.2661263917226478e-10
+ 2.6770019531249996e-05 4.265603774120343e-10
+ 2.6782226562499998e-05 4.265081302879591e-10
+ 2.6794433593749997e-05 4.2645589779594043e-10
+ 2.6806640624999995e-05 4.2640367993188038e-10
+ 2.6818847656249997e-05 4.2635147669168246e-10
+ 2.6831054687499996e-05 4.2629928807125108e-10
+ 2.6843261718749998e-05 4.2624711406649186e-10
+ 2.6855468749999997e-05 4.2619495467331169e-10
+ 2.6867675781249995e-05 4.2614280988761856e-10
+ 2.6879882812499997e-05 4.2609067970532156e-10
+ 2.6892089843749996e-05 4.2603856412233079e-10
+ 2.6904296874999998e-05 4.2598646313455786e-10
+ 2.6916503906249997e-05 4.2593437673791515e-10
+ 2.6928710937499995e-05 4.2588230492831644e-10
+ 2.6940917968749998e-05 4.2583024770167654e-10
+ 2.6953124999999996e-05 4.2577820505391141e-10
+ 2.6965332031249995e-05 4.2572617698093814e-10
+ 2.6977539062499997e-05 4.2567416347867499e-10
+ 2.6989746093749996e-05 4.2562216454304139e-10
+ 2.7001953124999994e-05 4.2557018016995789e-10
+ 2.7014160156249996e-05 4.2551821035534623e-10
+ 2.7026367187499995e-05 4.2546625509512913e-10
+ 2.7038574218749997e-05 4.254143143852306e-10
+ 2.7050781249999996e-05 4.2536238822157581e-10
+ 2.7062988281249994e-05 4.2531047660009089e-10
+ 2.7075195312499996e-05 4.2525857951670346e-10
+ 2.7087402343749995e-05 4.252066969673418e-10
+ 2.7099609374999997e-05 4.2515482894793579e-10
+ 2.7111816406249996e-05 4.2510297545441604e-10
+ 2.7124023437499994e-05 4.2505113648271467e-10
+ 2.7136230468749996e-05 4.2499931202876474e-10
+ 2.7148437499999995e-05 4.2494750208850055e-10
+ 2.7160644531249994e-05 4.248957066578573e-10
+ 2.7172851562499996e-05 4.2482519493572964e-10
+ 2.7185058593749994e-05 4.2475256100502045e-10
+ 2.7197265624999993e-05 4.2468173951608737e-10
+ 2.7209472656249995e-05 4.2459666096075283e-10
+ 2.7221679687499994e-05 4.2448010616874532e-10
+ 2.7233886718749996e-05 4.242745676347303e-10
+ 2.7239990234374995e-05 4.2406762246865748e-10
+ 2.7246093749999994e-05 4.2364446431160585e-10
+ 2.7249145507812494e-05 4.2320637096990359e-10
+ 2.7252197265624994e-05 4.2237081875579266e-10
+ 2.7255249023437493e-05 4.2039912634768696e-10
+ 2.7256606790774085e-05 4.184858057925494e-10
+ 2.7256998216660861e-05 4.1769354662518729e-10
+ 2.7257389642547638e-05 4.1673967866159501e-10
+ 2.7258368207264573e-05 4.1328644574257995e-10
+ 2.7259409502908187e-05 4.0647792025774505e-10
+ 2.7259970598735323e-05 4.0009399586852752e-10
+ 2.7260339629298368e-05 3.9400830485401903e-10
+ 2.7261110323815844e-05 3.7217296598144555e-10
+ 2.726174148123385e-05 3.3482378565862255e-10
+ 2.7262113084009009e-05 2.9476725253157392e-10
+ 2.726243419379579e-05 2.3913652951300332e-10
+ 2.7262647097925412e-05 2.1273235713088472e-10
+ 2.7262860002055034e-05 2.1207408791108858e-10
+ 2.7264989043351245e-05 2.1185023895337551e-10
+ 2.7277196074601244e-05 2.0757980032582087e-10
+ 2.7289403105851246e-05 1.9827504053149293e-10
+ 2.7301610137101244e-05 1.8447156434439206e-10
+ 2.7313817168351243e-05 1.6696410651490149e-10
+ 2.7326024199601245e-05 1.4676018343964647e-10
+ 2.7338231230851244e-05 1.2502212943217047e-10
+ 2.7350438262101246e-05 1.0300022779102304e-10
+ 2.7362645293351245e-05 8.1960799754197404e-11
+ 2.7374852324601243e-05 6.311338755160194e-11
+ 2.7387059355851245e-05 4.7541218733423125e-11
+ 2.7399266387101244e-05 3.6138949326912032e-11
+ 2.7411473418351246e-05 2.9561263935700322e-11
+ 2.7423680449601245e-05 2.8185285811614418e-11
+ 2.7435887480851243e-05 3.2088955187765566e-11
+ 2.7448094512101245e-05 4.1046615499322252e-11
+ 2.7460301543351244e-05 5.4542057385810135e-11
+ 2.7472508574601243e-05 7.1798266491615728e-11
+ 2.7484715605851245e-05 9.1822160785597292e-11
+ 2.7496922637101243e-05 1.1346174161334856e-10
+ 2.7509129668351242e-05 1.3547236949090519e-10
+ 2.7521336699601244e-05 1.5658835172212636e-10
+ 2.7533543730851243e-05 1.7559572435646284e-10
+ 2.7545750762101245e-05 1.9140204326212496e-10
+ 2.7557957793351243e-05 2.030991720132836e-10
+ 2.7561009551163743e-05 2.0529687447679853e-10
+ 2.7561314726944995e-05 2.0549982177660819e-10
+ 2.7562077666398118e-05 2.0599366009052315e-10
+ 2.756245913612468e-05 2.062333046850057e-10
+ 2.7562482977982591e-05 2.0624812098499301e-10
+ 2.7562487746354174e-05 2.0625108196291897e-10
+ 2.7562497283097335e-05 2.0625700163649109e-10
+ 2.756249804603679e-05 2.0625747507891284e-10
+ 2.7562499571915697e-05 2.0625842190532621e-10
+ 2.7562499693986009e-05 2.0625849764807365e-10
+ 2.7562499938126634e-05 2.0625864913207268e-10
+ 2.7562499957657883e-05 2.0625866125070641e-10
+ 2.7562499996720382e-05 2.0625868548793557e-10
+ 2.7562500074845382e-05 8.3574849775232329e-10
+ 2.7562500152970382e-05 2.8382408459534785e-09
+ 2.7562500934220379e-05 9.7910663945931592e-08
+ 2.7562508051845976e-05 6.9281309170090845e-06
+ 2.7562515169471571e-05 2.3496919613390592e-05
+ 2.7562522287097168e-05 4.8515586154137975e-05
+ 2.7562529404722766e-05 8.0864107426474553e-05
+ 2.756253652234836e-05 0.0001195688537478285
+ 2.7562543639973958e-05 0.00016378325676260678
+ 2.7562550757599552e-05 0.00021277103077073492
+ 2.756255787522515e-05 0.00026589161027525284
+ 2.7562564992850747e-05 0.00032258751106878353
+ 2.7562572110476342e-05 0.00038237336083026571
+ 2.7562579228101939e-05 0.00044482637875059637
+ 2.7562587807568571e-05 0.00052313156179263198
+ 2.7562596387035203e-05 0.00060422377214069478
+ 2.7562604966501835e-05 0.00068763160407692863
+ 2.7562613545968467e-05 0.00077295453496090106
+ 2.75626221254351e-05 0.00085985181282763258
+ 2.7562630704901732e-05 0.00094803308914625053
+ 2.7562639284368364e-05 0.0010372505228311898
+ 2.7562647863834996e-05 0.0011272921245865509
+ 2.7562658180770253e-05 0.0012364048498757886
+ 2.7562668497705506e-05 0.0013461799437633384
+ 2.756267881464076e-05 0.0014563930288477433
+ 2.7562689131576017e-05 0.001566855276772596
+ 2.7562699448511274e-05 0.0016774068636345029
+ 2.7562709765446528e-05 0.001787911643031166
+ 2.7562720082381782e-05 0.0018982528107135616
+ 2.7562730399317039e-05 0.0020083293767566338
+ 2.7562742902012258e-05 0.002141246780886198
+ 2.7562755404707477e-05 0.0022735106700283729
+ 2.7562767907402696e-05 0.0024050029041599369
+ 2.7562780410097918e-05 0.0025356196305195535
+ 2.7562792912793137e-05 0.0026652683340791378
+ 2.7562805415488356e-05 0.002793865545581445
+ 2.7562817918183576e-05 0.0029213350620943554
+ 2.7562830420878795e-05 0.0030476065669750823
+ 2.7562845592253876e-05 0.0031991277392290247
+ 2.7562860763628954e-05 0.0033486794005026179
+ 2.7562875935004032e-05 0.0034961593179601309
+ 2.7562891106379114e-05 0.0036414711081661105
+ 2.7562906277754195e-05 0.0037845233735065873
+ 2.7562921449129274e-05 0.0039252290818992874
+ 2.7562936620504352e-05 0.0040635051254073566
+ 2.7562954860519559e-05 0.0042264209820281088
+ 2.7562973100534767e-05 0.0043855785109888799
+ 2.7562991340549975e-05 0.004540852807539594
+ 2.7563009580565183e-05 0.0046921255232483241
+ 2.756302782058039e-05 0.004839284756390172
+ 2.7563046060595598e-05 0.0049822250059800644
+ 2.7563068199865846e-05 0.0051499118748984281
+ 2.7563090339136095e-05 0.0053110729761570875
+ 2.7563112478406343e-05 0.0054655577982168782
+ 2.7563134617676591e-05 0.0056132299331846198
+ 2.7563161293011316e-05 0.0057819364493443522
+ 2.7563187873095807e-05 0.0059398423573548687
+ 2.7563214453180298e-05 0.0060874136176253622
+ 2.756324868848434e-05 0.0062620603819550135
+ 2.7563282923788384e-05 0.0064191641307141745
+ 2.7563315356127049e-05 0.0065517091134031152
+ 2.7563347788465711e-05 0.0066683776453289999
+ 2.7563380220804376e-05 0.0067692021882621509
+ 2.756341265314304e-05 0.0068542763543729904
+ 2.7563445085481702e-05 0.0069237529436825757
+ 2.7563477517820367e-05 0.0069778416850672731
+ 2.7563509950159028e-05 0.0070168067033145008
+ 2.7563542382497693e-05 0.0070409637367341727
+ 2.7563569584998145e-05 0.0070500711051410814
+ 2.75635967874986e-05 0.0070492564131712353
+ 2.7563623989999055e-05 0.0070387804986578604
+ 2.7563651192499507e-05 0.0070189238317284377
+ 2.7563678394999959e-05 0.0069899850256677273
+ 2.7563705597500414e-05 0.0069522793135452206
+ 2.756373280000087e-05 0.0069061369988542495
+ 2.7563760002501321e-05 0.0068519018883273245
+ 2.7563787205001773e-05 0.0067899297149596706
+ 2.7563814407502228e-05 0.0067205865590935169
+ 2.7563841610002684e-05 0.0066442472751925379
+ 2.7563868812503135e-05 0.006561293931672073
+ 2.7563896015003587e-05 0.0064721142708494637
+ 2.7563923217504043e-05 0.0063771001957435066
+ 2.7563950420004498e-05 0.0062766462900859356
+ 2.756397762250495e-05 0.0061711483775146155
+ 2.7564004825005401e-05 0.0060610021255013743
+ 2.7564032027505857e-05 0.0059466016991306979
+ 2.7564059230006312e-05 0.0058283384693926773
+ 2.7564086432506764e-05 0.0057065997804302861
+ 2.7564115300883498e-05 0.0055740309990659331
+ 2.7564144169260232e-05 0.0054384272991202893
+ 2.7564173037636969e-05 0.0053002282345430132
+ 2.7564201906013704e-05 0.0051598626838551204
+ 2.7564230774390438e-05 0.0050177476630414884
+ 2.7564259642767175e-05 0.0048742872442221231
+ 2.7564288511143909e-05 0.0047298715812966012
+ 2.7564317379520643e-05 0.0045848760430473451
+ 2.7564346247897377e-05 0.0044396604535071188
+ 2.7564381135166683e-05 0.0042643637747592994
+ 2.7564416022435989e-05 0.0040898203879790361
+ 2.756444998550605e-05 0.0039211359224094145
+ 2.7564483948576114e-05 0.0037541355090310092
+ 2.7564517911646176e-05 0.0035892460195200843
+ 2.756455187471624e-05 0.0034268598627977894
+ 2.7564585837786301e-05 0.0032673350066711841
+ 2.7564627381082817e-05 0.0030765664536155394
+ 2.7564668924379334e-05 0.0028910852643209248
+ 2.756471046767585e-05 0.0027113416169293153
+ 2.7564752010972366e-05 0.0025377141992044784
+ 2.7564802322523098e-05 0.0023360685105670866
+ 2.7564853125173637e-05 0.0021424443576868821
+ 2.7564903927824172e-05 0.001959156496722657
+ 2.7564971607266247e-05 0.0017313192252947558
+ 2.7565039286708321e-05 0.0015222190408349249
+ 2.7565091919396568e-05 0.001372431253814393
+ 2.7565144552084811e-05 0.0012336381966261724
+ 2.7565197184773058e-05 0.0011055447342070166
+ 2.7565249817461301e-05 0.00098778684645394604
+ 2.7565297809929103e-05 0.00088906516794052203
+ 2.7565345802396908e-05 0.00079823747715313789
+ 2.7565393794864709e-05 0.00071492972227882204
+ 2.7565441787332511e-05 0.00063875107498295779
+ 2.7565489779800316e-05 0.00056929990178360005
+ 2.7565537261554863e-05 0.00050680910974394439
+ 2.7565584743309415e-05 0.00045011010916966049
+ 2.7565632225063962e-05 0.00039881145821643485
+ 2.756567970681851e-05 0.00035252854906615789
+ 2.7565727188573061e-05 0.00031088653907439246
+ 2.7565774670327609e-05 0.0002735227890958723
+ 2.7565824358583367e-05 0.00023862511600889196
+ 2.7565874046839122e-05 0.00020765025205703798
+ 2.756592373509488e-05 0.00018023763188315632
+ 2.7565973423350638e-05 0.00015604795426756195
+ 2.7566023111606392e-05 0.0001347637411803884
+ 2.756607279986215e-05 0.00011608953467670693
+ 2.7566127951386076e-05 9.8086983151495662e-05
+ 2.7566183102910001e-05 8.2620379659707852e-05
+ 2.756623825443393e-05 6.937830638173144e-05
+ 2.7566293405957855e-05 5.8079646203919961e-05
+ 2.756634855748178e-05 4.8471998343402797e-05
+ 2.7566411640520539e-05 3.9267448447275403e-05
+ 2.7566474723559298e-05 3.1683839518460041e-05
+ 2.7566537806598056e-05 2.5463033689023789e-05
+ 2.7566600889636815e-05 2.0382309617297274e-05
+ 2.7566674140146426e-05 1.5662206653736814e-05
+ 2.7566747390656037e-05 1.1971024407425274e-05
+ 2.7566820641165645e-05 9.101093726216712e-06
+ 2.7566905619421583e-05 6.5781195004269459e-06
+ 2.7566990597677525e-05 4.7207090840830405e-06
+ 2.7567093836844784e-05 3.1245246960755978e-06
+ 2.7567198171769415e-05 2.0371887602864823e-06
+ 2.7567302506694043e-05 1.3141391771344707e-06
+ 2.7567426664469165e-05 7.6923430377838728e-07
+ 2.7567550822244288e-05 4.435788450454647e-07
+ 2.7567705800806531e-05 2.1851475951109054e-07
+ 2.7567884937131788e-05 9.3708673373505121e-08
+ 2.7568098556602391e-05 3.2883700516734768e-08
+ 2.7568364485722953e-05 8.5309004428172277e-09
+ 2.7568717982712205e-05 1.4552417250701691e-09
+ 2.7569242097564147e-05 3.0578689270965244e-10
+ 2.7570136340120477e-05 2.4569663308855879e-10
+ 2.7572132807185035e-05 2.4259754686171839e-10
+ 2.7573988816858016e-05 2.4182034068072913e-10
+ 2.7576421668443081e-05 2.4138174969930913e-10
+ 2.7578854520028145e-05 2.4076582964276258e-10
+ 2.7581287371613206e-05 2.4012576594620444e-10
+ 2.758372022319827e-05 2.4057963384973803e-10
+ 2.7586153074783334e-05 2.4092919901400983e-10
+ 2.7588585926368399e-05 2.401872610697499e-10
+ 2.759101877795346e-05 2.3987554496708928e-10
+ 2.7593451629538524e-05 2.4037942571475707e-10
+ 2.7595767705239782e-05 2.4025247901632375e-10
+ 2.759881944040672e-05 2.4017887589128354e-10
+ 2.7601871175573658e-05 2.4009951114703349e-10
+ 2.7604922910740597e-05 2.4004351142745323e-10
+ 2.7607974645907535e-05 2.4016098617015712e-10
+ 2.7611026381074473e-05 2.4071442426522539e-10
+ 2.7614078116241411e-05 2.3968616681674537e-10
+ 2.7617773618773598e-05 2.4003007462135484e-10
+ 2.762113428861091e-05 2.4006402385879101e-10
+ 2.7624494958448219e-05 2.4006047129867007e-10
+ 2.7628620731690278e-05 2.4005210497337081e-10
+ 2.7632746504932338e-05 2.4004042399080182e-10
+ 2.7636872278174398e-05 2.4003044384477591e-10
+ 2.7640998051416455e-05 2.4003749578386358e-10
+ 2.7645123824658515e-05 2.4008180521387353e-10
+ 2.7650251138437098e-05 2.4016443526047099e-10
+ 2.7655378452215681e-05 2.3985136550844345e-10
+ 2.766050576599426e-05 2.3994252727381691e-10
+ 2.7665633079772843e-05 2.4004700010028028e-10
+ 2.7671995979825154e-05 2.4004483697536087e-10
+ 2.767835887987746e-05 2.3997024527683999e-10
+ 2.7684721779929771e-05 2.3997592655072043e-10
+ 2.7692497256254512e-05 2.4000749931504923e-10
+ 2.7700272732579253e-05 2.4001269631983051e-10
+ 2.7708048208903994e-05 2.3999782508278659e-10
+ 2.7717983441936067e-05 2.3999355892689472e-10
+ 2.7727918674968143e-05 2.4000179472492324e-10
+ 2.7740125706218142e-05 2.4000339716614338e-10
+ 2.7752332737468144e-05 2.3999888202599127e-10
+ 2.7764539768718143e-05 2.3999830525938688e-10
+ 2.7776746799968141e-05 2.4000037974237526e-10
+ 2.7788953831218143e-05 2.4000087414852165e-10
+ 2.7801160862468142e-05 2.3999993966201389e-10
+ 2.7813367893718141e-05 2.3999960494882817e-10
+ 2.7825574924968143e-05 2.4000001432309894e-10
+ 2.7837781956218141e-05 2.4000021737723387e-10
+ 2.7849988987468143e-05 2.4000004462513988e-10
+ 2.7862196018718142e-05 2.3999993006727966e-10
+ 2.7874403049968141e-05 2.3999999917748096e-10
+ 2.7886610081218143e-05 2.4000006049017395e-10
+ 2.7898817112468141e-05 2.4000003421757239e-10
+ 2.7911024143718143e-05 2.4000000237870328e-10
+ 2.7923231174968142e-05 2.4000001256652595e-10
+ 2.7935438206218141e-05 2.4000002745854788e-10
+ 2.7947645237468143e-05 2.4000002475271839e-10
+ 2.7959852268718141e-05 2.4000001795384735e-10
+ 2.797205929996814e-05 2.400000173879749e-10
+ 2.7984266331218142e-05 2.4000002070407596e-10
+ 2.7996473362468141e-05 2.4000002067419452e-10
+ 2.8008680393718139e-05 2.4000001976473751e-10
+ 2.8020887424968142e-05 2.40000019362722e-10
+ 2.803309445621814e-05 2.4000002028128461e-10
+ 2.8045301487468142e-05 2.4000002060646208e-10
+ 2.8057508518718141e-05 2.4000002008287723e-10
+ 2.806971554996814e-05 2.4000001934276911e-10
+ 2.8081922581218142e-05 2.4000001968966948e-10
+ 2.809412961246814e-05 2.4000002093381111e-10
+ 2.8106336643718142e-05 2.4000001965726013e-10
+ 2.8118543674968141e-05 2.4000001961507071e-10
+ 2.813075070621814e-05 2.4000002048512451e-10
+ 2.8142957737468142e-05 2.4000001998121006e-10
+ 2.815516476871814e-05 2.400000199764228e-10
+ 2.8167371799968139e-05 2.4000001998665694e-10
+ 2.8179578831218141e-05 2.4000001988395378e-10
+ 2.819178586246814e-05 2.4000001969840786e-10
+ 2.8203992893718138e-05 2.4000001962628526e-10
+ 2.821619992496814e-05 2.4000001985975601e-10
+ 2.8228406956218139e-05 2.4000001994562599e-10
+ 2.8240613987468141e-05 2.4000001873790616e-10
+ 2.825282101871814e-05 2.400000206888198e-10
+ 2.8265028049968138e-05 2.4000002115772409e-10
+ 2.827723508121814e-05 2.4000001926167516e-10
+ 2.8289442112468139e-05 2.4000001865095655e-10
+ 2.8301649143718141e-05 2.4000002024868279e-10
+ 2.831385617496814e-05 2.4000002062807212e-10
+ 2.8326063206218138e-05 2.4000001971246058e-10
+ 2.833827023746814e-05 2.4000001913611468e-10
+ 2.8350477268718139e-05 2.4000001939609548e-10
+ 2.8362684299968138e-05 2.4000001928925776e-10
+ 2.837489133121814e-05 2.4000002036211893e-10
+ 2.8387098362468138e-05 2.4000001948566678e-10
+ 2.8399305393718137e-05 2.40000020557049e-10
+ 2.8411512424968139e-05 2.400000203491446e-10
+ 2.8423719456218138e-05 2.4000001961720044e-10
+ 2.843592648746814e-05 2.400000200808237e-10
+ 2.8448133518718138e-05 2.4000002006495584e-10
+ 2.8460340549968137e-05 2.4000001941755901e-10
+ 2.8472547581218139e-05 2.4000001925514504e-10
+ 2.8484754612468138e-05 2.4000001949494439e-10
+ 2.849696164371814e-05 2.4000001987457185e-10
+ 2.8509168674968139e-05 2.4000001956535886e-10
+ 2.8521375706218137e-05 2.4000001976899341e-10
+ 2.8533582737468139e-05 2.4000001989767335e-10
+ 2.8545789768718138e-05 2.4000002010421042e-10
+ 2.8557996799968137e-05 2.4000002031692612e-10
+ 2.8570203831218139e-05 2.4000001943796074e-10
+ 2.8582410862468137e-05 2.4000001979057998e-10
+ 2.8594617893718136e-05 2.4000001994141042e-10
+ 2.8606824924968138e-05 2.4000001910787902e-10
+ 2.8619031956218137e-05 2.4000002014157438e-10
+ 2.8631238987468139e-05 2.4000002007976212e-10
+ 2.8643446018718137e-05 2.4000001897875313e-10
+ 2.8655653049968136e-05 2.4000002030066949e-10
+ 2.8667860081218138e-05 2.4000002070432142e-10
+ 2.8680067112468137e-05 2.4000001950520541e-10
+ 2.8692274143718139e-05 2.4000001947980057e-10
+ 2.8704481174968137e-05 2.4000002027253361e-10
+ 2.8716688206218136e-05 2.40000020609859e-10
+ 2.8728895237468138e-05 2.4000001911322354e-10
+ 2.8741102268718137e-05 2.4000001969739074e-10
+ 2.8753309299968135e-05 2.4000002073053612e-10
+ 2.8765516331218137e-05 2.4000001994814067e-10
+ 2.8777723362468136e-05 2.4000001923239209e-10
+ 2.8789930393718135e-05 2.4000002015288261e-10
+ 2.8802137424968137e-05 2.4000001930210656e-10
+ 2.8814344456218135e-05 2.4000001837686493e-10
+ 2.8826551487468137e-05 2.4000001946449939e-10
+ 2.8838758518718136e-05 2.4000002038326192e-10
+ 2.8850965549968138e-05 2.400000203109469e-10
+ 2.8863172581218137e-05 2.400000203952259e-10
+ 2.8875379612468139e-05 2.4000001970496741e-10
+ 2.8887586643718138e-05 2.4000001924454606e-10
+ 2.889979367496814e-05 2.4000001905466872e-10
+ 2.8912000706218138e-05 2.400000204518705e-10
+ 2.892420773746814e-05 2.4000002011557764e-10
+ 2.8936414768718139e-05 2.4000001946831419e-10
+ 2.8948621799968141e-05 2.4000001925940771e-10
+ 2.896082883121814e-05 2.4000001980987061e-10
+ 2.8973035862468142e-05 2.4000002089319245e-10
+ 2.898524289371814e-05 2.4000001973823067e-10
+ 2.8997449924968142e-05 2.4000001879346328e-10
+ 2.9009656956218141e-05 2.4000001869932423e-10
+ 2.9021863987468143e-05 2.4000002074828773e-10
+ 2.9034071018718142e-05 2.4000001934026167e-10
+ 2.9046278049968144e-05 2.4000001952115826e-10
+ 2.9058485081218142e-05 2.4000001987859593e-10
+ 2.9070692112468144e-05 2.400000198982881e-10
+ 2.9082899143718143e-05 2.40000018977687e-10
+ 2.9095106174968145e-05 2.4000001970468766e-10
+ 2.9107313206218144e-05 2.4000001969944985e-10
+ 2.9119520237468146e-05 2.4000002027367879e-10
+ 2.9131727268718145e-05 2.4000001840031488e-10
+ 2.9143934299968147e-05 2.4000001957318321e-10
+ 2.9156141331218145e-05 2.400000188108562e-10
+ 2.9168348362468147e-05 2.4000002046679305e-10
+ 2.9180555393718146e-05 2.4000001950571268e-10
+ 2.9192762424968148e-05 2.4000001838116472e-10
+ 2.9204969456218147e-05 2.4000001853089837e-10
+ 2.9217176487468149e-05 2.4000002004811227e-10
+ 2.9229383518718147e-05 2.4000001966057371e-10
+ 2.9241590549968149e-05 2.4000001941089245e-10
+ 2.9253797581218148e-05 2.4000001913185568e-10
+ 2.926600461246815e-05 2.4000001954838558e-10
+ 2.9278211643718149e-05 2.4000001920964592e-10
+ 2.9290418674968151e-05 2.4000001943469307e-10
+ 2.9302625706218149e-05 2.4000001866641258e-10
+ 2.9314832737468151e-05 2.4000002020897109e-10
+ 2.932703976871815e-05 2.4000001940179987e-10
+ 2.9339246799968152e-05 2.4000001993507329e-10
+ 2.9351453831218151e-05 2.4000002008198123e-10
+ 2.9363660862468153e-05 2.400000198005213e-10
+ 2.9375867893718152e-05 2.4000001916301211e-10
+ 2.9388074924968154e-05 2.4000001960280073e-10
+ 2.9400281956218152e-05 2.4000001963117276e-10
+ 2.9412488987468154e-05 2.400000196254434e-10
+ 2.9424696018718153e-05 2.4000002030623543e-10
+ 2.9436903049968155e-05 2.4000001985486468e-10
+ 2.9449110081218154e-05 2.4000001975560508e-10
+ 2.9461317112468156e-05 2.4000002002563028e-10
+ 2.9473524143718154e-05 2.4000001880683233e-10
+ 2.9485731174968156e-05 2.400000186107882e-10
+ 2.9497938206218155e-05 2.4000002026174485e-10
+ 2.9510145237468157e-05 2.4000001964579944e-10
+ 2.9522352268718156e-05 2.4000001869414737e-10
+ 2.9534559299968158e-05 2.4000002024855297e-10
+ 2.9546766331218156e-05 2.4000001886895933e-10
+ 2.9558973362468158e-05 2.4000001996539064e-10
+ 2.9571180393718157e-05 2.4000001852201533e-10
+ 2.9583387424968159e-05 2.4000001995376353e-10
+ 2.9595594456218158e-05 2.4000001885033681e-10
+ 2.960780148746816e-05 2.400000202275795e-10
+ 2.9620008518718159e-05 2.4000001938682899e-10
+ 2.9632215549968161e-05 2.400000185286626e-10
+ 2.9644422581218159e-05 2.4000002021567022e-10
+ 2.9656629612468161e-05 2.4000001929093104e-10
+ 2.966883664371816e-05 2.4000001945502139e-10
+ 2.9681043674968162e-05 2.4000001849176264e-10
+ 2.9693250706218161e-05 2.4000001899160695e-10
+ 2.9705457737468163e-05 2.4000001908469775e-10
+ 2.9717664768718161e-05 2.4000002021320925e-10
+ 2.9729871799968163e-05 2.4000001986077044e-10
+ 2.9742078831218162e-05 2.4000001985660228e-10
+ 2.9754285862468164e-05 2.4000001982734366e-10
+ 2.9766492893718163e-05 2.4000001909394165e-10
+ 2.9778699924968165e-05 2.4000001971428865e-10
+ 2.9790906956218163e-05 2.4000001921042243e-10
+ 2.9803113987468165e-05 2.400000190589926e-10
+ 2.9815321018718164e-05 2.400000192770844e-10
+ 2.9827528049968166e-05 2.4000001876027354e-10
+ 2.9839735081218165e-05 2.4000001963225885e-10
+ 2.9851942112468167e-05 2.4000001898595255e-10
+ 2.9864149143718166e-05 2.4000001876650681e-10
+ 2.9876356174968168e-05 2.4000001955479303e-10
+ 2.9888563206218166e-05 2.400000192149284e-10
+ 2.9900770237468168e-05 2.4000001962818762e-10
+ 2.9912977268718167e-05 2.400000192259498e-10
+ 2.9925184299968169e-05 2.4000001958046752e-10
+ 2.9937391331218168e-05 2.4000001876653049e-10
+ 2.994959836246817e-05 2.4000001901679062e-10
+ 2.9961805393718168e-05 2.4000001929188411e-10
+ 2.997401242496817e-05 2.4000001878460593e-10
+ 2.9986219456218169e-05 2.4000001895149019e-10
+ 2.9998426487468171e-05 2.4000001953324466e-10
+ 3.001063351871817e-05 2.4000001930179932e-10
+ 3.0022840549968172e-05 2.4000001867284628e-10
+ 3.003504758121817e-05 2.4000001876404646e-10
+ 3.0047254612468172e-05 2.4000001844012502e-10
+ 3.0059461643718171e-05 2.4000001847700822e-10
+ 3.0071668674968173e-05 2.4000001848915366e-10
+ 3.0083875706218172e-05 2.4000001847211049e-10
+ 3.0096082737468174e-05 2.4000001842583542e-10
+ 3.0108289768718172e-05 2.4000001874485954e-10
+ 3.0120496799968175e-05 2.4000001864470591e-10
+ 3.0132703831218173e-05 2.400000192645186e-10
+ 3.0144910862468175e-05 2.4000001911011029e-10
+ 3.0157117893718174e-05 2.400000189594016e-10
+ 3.0169324924968176e-05 2.4000001834385696e-10
+ 3.0181531956218175e-05 2.4000001923683012e-10
+ 3.0193738987468177e-05 2.4000002008098464e-10
+ 3.0205946018718175e-05 2.400000183211859e-10
+ 3.0218153049968177e-05 2.4000001983070817e-10
+ 3.0230360081218176e-05 2.4000001841550595e-10
+ 3.0242567112468178e-05 2.4000001987140726e-10
+ 3.0254774143718177e-05 2.4000001839799459e-10
+ 3.0266981174968179e-05 2.4000001979564812e-10
+ 3.0279188206218177e-05 2.4000001826400317e-10
+ 3.0291395237468179e-05 2.3996544537098469e-10
+ 3.0303602268718178e-05 2.3996256464191007e-10
+ 3.031580929996818e-05 2.3996062147298765e-10
+ 3.0328016331218179e-05 2.399538992151035e-10
+ 3.0340223362468181e-05 2.3990864356794482e-10
+ 3.0352430393718179e-05 2.3980391697569448e-10
+ 3.0364637424968182e-05 2.3960325885649169e-10
+ 3.0370740940593181e-05 2.3930636780140344e-10
+ 3.037684445621818e-05 2.3825018349924986e-10
+ 3.0379896214030683e-05 2.3664385617022961e-10
+ 3.0382947971843183e-05 2.313460144418538e-10
+ 3.0384473850749429e-05 2.2273712950258841e-10
+ 3.0385999729655683e-05 1.9502932447418286e-10
+ 3.0386991106889186e-05 1.3263414891107653e-10
+ 3.0387269733896242e-05 9.5672269136980181e-11
+ 3.0387548360903301e-05 4.6113023016783446e-11
+ 3.038809883562797e-05 4.077304569289076e-11
+ 3.0390875273912436e-05 4.2347131994264368e-11
+ 3.0403082305162435e-05 4.4733371018365243e-11
+ 3.0415289336412437e-05 5.3058719093237963e-11
+ 3.0427496367662439e-05 6.5249849962529414e-11
+ 3.0439703398912437e-05 8.0586557341896391e-11
+ 3.0451910430162436e-05 9.8186059694000248e-11
+ 3.0464117461412438e-05 1.1703587328666208e-10
+ 3.047632449266244e-05 1.3605185310399104e-10
+ 3.0488531523912439e-05 1.5414054504639482e-10
+ 3.0500738555162437e-05 1.7026206156240515e-10
+ 3.0512945586412439e-05 1.8348986297121229e-10
+ 3.0525152617662442e-05 1.9306400774952091e-10
+ 3.053735964891244e-05 1.9843481134517081e-10
+ 3.0549566680162439e-05 1.9929440536940058e-10
+ 3.0561773711412438e-05 1.9559438520732841e-10
+ 3.0573980742662443e-05 1.8754853451668201e-10
+ 3.0586187773912442e-05 1.7562047328816539e-10
+ 3.059839480516244e-05 1.6049694315998822e-10
+ 3.0610601836412446e-05 1.4304826930135124e-10
+ 3.0622808867662444e-05 1.2427827523140709e-10
+ 3.0635015898912443e-05 1.052665328361379e-10
+ 3.0647222930162442e-05 8.7106269937226752e-11
+ 3.065942996141244e-05 7.0841506734532094e-11
+ 3.0671636992662446e-05 5.7407035899497847e-11
+ 3.0683844023912444e-05 4.7574696846103914e-11
+ 3.0686895781724944e-05 4.5750674856066197e-11
+ 3.068704836961557e-05 4.5666462612461995e-11
+ 3.0687429839342132e-05 4.5458870923120094e-11
+ 3.0687467986314786e-05 4.5438342991126504e-11
+ 3.0687475615709319e-05 4.5434242455099145e-11
+ 3.0687490874498383e-05 4.5426046434154427e-11
+ 3.0687496978014005e-05 4.5422769911655126e-11
+ 3.0687499419420261e-05 4.542145960441293e-11
+ 3.0687499604455787e-05 4.5421360302533612e-11
+ 3.068749997452684e-05 4.5421161701746532e-11
+ 3.0687500714668945e-05 5.7234708751505077e-08
+ 3.0687501454811058e-05 2.3609835104101694e-07
+ 3.0687508856232148e-05 8.3378657603255145e-06
+ 3.0687516257653237e-05 2.6804211983519737e-05
+ 3.0687523659074327e-05 5.4212572160978158e-05
+ 3.0687531060495417e-05 8.9333429400249197e-05
+ 3.0687538461916507e-05 0.00013110387761772142
+ 3.068754751235569e-05 0.00018988604042548046
+ 3.0687556562794867e-05 0.000255812068272275
+ 3.0687565613234051e-05 0.00032768193023753725
+ 3.0687574663673228e-05 0.00040448949601993325
+ 3.0687583714112411e-05 0.00048539058840956265
+ 3.068759504453351e-05 0.00059137048504824714
+ 3.0687606374954608e-05 0.00070151686849491022
+ 3.0687617705375707e-05 0.0008149054011463608
+ 3.0687629035796805e-05 0.00093078918228233572
+ 3.068764321465336e-05 0.0010784080416500865
+ 3.0687657393509915e-05 0.0012280520970111633
+ 3.068767157236647e-05 0.0013789889014004875
+ 3.0687689032396934e-05 0.0015657925325384681
+ 3.0687706492427399e-05 0.0017528666320927736
+ 3.0687723952457863e-05 0.0019395804048633696
+ 3.0687746268477833e-05 0.0021769293571718938
+ 3.0687768584497803e-05 0.0024120996791847497
+ 3.0687790900517773e-05 0.0026444704336099976
+ 3.0687819090217242e-05 0.0029332237971511233
+ 3.0687847279916711e-05 0.0032158629328255771
+ 3.068787546961618e-05 0.0034916668520790159
+ 3.068790365931565e-05 0.0037599988278231356
+ 3.0687931849015119e-05 0.0040202830355208904
+ 3.0687960038714595e-05 0.0042719918874605982
+ 3.0687988228414064e-05 0.0045146394015623476
+ 3.0688019414106473e-05 0.0047719795450323309
+ 3.0688050599798882e-05 0.0050171295125712645
+ 3.0688081785491297e-05 0.0052495906087394869
+ 3.0688112971183706e-05 0.0054689190353913904
+ 3.0688150418414339e-05 0.0057143885297757718
+ 3.0688187865644965e-05 0.0059397992525804574
+ 3.0688225312875597e-05 0.006144702220679193
+ 3.0688270844195807e-05 0.0063657430322260553
+ 3.0688316375516024e-05 0.0065556175023236875
+ 3.0688361906836234e-05 0.0067142112673811444
+ 3.0688407438156444e-05 0.0068416534980290083
+ 3.0688441084028109e-05 0.0069160175765833089
+ 3.0688474729899775e-05 0.0069737900261410465
+ 3.068850837577144e-05 0.0070152594941248576
+ 3.0688542021643106e-05 0.0070407746969006688
+ 3.0688575667514771e-05 0.007050740823760393
+ 3.0688609313386437e-05 0.0070456156939712805
+ 3.0688642959258102e-05 0.007025905702338452
+ 3.0688676605129767e-05 0.0069921615895264296
+ 3.0688710251001433e-05 0.0069449740739896257
+ 3.068873687066815e-05 0.006898526876910809
+ 3.068876349033486e-05 0.0068443802044164921
+ 3.0688790110001569e-05 0.0067828688534493494
+ 3.0688816729668279e-05 0.0067143369242957376
+ 3.0688843349334989e-05 0.0066391364097472113
+ 3.0688869969001699e-05 0.0065576257964309343
+ 3.0688896588668409e-05 0.0064701686843428533
+ 3.0688923208335126e-05 0.0063771324303375145
+ 3.0688949828001836e-05 0.0062788868210215225
+ 3.0688976447668546e-05 0.0061758027801676225
+ 3.0689003067335255e-05 0.0060682511154162089
+ 3.0689029687001965e-05 0.0059566013086644297
+ 3.0689056306668675e-05 0.0058412203541628417
+ 3.0689082926335385e-05 0.0057224716479485063
+ 3.0689109546002095e-05 0.0056007139318451742
+ 3.0689136165668805e-05 0.0054763002948580381
+ 3.0689162785335522e-05 0.0053495772343856614
+ 3.0689189405002232e-05 0.0052208837792675896
+ 3.0689216024668941e-05 0.0050905506764474901
+ 3.0689239404935231e-05 0.0049749804171373225
+ 3.0689262785201514e-05 0.0048586054363550972
+ 3.0689286165467804e-05 0.0047416314482211135
+ 3.0689309545734094e-05 0.0046242577652878883
+ 3.0689332926000384e-05 0.0045066770343838705
+ 3.0689356306266667e-05 0.0043890750025309139
+ 3.0689379686532957e-05 0.0042716303126259531
+ 3.0689403066799247e-05 0.0041545143284691553
+ 3.0689426447065537e-05 0.0040378909886185305
+ 3.068944982733182e-05 0.0039219166884552218
+ 3.068947320759811e-05 0.0038067401897542695
+ 3.06894965878644e-05 0.0036925025569730643
+ 3.068951996813069e-05 0.0035793371193940525
+ 3.0689543348396973e-05 0.0034673694581895016
+ 3.0689566728663263e-05 0.0033567174174145066
+ 3.0689590108929553e-05 0.0032474911378798247
+ 3.0689613489195843e-05 0.0031397931128086067
+ 3.0689636869462126e-05 0.0030337182641405314
+ 3.0689660249728416e-05 0.0029293540383132049
+ 3.0689683629994706e-05 0.0028267805203238136
+ 3.0689707010260995e-05 0.0027260705648536779
+ 3.0689735591237516e-05 0.0026055855381113117
+ 3.0689764172214043e-05 0.0024880893416989024
+ 3.0689792753190564e-05 0.0023736731389782805
+ 3.0689821334167091e-05 0.0022624136400195647
+ 3.0689849915143611e-05 0.0021543736566158275
+ 3.068988619980621e-05 0.0020219271947776738
+ 3.0689925453373383e-05 0.0018846580284455387
+ 3.0689946977215262e-05 0.0018120618774395494
+ 3.0689973696714698e-05 0.0017245821083065652
+ 3.0690000416214134e-05 0.0016400258203643724
+ 3.069002713571357e-05 0.0015583844444338579
+ 3.0690053855213006e-05 0.0014796423351417674
+ 3.0690080574712442e-05 0.0014037772468436488
+ 3.0690107294211878e-05 0.0013307608065583204
+ 3.0690134013711314e-05 0.0012605589819463642
+ 3.0690160733210751e-05 0.0011931325425094006
+ 3.0690187452710187e-05 0.0011284375123336611
+ 3.0690214172209623e-05 0.0010664256128491564
+ 3.0690240891709059e-05 0.0010070446942234952
+ 3.0690262548859612e-05 0.00096080661895637035
+ 3.0690284206010166e-05 0.0009162294538821239
+ 3.0690305863160719e-05 0.00087328092606094238
+ 3.0690327520311266e-05 0.00083192771752318962
+ 3.0690349177461819e-05 0.00079213559354230647
+ 3.0690370834612373e-05 0.00075386952625768001
+ 3.0690392491762919e-05 0.00071709381353394315
+ 3.0690414148913473e-05 0.00068177219296354193
+ 3.0690435806064026e-05 0.00064786795094112185
+ 3.069045746321458e-05 0.00061534402675914772
+ 3.0690479120365133e-05 0.00058416311167918647
+ 3.0690496765399601e-05 0.00055972551886932095
+ 3.0690514410434075e-05 0.00053613426244406741
+ 3.069053205546855e-05 0.00051336904748169171
+ 3.0690549700503025e-05 0.00049140960981622914
+ 3.0690567345537499e-05 0.00047023574348777509
+ 3.0690584990571974e-05 0.00044982732676715286
+ 3.0690602635606449e-05 0.00043016434677204047
+ 3.0690620280640916e-05 0.00041122692269401575
+ 3.0690637925675391e-05 0.00039299532765819798
+ 3.0690655570709866e-05 0.00037545000923921415
+ 3.069067321574434e-05 0.00035857160865911174
+ 3.0690690860778815e-05 0.00034234097869457157
+ 3.0690708505813289e-05 0.00032673920032235228
+ 3.0690726150847764e-05 0.00031174759813332067
+ 3.0690743795882239e-05 0.00029734775454669758
+ 3.0690761440916713e-05 0.00028352152285727745
+ 3.0690779085951181e-05 0.0002702510391493668
+ 3.0690796730985656e-05 0.00025751873311203796
+ 3.069081437602013e-05 0.00024530733779101174
+ 3.0690832021054605e-05 0.00023359989831307307
+ 3.069084966608908e-05 0.00022237977961939102
+ 3.0690867311123554e-05 0.00021163067324446447
+ 3.0690884956158029e-05 0.00020133660317765155
+ 3.0690902601192497e-05 0.00019148193084437179
+ 3.0690920246226971e-05 0.00018205135924409671
+ 3.0690937891261446e-05 0.00017302993628217709
+ 3.0690955536295921e-05 0.00016440305733239472
+ 3.0690973181330395e-05 0.00015615646706688136
+ 3.069099082636487e-05 0.00014827626058972067
+ 3.0691008471399344e-05 0.00014074888391014853
+ 3.0691026116433819e-05 0.00013356113379079491
+ 3.0691043761468294e-05 0.00012670015700587552
+ 3.0691061406502761e-05 0.00012015344904364461
+ 3.0691079051537236e-05 0.00011390885228677083
+ 3.0691096696571711e-05 0.00010795455370359766
+ 3.0691114341606185e-05 0.00010227908208250491
+ 3.069113198664066e-05 9.687130484080241e-05
+ 3.0691149631675134e-05 9.1720424438765868e-05
+ 3.0691167276709609e-05 8.6815974428572379e-05
+ 3.0691184921744077e-05 8.2147815167013072e-05
+ 3.0691202566778552e-05 7.7706129219957601e-05
+ 3.0691220211813026e-05 7.3481416485622882e-05
+ 3.0691237856847501e-05 6.9464489062760908e-05
+ 3.0691255501881975e-05 6.5646465888930612e-05
+ 3.069127314691645e-05 6.2018767173060703e-05
+ 3.0691290791950925e-05 5.8573108645546759e-05
+ 3.0691308436985399e-05 5.5301495648160228e-05
+ 3.0691326082019874e-05 5.2196217085081444e-05
+ 3.0691343727054342e-05 4.9249839255407143e-05
+ 3.0691361372088816e-05 4.6455199586526805e-05
+ 3.0691379017123291e-05 4.3805400286814076e-05
+ 3.0691396662157766e-05 4.1293801935142287e-05
+ 3.069141430719224e-05 3.8914017023807698e-05
+ 3.0691431952226715e-05 3.6659903470533496e-05
+ 3.0691449597261189e-05 3.4525558114332587e-05
+ 3.0691467242295657e-05 3.2505310209129923e-05
+ 3.0691484887330132e-05 3.0593714928186798e-05
+ 3.0691502532364606e-05 2.878554689153125e-05
+ 3.0691520177399081e-05 2.7075793727781893e-05
+ 3.0691537822433556e-05 2.5459649680957857e-05
+ 3.069155546746803e-05 2.3932509272096093e-05
+ 3.0691573112502505e-05 2.2489961024749567e-05
+ 3.069159075753698e-05 2.1127781262716843e-05
+ 3.0691608402571454e-05 1.9841927987655173e-05
+ 3.0691626047605922e-05 1.8628534843556469e-05
+ 3.0691643692640397e-05 1.7483905174418017e-05
+ 3.0691661337674871e-05 1.6404506180818473e-05
+ 3.0691682620107576e-05 1.5184596516820046e-05
+ 3.069170274528168e-05 1.4108722156777394e-05
+ 3.0691722870455783e-05 1.3103783271809466e-05
+ 3.0691742995629887e-05 1.2165512099818384e-05
+ 3.0691763120803983e-05 1.1289867233639744e-05
+ 3.0691783245978087e-05 1.0473023791237365e-05
+ 3.069180337115219e-05 9.711363860421274e-06
+ 3.0691823496326294e-05 9.0014672215583367e-06
+ 3.0691843621500397e-05 8.3401023506671107e-06
+ 3.06918637466745e-05 7.7242177042852387e-06
+ 3.0691888110746126e-05 7.0353574872189284e-06
+ 3.0691912474817752e-05 6.4041509733236313e-06
+ 3.0691936838889385e-05 5.8261375978047346e-06
+ 3.069196120296101e-05 5.2971679183216326e-06
+ 3.0691985567032636e-05 4.8133849648221628e-06
+ 3.0692009931104262e-05 4.3712064413582404e-06
+ 3.0692034295175895e-05 3.9673077642003495e-06
+ 3.069205865924752e-05 3.5986059186122073e-06
+ 3.0692083023319146e-05 3.2622441148827113e-06
+ 3.0692107387390772e-05 2.955577222710442e-06
+ 3.0692136719683572e-05 2.6223173518557521e-06
+ 3.0692166051976365e-05 2.3246430183300364e-06
+ 3.0692195384269158e-05 2.0589938235170389e-06
+ 3.0692224716561951e-05 1.8221375097881734e-06
+ 3.0692254048854751e-05 1.6111428978970881e-06
+ 3.0692283381147544e-05 1.4233547079677823e-06
+ 3.0692312713440338e-05 1.2563701699769522e-06
+ 3.0692342045733131e-05 1.1080173307665688e-06
+ 3.0692377848029195e-05 9.4935328593955194e-07
+ 3.0692412335454629e-05 8.1703614317247063e-07
+ 3.0692446822880064e-05 7.0231034037170861e-07
+ 3.0692481310305498e-05 6.0295931014601184e-07
+ 3.0692515797730933e-05 5.1702814794412422e-07
+ 3.0692557828321211e-05 4.2796498791424164e-07
+ 3.0692599858911489e-05 3.5358466304975593e-07
+ 3.0692641889501767e-05 2.9157919961691281e-07
+ 3.0692683920092045e-05 2.3998333476715486e-07
+ 3.0692725950682323e-05 1.9712710629082681e-07
+ 3.0692777518503422e-05 1.5442331314774624e-07
+ 3.069282818666648e-05 1.2110746118199679e-07
+ 3.0692878854829539e-05 9.4668212428266369e-08
+ 3.0692929522992597e-05 7.3741045625230226e-08
+ 3.0692993215143461e-05 5.3572482382509411e-08
+ 3.0693056907294326e-05 3.8650410566722333e-08
+ 3.069312059944519e-05 2.7655607125139506e-08
+ 3.0693198945610717e-05 1.80624388894615e-08
+ 3.0693278657649688e-05 1.1455385675920075e-08
+ 3.0693358369688667e-05 7.0279116712338033e-09
+ 3.0693461292370762e-05 3.42722610432318e-09
+ 3.0693569508909818e-05 1.2415251844169095e-09
+ 3.0693701914804436e-05 -1.7423168879043324e-10
+ 3.0693847065030185e-05 -9.0046498724308251e-10
+ 3.0694034315235686e-05 -1.2675598336250834e-09
+ 3.0694255865010427e-05 -1.390661486095478e-09
+ 3.0694554034092504e-05 -1.4079464626524889e-09
+ 3.0694998769870886e-05 -1.3781166774969621e-09
+ 3.0695805003988995e-05 -1.313948994893242e-09
+ 3.0696711764368316e-05 -1.2450592154006523e-09
+ 3.0697737475686443e-05 -1.1711746826522686e-09
+ 3.069880114340234e-05 -1.0985374417948889e-09
+ 3.0699944764949547e-05 -1.0244977902794022e-09
+ 3.0702231646278912e-05 -8.876839903243166e-10
+ 3.070418268121666e-05 -7.8153991862173163e-10
+ 3.0706291228517248e-05 -6.7660226349856925e-10
+ 3.0708581467436163e-05 -5.7299433820914436e-10
+ 3.0710926666850021e-05 -4.7698621811411996e-10
+ 3.0713271866263885e-05 -3.901690868650475e-10
+ 3.0715590537179629e-05 -3.1248869476676087e-10
+ 3.0718474569484282e-05 -2.2600941125466692e-10
+ 3.0721358601788929e-05 -1.4953972152878652e-10
+ 3.0724242634093575e-05 -8.1909642546355165e-11
+ 3.0727126666398228e-05 -2.2097231394821104e-11
+ 3.0730010698702875e-05 3.0804763949844941e-11
+ 3.0732894731007528e-05 7.7599184420572088e-11
+ 3.0735778763312175e-05 1.1899177680085989e-10
+ 3.0739342797663592e-05 1.6360497315690482e-10
+ 3.0742906832015016e-05 2.0194460469335925e-10
+ 3.0746470866366433e-05 2.3489304324568193e-10
+ 3.0750034900717857e-05 2.6320792465228799e-10
+ 3.0753598935069274e-05 2.8754418863776942e-10
+ 3.075789996112736e-05 3.124003450031708e-10
+ 3.0762200987185453e-05 3.3310188136055884e-10
+ 3.0766502013243539e-05 3.5034335018174361e-10
+ 3.0770803039301626e-05 3.6470346013268147e-10
+ 3.0775104065359719e-05 3.7666442373221598e-10
+ 3.0780502505986983e-05 3.8888313831481749e-10
+ 3.0785900946614253e-05 3.9859542479219459e-10
+ 3.0791299387241517e-05 4.0629545583254085e-10
+ 3.0796697827868781e-05 4.1242659596079512e-10
+ 3.0803468247657468e-05 4.1836450212166619e-10
+ 3.0810238667446156e-05 4.228142873871682e-10
+ 3.0817009087234844e-05 4.2614500842071573e-10
+ 3.0825385304343956e-05 4.2912633403108892e-10
+ 3.0833761521453069e-05 4.3120345772378355e-10
+ 3.0842137738562181e-05 4.3264838822889765e-10
+ 3.0853043385488654e-05 4.3388610175178318e-10
+ 3.0863949032415133e-05 4.3464666000495187e-10
+ 3.0876156063665131e-05 4.3514763453961883e-10
+ 3.088836309491513e-05 4.3542384097085643e-10
+ 3.0900570126165129e-05 4.3556624282357159e-10
+ 3.0912777157415134e-05 4.3562884855868211e-10
+ 3.0924984188665133e-05 4.3564390919099658e-10
+ 3.0937191219915131e-05 4.3563071731303817e-10
+ 3.0949398251165137e-05 4.3560072832369711e-10
+ 3.0961605282415136e-05 4.3556071800624522e-10
+ 3.0973812313665134e-05 4.3551473285478916e-10
+ 3.0986019344915133e-05 4.3546520640556509e-10
+ 3.0998226376165132e-05 4.3541358487496968e-10
+ 3.1010433407415137e-05 4.3536071753580087e-10
+ 3.1022640438665136e-05 4.353071102954193e-10
+ 3.1034847469915134e-05 4.3525307030070124e-10
+ 3.104705450116514e-05 4.3519878102624261e-10
+ 3.1059261532415138e-05 4.3514434891989702e-10
+ 3.1071468563665137e-05 4.3508983678706616e-10
+ 3.1083675594915136e-05 4.3503528333983576e-10
+ 3.1095882626165134e-05 4.3498071205926307e-10
+ 3.110808965741514e-05 4.3492613633167183e-10
+ 3.1120296688665138e-05 4.348715638520445e-10
+ 3.1132503719915137e-05 4.3481699946235471e-10
+ 3.1144710751165142e-05 4.3476244620745766e-10
+ 3.1156917782415141e-05 4.3470790578886986e-10
+ 3.116912481366514e-05 4.3465337912630206e-10
+ 3.1181331844915138e-05 4.3459886680952396e-10
+ 3.1193538876165137e-05 4.3454436923774573e-10
+ 3.1205745907415143e-05 4.3448988663097442e-10
+ 3.1217952938665141e-05 4.3443541909242035e-10
+ 3.123015996991514e-05 4.3438096668679938e-10
+ 3.1242367001165145e-05 4.3432652946422885e-10
+ 3.1250000000000001e-05 4.3429323819786375e-10
+ 3.1262207031249999e-05 4.3423882549145797e-10
+ 3.1274414062499998e-05 4.3418442800650571e-10
+ 3.1286621093750003e-05 4.3413004574565444e-10
+ 3.1298828125000002e-05 4.3407567870875607e-10
+ 3.1311035156250001e-05 4.3402132689399754e-10
+ 3.1323242187499999e-05 4.3396699029857563e-10
+ 3.1335449218749998e-05 4.3391266891909689e-10
+ 3.1347656250000003e-05 4.338583627518177e-10
+ 3.1359863281250002e-05 4.338040717927861e-10
+ 3.1372070312500001e-05 4.3374979603792648e-10
+ 3.1384277343749999e-05 4.3369553548309005e-10
+ 3.1396484374999998e-05 4.3364129012408513e-10
+ 3.1408691406250004e-05 4.3358705995669485e-10
+ 3.1420898437500002e-05 4.3353284497668784e-10
+ 3.1433105468750001e-05 4.3347864517982436e-10
+ 3.1445312499999999e-05 4.3342446056186068e-10
+ 3.1457519531249998e-05 4.3337029111855061e-10
+ 3.1469726562500004e-05 4.3331613684564742e-10
+ 3.1481933593750002e-05 4.3326199773890431e-10
+ 3.1494140625000001e-05 4.3320787379407488e-10
+ 3.150634765625e-05 4.3315376500691365e-10
+ 3.1518554687499998e-05 4.3309967137317592e-10
+ 3.1530761718750004e-05 4.3304559288861817e-10
+ 3.1542968750000002e-05 4.3299152954899793e-10
+ 3.1555175781250001e-05 4.3293748135007384e-10
+ 3.15673828125e-05 4.3288344828760572e-10
+ 3.1579589843749998e-05 4.3282943035735457e-10
+ 3.1591796875000004e-05 4.3277542755508266e-10
+ 3.1604003906250002e-05 4.327214398765532e-10
+ 3.1616210937500001e-05 4.3266746731753079e-10
+ 3.162841796875e-05 4.3261350987378112e-10
+ 3.1640624999999998e-05 4.3255956754107106e-10
+ 3.1652832031250004e-05 4.3250564031516869e-10
+ 3.1665039062500002e-05 4.324517281918434e-10
+ 3.1677246093750001e-05 4.3239783116686546e-10
+ 3.1689453125e-05 4.3234394923600652e-10
+ 3.1701660156249998e-05 4.3229008239503964e-10
+ 3.1713867187499997e-05 4.322362306397386e-10
+ 3.1726074218750002e-05 4.3218239396587857e-10
+ 3.1738281250000001e-05 4.3212857236923607e-10
+ 3.175048828125e-05 4.3207476584558855e-10
+ 3.1762695312499998e-05 4.3202097439071481e-10
+ 3.1774902343749997e-05 4.3196719800039462e-10
+ 3.1787109375000002e-05 4.3191343667040926e-10
+ 3.1799316406250001e-05 4.3185969039654094e-10
+ 3.18115234375e-05 4.3180595917457319e-10
+ 3.1823730468749998e-05 4.3175224300029046e-10
+ 3.1835937500000004e-05 4.3169854186947872e-10
+ 3.1848144531250003e-05 4.3164485577792515e-10
+ 3.1860351562500001e-05 4.3159118472141752e-10
+ 3.187255859375e-05 4.315375286957455e-10
+ 3.1884765624999999e-05 4.3148388769669956e-10
+ 3.1896972656250004e-05 4.3143026172007142e-10
+ 3.1909179687500003e-05 4.3137665076165393e-10
+ 3.1921386718750001e-05 4.3132305481724119e-10
+ 3.193359375e-05 4.3126947388262849e-10
+ 3.1945800781249999e-05 4.3121590795361226e-10
+ 3.1958007812500004e-05 4.3116235702599014e-10
+ 3.1970214843750003e-05 4.311088210955608e-10
+ 3.1982421875000001e-05 4.3105530015812432e-10
+ 3.199462890625e-05 4.3100179420948178e-10
+ 3.2006835937499999e-05 4.3094830324543561e-10
+ 3.2019042968750004e-05 4.3089482726178914e-10
+ 3.2031250000000003e-05 4.3084136625434698e-10
+ 3.2043457031250001e-05 4.3078792021891527e-10
+ 3.20556640625e-05 4.3073448915130076e-10
+ 3.2067871093749999e-05 4.3068107304731183e-10
+ 3.2080078125000004e-05 4.3062767190275767e-10
+ 3.2092285156250003e-05 4.3057428571344897e-10
+ 3.2104492187500001e-05 4.305209144751974e-10
+ 3.211669921875e-05 4.3046755818381573e-10
+ 3.2128906249999999e-05 4.3041421683511815e-10
+ 3.2141113281250004e-05 4.3036089042491982e-10
+ 3.2153320312500003e-05 4.3030757894903721e-10
+ 3.2165527343750001e-05 4.3025428240328784e-10
+ 3.2177734375e-05 4.3020100078349046e-10
+ 3.2189941406249999e-05 4.3014773408546503e-10
+ 3.2202148437500004e-05 4.3009448230503257e-10
+ 3.2214355468750003e-05 4.3004124543801536e-10
+ 3.2226562500000002e-05 4.2998802348023685e-10
+ 3.223876953125e-05 4.2993481642752165e-10
+ 3.2250976562499999e-05 4.298816242756955e-10
+ 3.2263183593750004e-05 4.2982844702058526e-10
+ 3.2275390625000003e-05 4.2977528465801911e-10
+ 3.2287597656250002e-05 4.2972213718382639e-10
+ 3.22998046875e-05 4.296690045938374e-10
+ 3.2312011718749999e-05 4.2961588688388387e-10
+ 3.2324218750000004e-05 4.2956278404979846e-10
+ 3.2336425781250003e-05 4.2950969608741529e-10
+ 3.2348632812500002e-05 4.2945662299256918e-10
+ 3.236083984375e-05 4.2940356476109669e-10
+ 3.2373046874999999e-05 4.2935052138883517e-10
+ 3.2385253906249998e-05 4.2929749287162315e-10
+ 3.2397460937500003e-05 4.2924447920530045e-10
+ 3.2409667968750002e-05 4.2919148038570803e-10
+ 3.2421875e-05 4.2913849640868801e-10
+ 3.2434082031249999e-05 4.2908552727008359e-10
+ 3.2446289062499998e-05 4.2903257296573924e-10
+ 3.2458496093750003e-05 4.2897963349150058e-10
+ 3.2470703125000002e-05 4.2892670884321429e-10
+ 3.248291015625e-05 4.288737990167283e-10
+ 3.2495117187499999e-05 4.2882090400789185e-10
+ 3.2507324218749998e-05 4.2876802381255504e-10
+ 3.2519531249999996e-05 4.2871515842656934e-10
+ 3.2531738281250002e-05 4.2866230784578723e-10
+ 3.25439453125e-05 4.2860947206606246e-10
+ 3.2556152343749999e-05 4.2855665108325002e-10
+ 3.2568359374999998e-05 4.2850384489320595e-10
+ 3.2580566406249996e-05 4.2845105349178732e-10
+ 3.2592773437500002e-05 4.2839827687485269e-10
+ 3.260498046875e-05 4.2834551503826145e-10
+ 3.2617187499999999e-05 4.2829276797787439e-10
+ 3.2629394531249998e-05 4.2824003568955333e-10
+ 3.2641601562499996e-05 4.2818731816916134e-10
+ 3.2653808593750002e-05 4.2813461541256231e-10
+ 3.2666015625000001e-05 4.2808192741562203e-10
+ 3.2678222656249999e-05 4.2802925417420679e-10
+ 3.2690429687499998e-05 4.2797659568418397e-10
+ 3.2702636718749997e-05 4.2792395194142275e-10
+ 3.2714843750000002e-05 4.2787132294179297e-10
+ 3.2727050781250001e-05 4.2781870868116553e-10
+ 3.2739257812499999e-05 4.2776610915541303e-10
+ 3.2751464843749998e-05 4.2771352436040875e-10
+ 3.2763671874999997e-05 4.2766095429202714e-10
+ 3.2775878906249995e-05 4.2760839894614423e-10
+ 3.2788085937500001e-05 4.2755585831863669e-10
+ 3.2800292968749999e-05 4.2750333240538267e-10
+ 3.2812499999999998e-05 4.2745082120226136e-10
+ 3.2824707031249997e-05 4.2739832470515305e-10
+ 3.2836914062499995e-05 4.273458429099393e-10
+ 3.2849121093750001e-05 4.2729337581250278e-10
+ 3.2861328124999999e-05 4.2724092340872732e-10
+ 3.2873535156249998e-05 4.2718848569449787e-10
+ 3.2885742187499997e-05 4.2713606266570053e-10
+ 3.2897949218749995e-05 4.2708365431822263e-10
+ 3.2910156249999994e-05 4.270312606479525e-10
+ 3.2922363281249999e-05 4.2697888165077988e-10
+ 3.2934570312499998e-05 4.2692651732259529e-10
+ 3.2946777343749997e-05 4.2687416765929084e-10
+ 3.2958984374999995e-05 4.2682183265675928e-10
+ 3.2971191406249994e-05 4.2676951231089505e-10
+ 3.2983398437499999e-05 4.2671720661759342e-10
+ 3.2995605468749998e-05 4.2666491557275079e-10
+ 3.3007812499999997e-05 4.2661263917226478e-10
+ 3.3020019531249995e-05 4.265603774120343e-10
+ 3.3032226562499994e-05 4.265081302879591e-10
+ 3.304443359375e-05 4.2645589779594043e-10
+ 3.3056640624999998e-05 4.2640367993188038e-10
+ 3.3068847656249997e-05 4.2635147669168246e-10
+ 3.3081054687499996e-05 4.2629928807125108e-10
+ 3.3093261718749994e-05 4.2624711406649186e-10
+ 3.310546875e-05 4.2619495467331169e-10
+ 3.3117675781249998e-05 4.2614280988761856e-10
+ 3.3129882812499997e-05 4.2609067970532156e-10
+ 3.3142089843749996e-05 4.2603856412233079e-10
+ 3.3154296874999994e-05 4.2598646313455786e-10
+ 3.3166503906249993e-05 4.2593437673791515e-10
+ 3.3178710937499998e-05 4.2588230492831644e-10
+ 3.3190917968749997e-05 4.2583024770167654e-10
+ 3.3203124999999996e-05 4.2577820505391141e-10
+ 3.3215332031249994e-05 4.2572617698093814e-10
+ 3.3227539062499993e-05 4.2567416347867499e-10
+ 3.3239746093749998e-05 4.2562216454304139e-10
+ 3.3251953124999997e-05 4.2557018016995789e-10
+ 3.3264160156249996e-05 4.2551821035534623e-10
+ 3.3276367187499994e-05 4.2546625509512913e-10
+ 3.3288574218749993e-05 4.254143143852306e-10
+ 3.3300781249999992e-05 4.2536238822157581e-10
+ 3.3312988281249997e-05 4.2531047660009089e-10
+ 3.3325195312499996e-05 4.2525857951670346e-10
+ 3.3337402343749994e-05 4.252066969673418e-10
+ 3.3349609374999993e-05 4.2515482894793579e-10
+ 3.3361816406249992e-05 4.2510297545441604e-10
+ 3.3374023437499997e-05 4.2505113648271467e-10
+ 3.3386230468749996e-05 4.2499931202876474e-10
+ 3.3398437499999994e-05 4.2494750208850055e-10
+ 3.3410644531249993e-05 4.248957066578573e-10
+ 3.3422851562499992e-05 4.2482519493572964e-10
+ 3.3435058593749997e-05 4.2475256100502045e-10
+ 3.3447265624999996e-05 4.2468173951608737e-10
+ 3.3459472656249994e-05 4.2459666096075283e-10
+ 3.3471679687499993e-05 4.2448010616874532e-10
+ 3.3483886718749992e-05 4.242745676347303e-10
+ 3.3489990234374991e-05 4.2406762246865748e-10
+ 3.3496093749999997e-05 4.2364446431160585e-10
+ 3.3499145507812497e-05 4.2320637096990359e-10
+ 3.3502197265624997e-05 4.2237081875579266e-10
+ 3.3505249023437496e-05 4.2039912634768696e-10
+ 3.3506606790774088e-05 4.184858057925494e-10
+ 3.3506998216660861e-05 4.1769354662518729e-10
+ 3.3507389642547634e-05 4.1673967866159501e-10
+ 3.3508368207264576e-05 4.1328644574257995e-10
+ 3.3509409502908187e-05 4.0647792025774505e-10
+ 3.3509970598735322e-05 4.0009399586852752e-10
+ 3.3510339629298368e-05 3.9400830485401903e-10
+ 3.3511110323815843e-05 3.7217296598144555e-10
+ 3.3511741481233846e-05 3.3482378565862255e-10
+ 3.3512113084009008e-05 2.9476725253157392e-10
+ 3.3512434193795786e-05 2.3913652951300332e-10
+ 3.3512647097925408e-05 2.1273235713088472e-10
+ 3.351286000205503e-05 2.1207408791108858e-10
+ 3.3514989043351245e-05 2.1185023895337551e-10
+ 3.3527196074601243e-05 2.0757980032582087e-10
+ 3.3539403105851242e-05 1.9827504053149293e-10
+ 3.3551610137101247e-05 1.8447156434439206e-10
+ 3.3563817168351246e-05 1.6696410651490149e-10
+ 3.3576024199601245e-05 1.4676018343964647e-10
+ 3.3588231230851243e-05 1.2502212943217047e-10
+ 3.3600438262101242e-05 1.0300022779102304e-10
+ 3.3612645293351241e-05 8.1960799754197404e-11
+ 3.3624852324601246e-05 6.311338755160194e-11
+ 3.3637059355851245e-05 4.7541218733423125e-11
+ 3.3649266387101243e-05 3.6138949326912032e-11
+ 3.3661473418351242e-05 2.9561263935700322e-11
+ 3.3673680449601241e-05 2.8185285811614418e-11
+ 3.3685887480851246e-05 3.2088955187765566e-11
+ 3.3698094512101245e-05 4.1046615499322252e-11
+ 3.3710301543351243e-05 5.4542057385810135e-11
+ 3.3722508574601242e-05 7.1798266491615728e-11
+ 3.3734715605851241e-05 9.1822160785597292e-11
+ 3.3746922637101246e-05 1.1346174161334856e-10
+ 3.3759129668351245e-05 1.3547236949090519e-10
+ 3.3771336699601243e-05 1.5658835172212636e-10
+ 3.3783543730851242e-05 1.7559572435646284e-10
+ 3.3795750762101241e-05 1.9140204326212496e-10
+ 3.3807957793351246e-05 2.030991720132836e-10
+ 3.3811009551163746e-05 2.0529687447679853e-10
+ 3.3811314726944991e-05 2.0549982177660819e-10
+ 3.3812077666398114e-05 2.0599366009052315e-10
+ 3.3812459136124683e-05 2.062333046850057e-10
+ 3.3812482977982594e-05 2.0624812098499301e-10
+ 3.381248774635417e-05 2.0625108196291897e-10
+ 3.3812497283097337e-05 2.0625700163649109e-10
+ 3.3812498046036786e-05 2.0625747507891284e-10
+ 3.3812499571915696e-05 2.0625842190532621e-10
+ 3.3812499693986006e-05 2.0625849764807365e-10
+ 3.381249993812663e-05 2.0625864913207268e-10
+ 3.3812499957657882e-05 2.0625866125070641e-10
+ 3.3812499996720385e-05 2.0625868548793557e-10
+ 3.3812500074845385e-05 8.3574849775232329e-10
+ 3.3812500152970385e-05 2.8382408459534785e-09
+ 3.3812500934220382e-05 9.7910663945931592e-08
+ 3.3812508051845976e-05 6.9281309170090845e-06
+ 3.381251516947157e-05 2.3496919613390592e-05
+ 3.3812522287097164e-05 4.8515586154137975e-05
+ 3.3812529404722765e-05 8.0864107426474553e-05
+ 3.381253652234836e-05 0.0001195688537478285
+ 3.3812543639973954e-05 0.00016378325676260678
+ 3.3812550757599555e-05 0.00021277103077073492
+ 3.3812557875225149e-05 0.00026589161027525284
+ 3.3812564992850743e-05 0.00032258751106878353
+ 3.3812572110476345e-05 0.00038237336083026571
+ 3.3812579228101939e-05 0.00044482637875059637
+ 3.3812587807568571e-05 0.00052313156179263198
+ 3.3812596387035203e-05 0.00060422377214069478
+ 3.3812604966501835e-05 0.00068763160407692863
+ 3.3812613545968467e-05 0.00077295453496090106
+ 3.3812622125435099e-05 0.00085985181282763258
+ 3.3812630704901731e-05 0.00094803308914625053
+ 3.3812639284368363e-05 0.0010372505228311898
+ 3.3812647863834995e-05 0.0011272921245865509
+ 3.3812658180770249e-05 0.0012364048498757886
+ 3.3812668497705509e-05 0.0013461799437633384
+ 3.3812678814640763e-05 0.0014563930288477433
+ 3.3812689131576017e-05 0.001566855276772596
+ 3.381269944851127e-05 0.0016774068636345029
+ 3.3812709765446524e-05 0.001787911643031166
+ 3.3812720082381784e-05 0.0018982528107135616
+ 3.3812730399317038e-05 0.0020083293767566338
+ 3.3812742902012261e-05 0.002141246780886198
+ 3.3812755404707476e-05 0.0022735106700283729
+ 3.3812767907402699e-05 0.0024050029041599369
+ 3.3812780410097914e-05 0.0025356196305195535
+ 3.3812792912793137e-05 0.0026652683340791378
+ 3.3812805415488353e-05 0.002793865545581445
+ 3.3812817918183575e-05 0.0029213350620943554
+ 3.3812830420878797e-05 0.0030476065669750823
+ 3.3812845592253872e-05 0.0031991277392290247
+ 3.3812860763628954e-05 0.0033486794005026179
+ 3.3812875935004035e-05 0.0034961593179601309
+ 3.381289110637911e-05 0.0036414711081661105
+ 3.3812906277754191e-05 0.0037845233735065873
+ 3.3812921449129273e-05 0.0039252290818992874
+ 3.3812936620504354e-05 0.0040635051254073566
+ 3.3812954860519559e-05 0.0042264209820281088
+ 3.381297310053477e-05 0.0043855785109888799
+ 3.3812991340549974e-05 0.004540852807539594
+ 3.3813009580565179e-05 0.0046921255232483241
+ 3.381302782058039e-05 0.004839284756390172
+ 3.3813046060595594e-05 0.0049822250059800644
+ 3.3813068199865842e-05 0.0051499118748984281
+ 3.3813090339136098e-05 0.0053110729761570875
+ 3.3813112478406346e-05 0.0054655577982168782
+ 3.3813134617676594e-05 0.0056132299331846198
+ 3.3813161293011319e-05 0.0057819364493443522
+ 3.3813187873095807e-05 0.0059398423573548687
+ 3.3813214453180294e-05 0.0060874136176253622
+ 3.3813248688484339e-05 0.0062620603819550135
+ 3.3813282923788384e-05 0.0064191641307141745
+ 3.3813315356127045e-05 0.0065517091134031152
+ 3.3813347788465714e-05 0.0066683776453289999
+ 3.3813380220804375e-05 0.0067692021882621509
+ 3.3813412653143037e-05 0.0068542763543729904
+ 3.3813445085481705e-05 0.0069237529436825757
+ 3.3813477517820366e-05 0.0069778416850672731
+ 3.3813509950159028e-05 0.0070168067033145008
+ 3.3813542382497689e-05 0.0070409637367341727
+ 3.3813569584998148e-05 0.0070500711051410814
+ 3.38135967874986e-05 0.0070492564131712353
+ 3.3813623989999051e-05 0.0070387804986578604
+ 3.381365119249951e-05 0.0070189238317284377
+ 3.3813678394999962e-05 0.0069899850256677273
+ 3.3813705597500414e-05 0.0069522793135452206
+ 3.3813732800000866e-05 0.0069061369988542495
+ 3.3813760002501317e-05 0.0068519018883273245
+ 3.3813787205001776e-05 0.0067899297149596706
+ 3.3813814407502228e-05 0.0067205865590935169
+ 3.381384161000268e-05 0.0066442472751925379
+ 3.3813868812503138e-05 0.006561293931672073
+ 3.381389601500359e-05 0.0064721142708494637
+ 3.3813923217504042e-05 0.0063771001957435066
+ 3.3813950420004494e-05 0.0062766462900859356
+ 3.3813977622504946e-05 0.0061711483775146155
+ 3.3814004825005404e-05 0.0060610021255013743
+ 3.3814032027505856e-05 0.0059466016991306979
+ 3.3814059230006308e-05 0.0058283384693926773
+ 3.3814086432506767e-05 0.0057065997804302861
+ 3.3814115300883497e-05 0.0055740309990659331
+ 3.3814144169260235e-05 0.0054384272991202893
+ 3.3814173037636965e-05 0.0053002282345430132
+ 3.3814201906013703e-05 0.0051598626838551204
+ 3.381423077439044e-05 0.0050177476630414884
+ 3.3814259642767171e-05 0.0048742872442221231
+ 3.3814288511143909e-05 0.0047298715812966012
+ 3.3814317379520639e-05 0.0045848760430473451
+ 3.3814346247897377e-05 0.0044396604535071188
+ 3.3814381135166679e-05 0.0042643637747592994
+ 3.3814416022435988e-05 0.0040898203879790361
+ 3.3814449985506049e-05 0.0039211359224094145
+ 3.3814483948576111e-05 0.0037541355090310092
+ 3.3814517911646178e-05 0.0035892460195200843
+ 3.381455187471624e-05 0.0034268598627977894
+ 3.3814585837786301e-05 0.0032673350066711841
+ 3.381462738108282e-05 0.0030765664536155394
+ 3.3814668924379333e-05 0.0028910852643209248
+ 3.3814710467675846e-05 0.0027113416169293153
+ 3.3814752010972365e-05 0.0025377141992044784
+ 3.3814802322523101e-05 0.0023360685105670866
+ 3.3814853125173633e-05 0.0021424443576868821
+ 3.3814903927824171e-05 0.001959156496722657
+ 3.3814971607266246e-05 0.0017313192252947558
+ 3.3815039286708321e-05 0.0015222190408349249
+ 3.3815091919396567e-05 0.001372431253814393
+ 3.3815144552084814e-05 0.0012336381966261724
+ 3.3815197184773054e-05 0.0011055447342070166
+ 3.3815249817461301e-05 0.00098778684645394604
+ 3.3815297809929102e-05 0.00088906516794052203
+ 3.3815345802396904e-05 0.00079823747715313789
+ 3.3815393794864705e-05 0.00071492972227882204
+ 3.3815441787332514e-05 0.00063875107498295779
+ 3.3815489779800315e-05 0.00056929990178360005
+ 3.3815537261554866e-05 0.00050680910974394439
+ 3.3815584743309411e-05 0.00045011010916966049
+ 3.3815632225063962e-05 0.00039881145821643485
+ 3.3815679706818513e-05 0.00035252854906615789
+ 3.3815727188573057e-05 0.00031088653907439246
+ 3.3815774670327608e-05 0.0002735227890958723
+ 3.3815824358583363e-05 0.00023862511600889196
+ 3.3815874046839124e-05 0.00020765025205703798
+ 3.3815923735094879e-05 0.00018023763188315632
+ 3.3815973423350634e-05 0.00015604795426756195
+ 3.3816023111606395e-05 0.0001347637411803884
+ 3.381607279986215e-05 0.00011608953467670693
+ 3.3816127951386075e-05 9.8086983151495662e-05
+ 3.381618310291e-05 8.2620379659707852e-05
+ 3.3816238254433926e-05 6.937830638173144e-05
+ 3.3816293405957851e-05 5.8079646203919961e-05
+ 3.3816348557481776e-05 4.8471998343402797e-05
+ 3.3816411640520542e-05 3.9267448447275403e-05
+ 3.3816474723559301e-05 3.1683839518460041e-05
+ 3.3816537806598059e-05 2.5463033689023789e-05
+ 3.3816600889636818e-05 2.0382309617297274e-05
+ 3.3816674140146426e-05 1.5662206653736814e-05
+ 3.3816747390656033e-05 1.1971024407425274e-05
+ 3.3816820641165648e-05 9.101093726216712e-06
+ 3.3816905619421586e-05 6.5781195004269459e-06
+ 3.3816990597677524e-05 4.7207090840830405e-06
+ 3.3817093836844787e-05 3.1245246960755978e-06
+ 3.3817198171769411e-05 2.0371887602864823e-06
+ 3.3817302506694043e-05 1.3141391771344707e-06
+ 3.3817426664469162e-05 7.6923430377838728e-07
+ 3.3817550822244287e-05 4.435788450454647e-07
+ 3.3817705800806531e-05 2.1851475951109054e-07
+ 3.3817884937131784e-05 9.3708673373505121e-08
+ 3.3818098556602387e-05 3.2883700516734768e-08
+ 3.3818364485722956e-05 8.5309004428172277e-09
+ 3.3818717982712204e-05 1.4552417250701691e-09
+ 3.3819242097564146e-05 3.0578689270965244e-10
+ 3.3820136340120473e-05 2.4569663308855879e-10
+ 3.3822132807185038e-05 2.4259754686171839e-10
+ 3.3823988816858016e-05 2.4182034068072913e-10
+ 3.382642166844308e-05 2.4138174969930913e-10
+ 3.3828854520028144e-05 2.4076582964276258e-10
+ 3.3831287371613209e-05 2.4012576594620444e-10
+ 3.3833720223198273e-05 2.4057963384973803e-10
+ 3.3836153074783331e-05 2.4092919901400983e-10
+ 3.3838585926368395e-05 2.401872610697499e-10
+ 3.3841018777953459e-05 2.3987554496708928e-10
+ 3.3843451629538523e-05 2.4037942571475707e-10
+ 3.3845767705239778e-05 2.4025247901632375e-10
+ 3.3848819440406716e-05 2.4017887589128354e-10
+ 3.3851871175573654e-05 2.4009951114703349e-10
+ 3.3854922910740599e-05 2.4004351142745323e-10
+ 3.3857974645907538e-05 2.4016098617015712e-10
+ 3.3861026381074476e-05 2.4071442426522539e-10
+ 3.3864078116241414e-05 2.3968616681674537e-10
+ 3.3867773618773601e-05 2.4003007462135484e-10
+ 3.3871134288610906e-05 2.4006402385879101e-10
+ 3.3874494958448218e-05 2.4006047129867007e-10
+ 3.3878620731690281e-05 2.4005210497337081e-10
+ 3.3882746504932338e-05 2.4004042399080182e-10
+ 3.3886872278174394e-05 2.4003044384477591e-10
+ 3.3890998051416458e-05 2.4003749578386358e-10
+ 3.3895123824658514e-05 2.4008180521387353e-10
+ 3.3900251138437097e-05 2.4016443526047099e-10
+ 3.390537845221568e-05 2.3985136550844345e-10
+ 3.3910505765994263e-05 2.3994252727381691e-10
+ 3.3915633079772846e-05 2.4004700010028028e-10
+ 3.3921995979825153e-05 2.4004483697536087e-10
+ 3.392835887987746e-05 2.3997024527683999e-10
+ 3.3934721779929767e-05 2.3997592655072043e-10
+ 3.3942497256254511e-05 2.4000749931504923e-10
+ 3.3950272732579249e-05 2.4001269631983051e-10
+ 3.3958048208903994e-05 2.3999782508278659e-10
+ 3.396798344193607e-05 2.3999355892689472e-10
+ 3.3977918674968139e-05 2.4000179472492324e-10
+ 3.3990125706218145e-05 2.4000339716614338e-10
+ 3.4002332737468143e-05 2.3999888202599127e-10
+ 3.4014539768718142e-05 2.3999830525938688e-10
+ 3.4026746799968141e-05 2.4000037974237526e-10
+ 3.4038953831218139e-05 2.4000087414852165e-10
+ 3.4051160862468145e-05 2.3999993966201389e-10
+ 3.4063367893718143e-05 2.3999960494882817e-10
+ 3.4075574924968142e-05 2.4000001432309894e-10
+ 3.4087781956218141e-05 2.4000021737723387e-10
+ 3.4099988987468139e-05 2.4000004462513988e-10
+ 3.4112196018718145e-05 2.3999993006727966e-10
+ 3.4124403049968144e-05 2.3999999917748096e-10
+ 3.4136610081218142e-05 2.4000006049017395e-10
+ 3.4148817112468141e-05 2.4000003421757239e-10
+ 3.416102414371814e-05 2.4000000237870328e-10
+ 3.4173231174968138e-05 2.4000001256652595e-10
+ 3.4185438206218144e-05 2.4000002745854788e-10
+ 3.4197645237468142e-05 2.4000002475271839e-10
+ 3.4209852268718141e-05 2.4000001795384735e-10
+ 3.422205929996814e-05 2.400000173879749e-10
+ 3.4234266331218138e-05 2.4000002070407596e-10
+ 3.4246473362468144e-05 2.4000002067419452e-10
+ 3.4258680393718142e-05 2.4000001976473751e-10
+ 3.4270887424968141e-05 2.40000019362722e-10
+ 3.428309445621814e-05 2.4000002028128461e-10
+ 3.4295301487468138e-05 2.4000002060646208e-10
+ 3.4307508518718137e-05 2.4000002008287723e-10
+ 3.4319715549968142e-05 2.4000001934276911e-10
+ 3.4331922581218141e-05 2.4000001968966948e-10
+ 3.434412961246814e-05 2.4000002093381111e-10
+ 3.4356336643718138e-05 2.4000001965726013e-10
+ 3.4368543674968137e-05 2.4000001961507071e-10
+ 3.4380750706218142e-05 2.4000002048512451e-10
+ 3.4392957737468141e-05 2.4000001998121006e-10
+ 3.440516476871814e-05 2.400000199764228e-10
+ 3.4417371799968138e-05 2.4000001998665694e-10
+ 3.4429578831218137e-05 2.4000001988395378e-10
+ 3.4441785862468142e-05 2.4000001969840786e-10
+ 3.4453992893718141e-05 2.4000001962628526e-10
+ 3.446619992496814e-05 2.4000001985975601e-10
+ 3.4478406956218138e-05 2.4000001994562599e-10
+ 3.4490613987468137e-05 2.4000001873790616e-10
+ 3.4502821018718143e-05 2.400000206888198e-10
+ 3.4515028049968141e-05 2.4000002115772409e-10
+ 3.452723508121814e-05 2.4000001926167516e-10
+ 3.4539442112468138e-05 2.4000001865095655e-10
+ 3.4551649143718137e-05 2.4000002024868279e-10
+ 3.4563856174968136e-05 2.4000002062807212e-10
+ 3.4576063206218141e-05 2.4000001971246058e-10
+ 3.458827023746814e-05 2.4000001913611468e-10
+ 3.4600477268718139e-05 2.4000001939609548e-10
+ 3.4612684299968137e-05 2.4000001928925776e-10
+ 3.4624891331218136e-05 2.4000002036211893e-10
+ 3.4637098362468141e-05 2.4000001948566678e-10
+ 3.464930539371814e-05 2.40000020557049e-10
+ 3.4661512424968139e-05 2.400000203491446e-10
+ 3.4673719456218137e-05 2.4000001961720044e-10
+ 3.4685926487468136e-05 2.400000200808237e-10
+ 3.4698133518718135e-05 2.4000002006495584e-10
+ 3.471034054996814e-05 2.4000001941755901e-10
+ 3.4722547581218139e-05 2.4000001925514504e-10
+ 3.4734754612468137e-05 2.4000001949494439e-10
+ 3.4746961643718136e-05 2.4000001987457185e-10
+ 3.4759168674968135e-05 2.4000001956535886e-10
+ 3.477137570621814e-05 2.4000001976899341e-10
+ 3.4783582737468139e-05 2.4000001989767335e-10
+ 3.4795789768718137e-05 2.4000002010421042e-10
+ 3.4807996799968136e-05 2.4000002031692612e-10
+ 3.4820203831218135e-05 2.4000001943796074e-10
+ 3.483241086246814e-05 2.4000001979057998e-10
+ 3.4844617893718139e-05 2.4000001994141042e-10
+ 3.4856824924968137e-05 2.4000001910787902e-10
+ 3.4869031956218136e-05 2.4000002014157438e-10
+ 3.4881238987468135e-05 2.4000002007976212e-10
+ 3.489344601871814e-05 2.4000001897875313e-10
+ 3.4905653049968139e-05 2.4000002030066949e-10
+ 3.4917860081218137e-05 2.4000002070432142e-10
+ 3.4930067112468136e-05 2.4000001950520541e-10
+ 3.4942274143718135e-05 2.4000001947980057e-10
+ 3.4954481174968133e-05 2.4000002027253361e-10
+ 3.4966688206218139e-05 2.40000020609859e-10
+ 3.4978895237468138e-05 2.4000001911322354e-10
+ 3.4991102268718136e-05 2.4000001969739074e-10
+ 3.5003309299968135e-05 2.4000002073053612e-10
+ 3.5015516331218133e-05 2.4000001994814067e-10
+ 3.5027723362468139e-05 2.4000001923239209e-10
+ 3.5039930393718138e-05 2.4000002015288261e-10
+ 3.5052137424968136e-05 2.4000001930210656e-10
+ 3.5064344456218135e-05 2.4000001837686493e-10
+ 3.5076551487468134e-05 2.4000001946449939e-10
+ 3.5088758518718139e-05 2.4000002038326192e-10
+ 3.5100965549968138e-05 2.400000203109469e-10
+ 3.5113172581218136e-05 2.400000203952259e-10
+ 3.5125379612468135e-05 2.4000001970496741e-10
+ 3.513758664371814e-05 2.4000001924454606e-10
+ 3.5149793674968139e-05 2.4000001905466872e-10
+ 3.5162000706218138e-05 2.400000204518705e-10
+ 3.5174207737468136e-05 2.4000002011557764e-10
+ 3.5186414768718142e-05 2.4000001946831419e-10
+ 3.519862179996814e-05 2.4000001925940771e-10
+ 3.5210828831218139e-05 2.4000001980987061e-10
+ 3.5223035862468138e-05 2.4000002089319245e-10
+ 3.5235242893718143e-05 2.4000001973823067e-10
+ 3.5247449924968142e-05 2.4000001879346328e-10
+ 3.525965695621814e-05 2.4000001869932423e-10
+ 3.5271863987468139e-05 2.4000002074828773e-10
+ 3.5284071018718145e-05 2.4000001934026167e-10
+ 3.5296278049968143e-05 2.4000001952115826e-10
+ 3.5308485081218142e-05 2.4000001987859593e-10
+ 3.5320692112468141e-05 2.400000198982881e-10
+ 3.5332899143718146e-05 2.40000018977687e-10
+ 3.5345106174968145e-05 2.4000001970468766e-10
+ 3.5357313206218143e-05 2.4000001969944985e-10
+ 3.5369520237468142e-05 2.4000002027367879e-10
+ 3.5381727268718147e-05 2.4000001840031488e-10
+ 3.5393934299968146e-05 2.4000001957318321e-10
+ 3.5406141331218145e-05 2.400000188108562e-10
+ 3.5418348362468143e-05 2.4000002046679305e-10
+ 3.5430555393718149e-05 2.4000001950571268e-10
+ 3.5442762424968147e-05 2.4000001838116472e-10
+ 3.5454969456218146e-05 2.4000001853089837e-10
+ 3.5467176487468145e-05 2.4000002004811227e-10
+ 3.547938351871815e-05 2.4000001966057371e-10
+ 3.5491590549968149e-05 2.4000001941089245e-10
+ 3.5503797581218147e-05 2.4000001913185568e-10
+ 3.5516004612468146e-05 2.4000001954838558e-10
+ 3.5528211643718152e-05 2.4000001920964592e-10
+ 3.554041867496815e-05 2.4000001943469307e-10
+ 3.5552625706218149e-05 2.4000001866641258e-10
+ 3.5564832737468148e-05 2.4000002020897109e-10
+ 3.5577039768718153e-05 2.4000001940179987e-10
+ 3.5589246799968152e-05 2.4000001993507329e-10
+ 3.560145383121815e-05 2.4000002008198123e-10
+ 3.5613660862468149e-05 2.400000198005213e-10
+ 3.5625867893718154e-05 2.4000001916301211e-10
+ 3.5638074924968153e-05 2.4000001960280073e-10
+ 3.5650281956218152e-05 2.4000001963117276e-10
+ 3.566248898746815e-05 2.400000196254434e-10
+ 3.5674696018718156e-05 2.4000002030623543e-10
+ 3.5686903049968154e-05 2.4000001985486468e-10
+ 3.5699110081218153e-05 2.4000001975560508e-10
+ 3.5711317112468152e-05 2.4000002002563028e-10
+ 3.5723524143718157e-05 2.4000001880683233e-10
+ 3.5735731174968156e-05 2.400000186107882e-10
+ 3.5747938206218154e-05 2.4000002026174485e-10
+ 3.5760145237468153e-05 2.4000001964579944e-10
+ 3.5772352268718159e-05 2.4000001869414737e-10
+ 3.5784559299968157e-05 2.4000002024855297e-10
+ 3.5796766331218156e-05 2.4000001886895933e-10
+ 3.5808973362468155e-05 2.4000001996539064e-10
+ 3.582118039371816e-05 2.4000001852201533e-10
+ 3.5833387424968159e-05 2.4000001995376353e-10
+ 3.5845594456218157e-05 2.4000001885033681e-10
+ 3.5857801487468156e-05 2.400000202275795e-10
+ 3.5870008518718161e-05 2.4000001938682899e-10
+ 3.588221554996816e-05 2.400000185286626e-10
+ 3.5894422581218159e-05 2.4000002021567022e-10
+ 3.5906629612468157e-05 2.4000001929093104e-10
+ 3.5918836643718163e-05 2.4000001945502139e-10
+ 3.5931043674968161e-05 2.4000001849176264e-10
+ 3.594325070621816e-05 2.4000001899160695e-10
+ 3.5955457737468159e-05 2.4000001908469775e-10
+ 3.5967664768718164e-05 2.4000002021320925e-10
+ 3.5979871799968163e-05 2.4000001986077044e-10
+ 3.5992078831218161e-05 2.4000001985660228e-10
+ 3.600428586246816e-05 2.4000001982734366e-10
+ 3.6016492893718166e-05 2.4000001909394165e-10
+ 3.6028699924968164e-05 2.4000001971428865e-10
+ 3.6040906956218163e-05 2.4000001921042243e-10
+ 3.6053113987468162e-05 2.400000190589926e-10
+ 3.6065321018718167e-05 2.400000192770844e-10
+ 3.6077528049968166e-05 2.4000001876027354e-10
+ 3.6089735081218164e-05 2.4000001963225885e-10
+ 3.6101942112468163e-05 2.4000001898595255e-10
+ 3.6114149143718168e-05 2.4000001876650681e-10
+ 3.6126356174968167e-05 2.4000001955479303e-10
+ 3.6138563206218166e-05 2.400000192149284e-10
+ 3.6150770237468164e-05 2.4000001962818762e-10
+ 3.616297726871817e-05 2.400000192259498e-10
+ 3.6175184299968168e-05 2.4000001958046752e-10
+ 3.6187391331218167e-05 2.4000001876653049e-10
+ 3.6199598362468166e-05 2.4000001901679062e-10
+ 3.6211805393718171e-05 2.4000001929188411e-10
+ 3.622401242496817e-05 2.4000001878460593e-10
+ 3.6236219456218168e-05 2.4000001895149019e-10
+ 3.6248426487468167e-05 2.4000001953324466e-10
+ 3.6260633518718173e-05 2.4000001930179932e-10
+ 3.6272840549968171e-05 2.4000001867284628e-10
+ 3.628504758121817e-05 2.4000001876404646e-10
+ 3.6297254612468169e-05 2.4000001844012502e-10
+ 3.6309461643718174e-05 2.4000001847700822e-10
+ 3.6321668674968173e-05 2.4000001848915366e-10
+ 3.6333875706218171e-05 2.4000001847211049e-10
+ 3.634608273746817e-05 2.4000001842583542e-10
+ 3.6358289768718175e-05 2.4000001874485954e-10
+ 3.6370496799968174e-05 2.4000001864470591e-10
+ 3.6382703831218173e-05 2.400000192645186e-10
+ 3.6394910862468171e-05 2.4000001911011029e-10
+ 3.6407117893718177e-05 2.400000189594016e-10
+ 3.6419324924968175e-05 2.4000001834385696e-10
+ 3.6431531956218174e-05 2.4000001923683012e-10
+ 3.6443738987468173e-05 2.4000002008098464e-10
+ 3.6455946018718178e-05 2.400000183211859e-10
+ 3.6468153049968177e-05 2.4000001983070817e-10
+ 3.6480360081218175e-05 2.4000001841550595e-10
+ 3.6492567112468174e-05 2.4000001987140726e-10
+ 3.650477414371818e-05 2.4000001839799459e-10
+ 3.6516981174968178e-05 2.4000001979564812e-10
+ 3.6529188206218177e-05 2.4000001826400317e-10
+ 3.6541395237468176e-05 2.3996544537098469e-10
+ 3.6553602268718181e-05 2.3996256464191007e-10
+ 3.656580929996818e-05 2.3996062147298765e-10
+ 3.6578016331218178e-05 2.399538992151035e-10
+ 3.6590223362468177e-05 2.3990864356794482e-10
+ 3.6602430393718182e-05 2.3980391697569448e-10
+ 3.6614637424968181e-05 2.3960325885649169e-10
+ 3.662074094059318e-05 2.3930636780140344e-10
+ 3.662684445621818e-05 2.3825018349924986e-10
+ 3.6629896214030679e-05 2.3664385617022961e-10
+ 3.6632947971843179e-05 2.313460144418538e-10
+ 3.6634473850749432e-05 2.2273712950258841e-10
+ 3.6635999729655679e-05 1.9502932447418286e-10
+ 3.6636991106889185e-05 1.3263414891107653e-10
+ 3.6637269733896245e-05 9.5672269136980181e-11
+ 3.6637548360903298e-05 4.6113023016783446e-11
+ 3.6638098835627972e-05 4.077304569289076e-11
+ 3.6640875273912432e-05 4.2347131994264368e-11
+ 3.6653082305162437e-05 4.4733371018365243e-11
+ 3.6665289336412436e-05 5.3058719093237963e-11
+ 3.6677496367662435e-05 6.5249849962529414e-11
+ 3.668970339891244e-05 8.0586557341896391e-11
+ 3.6701910430162439e-05 9.8186059694000248e-11
+ 3.6714117461412438e-05 1.1703587328666208e-10
+ 3.6726324492662436e-05 1.3605185310399104e-10
+ 3.6738531523912435e-05 1.5414054504639482e-10
+ 3.675073855516244e-05 1.7026206156240515e-10
+ 3.6762945586412439e-05 1.8348986297121229e-10
+ 3.6775152617662438e-05 1.9306400774952091e-10
+ 3.6787359648912443e-05 1.9843481134517081e-10
+ 3.6799566680162442e-05 1.9929440536940058e-10
+ 3.681177371141244e-05 1.9559438520732841e-10
+ 3.6823980742662439e-05 1.8754853451668201e-10
+ 3.6836187773912438e-05 1.7562047328816539e-10
+ 3.6848394805162443e-05 1.6049694315998822e-10
+ 3.6860601836412442e-05 1.4304826930135124e-10
+ 3.687280886766244e-05 1.2427827523140709e-10
+ 3.6885015898912446e-05 1.052665328361379e-10
+ 3.6897222930162444e-05 8.7106269937226752e-11
+ 3.6909429961412443e-05 7.0841506734532094e-11
+ 3.6921636992662442e-05 5.7407035899497847e-11
+ 3.693384402391244e-05 4.7574696846103914e-11
+ 3.6936895781724947e-05 4.5750674856066197e-11
+ 3.6937048369615566e-05 4.5666462612461995e-11
+ 3.6937429839342128e-05 4.5458870923120094e-11
+ 3.6937467986314789e-05 4.5438342991126504e-11
+ 3.6937475615709322e-05 4.5434242455099145e-11
+ 3.6937490874498379e-05 4.5426046434154427e-11
+ 3.6937496978014008e-05 4.5422769911655126e-11
+ 3.6937499419420257e-05 4.542145960441293e-11
+ 3.6937499604455783e-05 4.5421360302533612e-11
+ 3.6937499974526843e-05 4.5421161701746532e-11
+ 3.6937500714668948e-05 5.7234708751505077e-08
+ 3.6937501454811054e-05 2.3609835104101694e-07
+ 3.693750885623215e-05 8.3378657603255145e-06
+ 3.6937516257653233e-05 2.6804211983519737e-05
+ 3.693752365907433e-05 5.4212572160978158e-05
+ 3.6937531060495413e-05 8.9333429400249197e-05
+ 3.693753846191651e-05 0.00013110387761772142
+ 3.6937547512355686e-05 0.00018988604042548046
+ 3.693755656279487e-05 0.000255812068272275
+ 3.6937565613234047e-05 0.00032768193023753725
+ 3.6937574663673231e-05 0.00040448949601993325
+ 3.6937583714112414e-05 0.00048539058840956265
+ 3.6937595044533513e-05 0.00059137048504824714
+ 3.6937606374954611e-05 0.00070151686849491022
+ 3.6937617705375709e-05 0.0008149054011463608
+ 3.6937629035796808e-05 0.00093078918228233572
+ 3.6937643214653363e-05 0.0010784080416500865
+ 3.6937657393509918e-05 0.0012280520970111633
+ 3.6937671572366472e-05 0.0013789889014004875
+ 3.6937689032396937e-05 0.0015657925325384681
+ 3.6937706492427402e-05 0.0017528666320927736
+ 3.6937723952457859e-05 0.0019395804048633696
+ 3.6937746268477829e-05 0.0021769293571718938
+ 3.6937768584497799e-05 0.0024120996791847497
+ 3.6937790900517769e-05 0.0026444704336099976
+ 3.6937819090217238e-05 0.0029332237971511233
+ 3.6937847279916707e-05 0.0032158629328255771
+ 3.6937875469616183e-05 0.0034916668520790159
+ 3.6937903659315653e-05 0.0037599988278231356
+ 3.6937931849015122e-05 0.0040202830355208904
+ 3.6937960038714591e-05 0.0042719918874605982
+ 3.6937988228414061e-05 0.0045146394015623476
+ 3.6938019414106476e-05 0.0047719795450323309
+ 3.6938050599798885e-05 0.0050171295125712645
+ 3.6938081785491293e-05 0.0052495906087394869
+ 3.6938112971183709e-05 0.0054689190353913904
+ 3.6938150418414335e-05 0.0057143885297757718
+ 3.6938187865644967e-05 0.0059397992525804574
+ 3.6938225312875593e-05 0.006144702220679193
+ 3.693827084419581e-05 0.0063657430322260553
+ 3.693831637551602e-05 0.0065556175023236875
+ 3.6938361906836237e-05 0.0067142112673811444
+ 3.6938407438156446e-05 0.0068416534980290083
+ 3.6938441084028112e-05 0.0069160175765833089
+ 3.6938474729899777e-05 0.0069737900261410465
+ 3.6938508375771443e-05 0.0070152594941248576
+ 3.6938542021643108e-05 0.0070407746969006688
+ 3.6938575667514774e-05 0.007050740823760393
+ 3.6938609313386439e-05 0.0070456156939712805
+ 3.6938642959258105e-05 0.007025905702338452
+ 3.693867660512977e-05 0.0069921615895264296
+ 3.6938710251001436e-05 0.0069449740739896257
+ 3.6938736870668146e-05 0.006898526876910809
+ 3.6938763490334856e-05 0.0068443802044164921
+ 3.6938790110001566e-05 0.0067828688534493494
+ 3.6938816729668275e-05 0.0067143369242957376
+ 3.6938843349334992e-05 0.0066391364097472113
+ 3.6938869969001702e-05 0.0065576257964309343
+ 3.6938896588668412e-05 0.0064701686843428533
+ 3.6938923208335122e-05 0.0063771324303375145
+ 3.6938949828001832e-05 0.0062788868210215225
+ 3.6938976447668542e-05 0.0061758027801676225
+ 3.6939003067335252e-05 0.0060682511154162089
+ 3.6939029687001968e-05 0.0059566013086644297
+ 3.6939056306668678e-05 0.0058412203541628417
+ 3.6939082926335388e-05 0.0057224716479485063
+ 3.6939109546002098e-05 0.0056007139318451742
+ 3.6939136165668808e-05 0.0054763002948580381
+ 3.6939162785335518e-05 0.0053495772343856614
+ 3.6939189405002228e-05 0.0052208837792675896
+ 3.6939216024668937e-05 0.0050905506764474901
+ 3.6939239404935227e-05 0.0049749804171373225
+ 3.6939262785201517e-05 0.0048586054363550972
+ 3.6939286165467807e-05 0.0047416314482211135
+ 3.693930954573409e-05 0.0046242577652878883
+ 3.693933292600038e-05 0.0045066770343838705
+ 3.693935630626667e-05 0.0043890750025309139
+ 3.693937968653296e-05 0.0042716303126259531
+ 3.6939403066799243e-05 0.0041545143284691553
+ 3.6939426447065533e-05 0.0040378909886185305
+ 3.6939449827331823e-05 0.0039219166884552218
+ 3.6939473207598113e-05 0.0038067401897542695
+ 3.6939496587864396e-05 0.0036925025569730643
+ 3.6939519968130686e-05 0.0035793371193940525
+ 3.6939543348396976e-05 0.0034673694581895016
+ 3.6939566728663266e-05 0.0033567174174145066
+ 3.6939590108929549e-05 0.0032474911378798247
+ 3.6939613489195839e-05 0.0031397931128086067
+ 3.6939636869462129e-05 0.0030337182641405314
+ 3.6939660249728419e-05 0.0029293540383132049
+ 3.6939683629994702e-05 0.0028267805203238136
+ 3.6939707010260992e-05 0.0027260705648536779
+ 3.6939735591237519e-05 0.0026055855381113117
+ 3.6939764172214039e-05 0.0024880893416989024
+ 3.6939792753190567e-05 0.0023736731389782805
+ 3.6939821334167087e-05 0.0022624136400195647
+ 3.6939849915143614e-05 0.0021543736566158275
+ 3.6939886199806212e-05 0.0020219271947776738
+ 3.6939925453373379e-05 0.0018846580284455387
+ 3.6939946977215265e-05 0.0018120618774395494
+ 3.6939973696714701e-05 0.0017245821083065652
+ 3.6940000416214137e-05 0.0016400258203643724
+ 3.6940027135713573e-05 0.0015583844444338579
+ 3.6940053855213009e-05 0.0014796423351417674
+ 3.6940080574712445e-05 0.0014037772468436488
+ 3.6940107294211881e-05 0.0013307608065583204
+ 3.6940134013711317e-05 0.0012605589819463642
+ 3.6940160733210753e-05 0.0011931325425094006
+ 3.6940187452710189e-05 0.0011284375123336611
+ 3.6940214172209626e-05 0.0010664256128491564
+ 3.6940240891709062e-05 0.0010070446942234952
+ 3.6940262548859615e-05 0.00096080661895637035
+ 3.6940284206010162e-05 0.0009162294538821239
+ 3.6940305863160715e-05 0.00087328092606094238
+ 3.6940327520311269e-05 0.00083192771752318962
+ 3.6940349177461815e-05 0.00079213559354230647
+ 3.6940370834612369e-05 0.00075386952625768001
+ 3.6940392491762922e-05 0.00071709381353394315
+ 3.6940414148913476e-05 0.00068177219296354193
+ 3.6940435806064029e-05 0.00064786795094112185
+ 3.6940457463214576e-05 0.00061534402675914772
+ 3.6940479120365129e-05 0.00058416311167918647
+ 3.6940496765399604e-05 0.00055972551886932095
+ 3.6940514410434078e-05 0.00053613426244406741
+ 3.6940532055468553e-05 0.00051336904748169171
+ 3.6940549700503021e-05 0.00049140960981622914
+ 3.6940567345537495e-05 0.00047023574348777509
+ 3.694058499057197e-05 0.00044982732676715286
+ 3.6940602635606445e-05 0.00043016434677204047
+ 3.6940620280640919e-05 0.00041122692269401575
+ 3.6940637925675394e-05 0.00039299532765819798
+ 3.6940655570709868e-05 0.00037545000923921415
+ 3.6940673215744343e-05 0.00035857160865911174
+ 3.6940690860778818e-05 0.00034234097869457157
+ 3.6940708505813286e-05 0.00032673920032235228
+ 3.694072615084776e-05 0.00031174759813332067
+ 3.6940743795882235e-05 0.00029734775454669758
+ 3.6940761440916709e-05 0.00028352152285727745
+ 3.6940779085951184e-05 0.0002702510391493668
+ 3.6940796730985659e-05 0.00025751873311203796
+ 3.6940814376020133e-05 0.00024530733779101174
+ 3.6940832021054601e-05 0.00023359989831307307
+ 3.6940849666089076e-05 0.00022237977961939102
+ 3.694086731112355e-05 0.00021163067324446447
+ 3.6940884956158025e-05 0.00020133660317765155
+ 3.6940902601192499e-05 0.00019148193084437179
+ 3.6940920246226974e-05 0.00018205135924409671
+ 3.6940937891261449e-05 0.00017302993628217709
+ 3.6940955536295923e-05 0.00016440305733239472
+ 3.6940973181330398e-05 0.00015615646706688136
+ 3.6940990826364866e-05 0.00014827626058972067
+ 3.694100847139934e-05 0.00014074888391014853
+ 3.6941026116433815e-05 0.00013356113379079491
+ 3.694104376146829e-05 0.00012670015700587552
+ 3.6941061406502764e-05 0.00012015344904364461
+ 3.6941079051537239e-05 0.00011390885228677083
+ 3.6941096696571713e-05 0.00010795455370359766
+ 3.6941114341606181e-05 0.00010227908208250491
+ 3.6941131986640656e-05 9.687130484080241e-05
+ 3.6941149631675131e-05 9.1720424438765868e-05
+ 3.6941167276709605e-05 8.6815974428572379e-05
+ 3.694118492174408e-05 8.2147815167013072e-05
+ 3.6941202566778554e-05 7.7706129219957601e-05
+ 3.6941220211813029e-05 7.3481416485622882e-05
+ 3.6941237856847504e-05 6.9464489062760908e-05
+ 3.6941255501881978e-05 6.5646465888930612e-05
+ 3.6941273146916446e-05 6.2018767173060703e-05
+ 3.6941290791950921e-05 5.8573108645546759e-05
+ 3.6941308436985395e-05 5.5301495648160228e-05
+ 3.694132608201987e-05 5.2196217085081444e-05
+ 3.6941343727054345e-05 4.9249839255407143e-05
+ 3.6941361372088819e-05 4.6455199586526805e-05
+ 3.6941379017123294e-05 4.3805400286814076e-05
+ 3.6941396662157762e-05 4.1293801935142287e-05
+ 3.6941414307192236e-05 3.8914017023807698e-05
+ 3.6941431952226711e-05 3.6659903470533496e-05
+ 3.6941449597261185e-05 3.4525558114332587e-05
+ 3.694146724229566e-05 3.2505310209129923e-05
+ 3.6941484887330135e-05 3.0593714928186798e-05
+ 3.6941502532364609e-05 2.878554689153125e-05
+ 3.6941520177399084e-05 2.7075793727781893e-05
+ 3.6941537822433559e-05 2.5459649680957857e-05
+ 3.6941555467468026e-05 2.3932509272096093e-05
+ 3.6941573112502501e-05 2.2489961024749567e-05
+ 3.6941590757536976e-05 2.1127781262716843e-05
+ 3.694160840257145e-05 1.9841927987655173e-05
+ 3.6941626047605925e-05 1.8628534843556469e-05
+ 3.6941643692640399e-05 1.7483905174418017e-05
+ 3.6941661337674874e-05 1.6404506180818473e-05
+ 3.6941682620107572e-05 1.5184596516820046e-05
+ 3.6941702745281676e-05 1.4108722156777394e-05
+ 3.6941722870455779e-05 1.3103783271809466e-05
+ 3.6941742995629883e-05 1.2165512099818384e-05
+ 3.6941763120803986e-05 1.1289867233639744e-05
+ 3.6941783245978089e-05 1.0473023791237365e-05
+ 3.6941803371152193e-05 9.711363860421274e-06
+ 3.6941823496326296e-05 9.0014672215583367e-06
+ 3.69418436215004e-05 8.3401023506671107e-06
+ 3.6941863746674496e-05 7.7242177042852387e-06
+ 3.6941888110746129e-05 7.0353574872189284e-06
+ 3.6941912474817755e-05 6.4041509733236313e-06
+ 3.6941936838889381e-05 5.8261375978047346e-06
+ 3.6941961202961007e-05 5.2971679183216326e-06
+ 3.6941985567032639e-05 4.8133849648221628e-06
+ 3.6942009931104265e-05 4.3712064413582404e-06
+ 3.6942034295175891e-05 3.9673077642003495e-06
+ 3.6942058659247517e-05 3.5986059186122073e-06
+ 3.6942083023319149e-05 3.2622441148827113e-06
+ 3.6942107387390775e-05 2.955577222710442e-06
+ 3.6942136719683568e-05 2.6223173518557521e-06
+ 3.6942166051976361e-05 2.3246430183300364e-06
+ 3.6942195384269161e-05 2.0589938235170389e-06
+ 3.6942224716561954e-05 1.8221375097881734e-06
+ 3.6942254048854747e-05 1.6111428978970881e-06
+ 3.6942283381147541e-05 1.4233547079677823e-06
+ 3.694231271344034e-05 1.2563701699769522e-06
+ 3.6942342045733134e-05 1.1080173307665688e-06
+ 3.6942377848029198e-05 9.4935328593955194e-07
+ 3.6942412335454626e-05 8.1703614317247063e-07
+ 3.694244682288006e-05 7.0231034037170861e-07
+ 3.6942481310305494e-05 6.0295931014601184e-07
+ 3.6942515797730929e-05 5.1702814794412422e-07
+ 3.6942557828321207e-05 4.2796498791424164e-07
+ 3.6942599858911485e-05 3.5358466304975593e-07
+ 3.694264188950177e-05 2.9157919961691281e-07
+ 3.6942683920092048e-05 2.3998333476715486e-07
+ 3.6942725950682326e-05 1.9712710629082681e-07
+ 3.6942777518503424e-05 1.5442331314774624e-07
+ 3.6942828186666483e-05 1.2110746118199679e-07
+ 3.6942878854829541e-05 9.4668212428266369e-08
+ 3.6942929522992593e-05 7.3741045625230226e-08
+ 3.6942993215143458e-05 5.3572482382509411e-08
+ 3.6943056907294322e-05 3.8650410566722333e-08
+ 3.6943120599445186e-05 2.7655607125139506e-08
+ 3.6943198945610713e-05 1.80624388894615e-08
+ 3.6943278657649691e-05 1.1455385675920075e-08
+ 3.6943358369688669e-05 7.0279116712338033e-09
+ 3.6943461292370765e-05 3.42722610432318e-09
+ 3.6943569508909821e-05 1.2415251844169095e-09
+ 3.6943701914804439e-05 -1.7423168879043324e-10
+ 3.6943847065030181e-05 -9.0046498724308251e-10
+ 3.6944034315235682e-05 -1.2675598336250834e-09
+ 3.6944255865010424e-05 -1.390661486095478e-09
+ 3.6944554034092506e-05 -1.4079464626524889e-09
+ 3.6944998769870889e-05 -1.3781166774969621e-09
+ 3.6945805003988991e-05 -1.313948994893242e-09
+ 3.6946711764368318e-05 -1.2450592154006523e-09
+ 3.6947737475686439e-05 -1.1711746826522686e-09
+ 3.6948801143402343e-05 -1.0985374417948889e-09
+ 3.6949944764949543e-05 -1.0244977902794022e-09
+ 3.6952231646278908e-05 -8.876839903243166e-10
+ 3.6954182681216656e-05 -7.8153991862173163e-10
+ 3.695629122851725e-05 -6.7660226349856925e-10
+ 3.6958581467436159e-05 -5.7299433820914436e-10
+ 3.6960926666850023e-05 -4.7698621811411996e-10
+ 3.6963271866263888e-05 -3.901690868650475e-10
+ 3.6965590537179632e-05 -3.1248869476676087e-10
+ 3.6968474569484278e-05 -2.2600941125466692e-10
+ 3.6971358601788931e-05 -1.4953972152878652e-10
+ 3.6974242634093578e-05 -8.1909642546355165e-11
+ 3.6977126666398224e-05 -2.2097231394821104e-11
+ 3.6980010698702878e-05 3.0804763949844941e-11
+ 3.6982894731007524e-05 7.7599184420572088e-11
+ 3.6985778763312178e-05 1.1899177680085989e-10
+ 3.6989342797663595e-05 1.6360497315690482e-10
+ 3.6992906832015012e-05 2.0194460469335925e-10
+ 3.6996470866366436e-05 2.3489304324568193e-10
+ 3.7000034900717853e-05 2.6320792465228799e-10
+ 3.700359893506927e-05 2.8754418863776942e-10
+ 3.7007899961127363e-05 3.124003450031708e-10
+ 3.7012200987185449e-05 3.3310188136055884e-10
+ 3.7016502013243542e-05 3.5034335018174361e-10
+ 3.7020803039301629e-05 3.6470346013268147e-10
+ 3.7025104065359715e-05 3.7666442373221598e-10
+ 3.7030502505986986e-05 3.8888313831481749e-10
+ 3.7035900946614249e-05 3.9859542479219459e-10
+ 3.7041299387241513e-05 4.0629545583254085e-10
+ 3.7046697827868783e-05 4.1242659596079512e-10
+ 3.7053468247657471e-05 4.1836450212166619e-10
+ 3.7060238667446159e-05 4.228142873871682e-10
+ 3.7067009087234846e-05 4.2614500842071573e-10
+ 3.7075385304343959e-05 4.2912633403108892e-10
+ 3.7083761521453071e-05 4.3120345772378355e-10
+ 3.7092137738562184e-05 4.3264838822889765e-10
+ 3.7103043385488656e-05 4.3388610175178318e-10
+ 3.7113949032415129e-05 4.3464666000495187e-10
+ 3.7126156063665134e-05 4.3514763453961883e-10
+ 3.7138363094915133e-05 4.3542384097085643e-10
+ 3.7150570126165132e-05 4.3556624282357159e-10
+ 3.716277715741513e-05 4.3562884855868211e-10
+ 3.7174984188665129e-05 4.3564390919099658e-10
+ 3.7187191219915134e-05 4.3563071731303817e-10
+ 3.7199398251165133e-05 4.3560072832369711e-10
+ 3.7211605282415132e-05 4.3556071800624522e-10
+ 3.7223812313665137e-05 4.3551473285478916e-10
+ 3.7236019344915136e-05 4.3546520640556509e-10
+ 3.7248226376165134e-05 4.3541358487496968e-10
+ 3.7260433407415133e-05 4.3536071753580087e-10
+ 3.7272640438665132e-05 4.353071102954193e-10
+ 3.7284847469915137e-05 4.3525307030070124e-10
+ 3.7297054501165136e-05 4.3519878102624261e-10
+ 3.7309261532415134e-05 4.3514434891989702e-10
+ 3.732146856366514e-05 4.3508983678706616e-10
+ 3.7333675594915139e-05 4.3503528333983576e-10
+ 3.7345882626165137e-05 4.3498071205926307e-10
+ 3.7358089657415136e-05 4.3492613633167183e-10
+ 3.7370296688665134e-05 4.348715638520445e-10
+ 3.738250371991514e-05 4.3481699946235471e-10
+ 3.7394710751165139e-05 4.3476244620745766e-10
+ 3.7406917782415137e-05 4.3470790578886986e-10
+ 3.7419124813665143e-05 4.3465337912630206e-10
+ 3.7431331844915141e-05 4.3459886680952396e-10
+ 3.744353887616514e-05 4.3454436923774573e-10
+ 3.7455745907415139e-05 4.3448988663097442e-10
+ 3.7467952938665137e-05 4.3443541909242035e-10
+ 3.7480159969915143e-05 4.3438096668679938e-10
+ 3.7492367001165141e-05 4.3432652946422885e-10
+ 3.7500000000000003e-05 4.3429323819786375e-10
+ 3.7512207031250002e-05 4.3423882549145797e-10
+ 3.7524414062500001e-05 4.3418442800650571e-10
+ 3.7536621093750006e-05 4.3413004574565444e-10
+ 3.7548828125000005e-05 4.3407567870875607e-10
+ 3.7561035156250004e-05 4.3402132689399754e-10
+ 3.7573242187500002e-05 4.3396699029857563e-10
+ 3.7585449218750001e-05 4.3391266891909689e-10
+ 3.7597656250000006e-05 4.338583627518177e-10
+ 3.7609863281250005e-05 4.338040717927861e-10
+ 3.7622070312500004e-05 4.3374979603792648e-10
+ 3.7634277343750002e-05 4.3369553548309005e-10
+ 3.7646484375000001e-05 4.3364129012408513e-10
+ 3.7658691406250006e-05 4.3358705995669485e-10
+ 3.7670898437500005e-05 4.3353284497668784e-10
+ 3.7683105468750004e-05 4.3347864517982436e-10
+ 3.7695312500000002e-05 4.3342446056186068e-10
+ 3.7707519531250001e-05 4.3337029111855061e-10
+ 3.7719726562500006e-05 4.3331613684564742e-10
+ 3.7731933593750005e-05 4.3326199773890431e-10
+ 3.7744140625000004e-05 4.3320787379407488e-10
+ 3.7756347656250002e-05 4.3315376500691365e-10
+ 3.7768554687500001e-05 4.3309967137317592e-10
+ 3.7780761718750006e-05 4.3304559288861817e-10
+ 3.7792968750000005e-05 4.3299152954899793e-10
+ 3.7805175781250004e-05 4.3293748135007384e-10
+ 3.7817382812500002e-05 4.3288344828760572e-10
+ 3.7829589843750001e-05 4.3282943035735457e-10
+ 3.7841796875000007e-05 4.3277542755508266e-10
+ 3.7854003906250005e-05 4.327214398765532e-10
+ 3.7866210937500004e-05 4.3266746731753079e-10
+ 3.7878417968750002e-05 4.3261350987378112e-10
+ 3.7890625000000001e-05 4.3255956754107106e-10
+ 3.7902832031250007e-05 4.3250564031516869e-10
+ 3.7915039062500005e-05 4.324517281918434e-10
+ 3.7927246093750004e-05 4.3239783116686546e-10
+ 3.7939453125000003e-05 4.3234394923600652e-10
+ 3.7951660156250001e-05 4.3229008239503964e-10
+ 3.79638671875e-05 4.322362306397386e-10
+ 3.7976074218750005e-05 4.3218239396587857e-10
+ 3.7988281250000004e-05 4.3212857236923607e-10
+ 3.8000488281250003e-05 4.3207476584558855e-10
+ 3.8012695312500001e-05 4.3202097439071481e-10
+ 3.802490234375e-05 4.3196719800039462e-10
+ 3.8037109375000005e-05 4.3191343667040926e-10
+ 3.8049316406250004e-05 4.3185969039654094e-10
+ 3.8061523437500003e-05 4.3180595917457319e-10
+ 3.8073730468750001e-05 4.3175224300029046e-10
+ 3.8085937500000007e-05 4.3169854186947872e-10
+ 3.8098144531250005e-05 4.3164485577792515e-10
+ 3.8110351562500004e-05 4.3159118472141752e-10
+ 3.8122558593750003e-05 4.315375286957455e-10
+ 3.8134765625000001e-05 4.3148388769669956e-10
+ 3.8146972656250007e-05 4.3143026172007142e-10
+ 3.8159179687500005e-05 4.3137665076165393e-10
+ 3.8171386718750004e-05 4.3132305481724119e-10
+ 3.8183593750000003e-05 4.3126947388262849e-10
+ 3.8195800781250001e-05 4.3121590795361226e-10
+ 3.8208007812500007e-05 4.3116235702599014e-10
+ 3.8220214843750005e-05 4.311088210955608e-10
+ 3.8232421875000004e-05 4.3105530015812432e-10
+ 3.8244628906250003e-05 4.3100179420948178e-10
+ 3.8256835937500001e-05 4.3094830324543561e-10
+ 3.8269042968750007e-05 4.3089482726178914e-10
+ 3.8281250000000006e-05 4.3084136625434698e-10
+ 3.8293457031250004e-05 4.3078792021891527e-10
+ 3.8305664062500003e-05 4.3073448915130076e-10
+ 3.8317871093750002e-05 4.3068107304731183e-10
+ 3.8330078125000007e-05 4.3062767190275767e-10
+ 3.8342285156250006e-05 4.3057428571344897e-10
+ 3.8354492187500004e-05 4.305209144751974e-10
+ 3.8366699218750003e-05 4.3046755818381573e-10
+ 3.8378906250000002e-05 4.3041421683511815e-10
+ 3.8391113281250007e-05 4.3036089042491982e-10
+ 3.8403320312500006e-05 4.3030757894903721e-10
+ 3.8415527343750004e-05 4.3025428240328784e-10
+ 3.8427734375000003e-05 4.3020100078349046e-10
+ 3.8439941406250002e-05 4.3014773408546503e-10
+ 3.8452148437500007e-05 4.3009448230503257e-10
+ 3.8464355468750006e-05 4.3004124543801536e-10
+ 3.8476562500000004e-05 4.2998802348023685e-10
+ 3.8488769531250003e-05 4.2993481642752165e-10
+ 3.8500976562500002e-05 4.298816242756955e-10
+ 3.8513183593750007e-05 4.2982844702058526e-10
+ 3.8525390625000006e-05 4.2977528465801911e-10
+ 3.8537597656250004e-05 4.2972213718382639e-10
+ 3.8549804687500003e-05 4.296690045938374e-10
+ 3.8562011718750002e-05 4.2961588688388387e-10
+ 3.8574218750000007e-05 4.2956278404979846e-10
+ 3.8586425781250006e-05 4.2950969608741529e-10
+ 3.8598632812500004e-05 4.2945662299256918e-10
+ 3.8610839843750003e-05 4.2940356476109669e-10
+ 3.8623046875000002e-05 4.2935052138883517e-10
+ 3.863525390625e-05 4.2929749287162315e-10
+ 3.8647460937500006e-05 4.2924447920530045e-10
+ 3.8659667968750005e-05 4.2919148038570803e-10
+ 3.8671875000000003e-05 4.2913849640868801e-10
+ 3.8684082031250002e-05 4.2908552727008359e-10
+ 3.86962890625e-05 4.2903257296573924e-10
+ 3.8708496093750006e-05 4.2897963349150058e-10
+ 3.8720703125000005e-05 4.2892670884321429e-10
+ 3.8732910156250003e-05 4.288737990167283e-10
+ 3.8745117187500002e-05 4.2882090400789185e-10
+ 3.8757324218750001e-05 4.2876802381255504e-10
+ 3.8769531249999999e-05 4.2871515842656934e-10
+ 3.8781738281250005e-05 4.2866230784578723e-10
+ 3.8793945312500003e-05 4.2860947206606246e-10
+ 3.8806152343750002e-05 4.2855665108325002e-10
+ 3.8818359375000001e-05 4.2850384489320595e-10
+ 3.8830566406249999e-05 4.2845105349178732e-10
+ 3.8842773437500005e-05 4.2839827687485269e-10
+ 3.8854980468750003e-05 4.2834551503826145e-10
+ 3.8867187500000002e-05 4.2829276797787439e-10
+ 3.8879394531250001e-05 4.2824003568955333e-10
+ 3.8891601562499999e-05 4.2818731816916134e-10
+ 3.8903808593750005e-05 4.2813461541256231e-10
+ 3.8916015625000003e-05 4.2808192741562203e-10
+ 3.8928222656250002e-05 4.2802925417420679e-10
+ 3.8940429687500001e-05 4.2797659568418397e-10
+ 3.8952636718749999e-05 4.2792395194142275e-10
+ 3.8964843750000005e-05 4.2787132294179297e-10
+ 3.8977050781250003e-05 4.2781870868116553e-10
+ 3.8989257812500002e-05 4.2776610915541303e-10
+ 3.9001464843750001e-05 4.2771352436040875e-10
+ 3.9013671874999999e-05 4.2766095429202714e-10
+ 3.9025878906249998e-05 4.2760839894614423e-10
+ 3.9038085937500004e-05 4.2755585831863669e-10
+ 3.9050292968750002e-05 4.2750333240538267e-10
+ 3.9062500000000001e-05 4.2745082120226136e-10
+ 3.9074707031249999e-05 4.2739832470515305e-10
+ 3.9086914062499998e-05 4.273458429099393e-10
+ 3.9099121093750004e-05 4.2729337581250278e-10
+ 3.9111328125000002e-05 4.2724092340872732e-10
+ 3.9123535156250001e-05 4.2718848569449787e-10
+ 3.91357421875e-05 4.2713606266570053e-10
+ 3.9147949218749998e-05 4.2708365431822263e-10
+ 3.9160156249999997e-05 4.270312606479525e-10
+ 3.9172363281250002e-05 4.2697888165077988e-10
+ 3.9184570312500001e-05 4.2692651732259529e-10
+ 3.919677734375e-05 4.2687416765929084e-10
+ 3.9208984374999998e-05 4.2682183265675928e-10
+ 3.9221191406249997e-05 4.2676951231089505e-10
+ 3.9233398437500002e-05 4.2671720661759342e-10
+ 3.9245605468750001e-05 4.2666491557275079e-10
+ 3.92578125e-05 4.2661263917226478e-10
+ 3.9270019531249998e-05 4.265603774120343e-10
+ 3.9282226562499997e-05 4.265081302879591e-10
+ 3.9294433593750002e-05 4.2645589779594043e-10
+ 3.9306640625000001e-05 4.2640367993188038e-10
+ 3.931884765625e-05 4.2635147669168246e-10
+ 3.9331054687499998e-05 4.2629928807125108e-10
+ 3.9343261718749997e-05 4.2624711406649186e-10
+ 3.9355468750000002e-05 4.2619495467331169e-10
+ 3.9367675781250001e-05 4.2614280988761856e-10
+ 3.93798828125e-05 4.2609067970532156e-10
+ 3.9392089843749998e-05 4.2603856412233079e-10
+ 3.9404296874999997e-05 4.2598646313455786e-10
+ 3.9416503906249996e-05 4.2593437673791515e-10
+ 3.9428710937500001e-05 4.2588230492831644e-10
+ 3.944091796875e-05 4.2583024770167654e-10
+ 3.9453124999999998e-05 4.2577820505391141e-10
+ 3.9465332031249997e-05 4.2572617698093814e-10
+ 3.9477539062499996e-05 4.2567416347867499e-10
+ 3.9489746093750001e-05 4.2562216454304139e-10
+ 3.9501953125e-05 4.2557018016995789e-10
+ 3.9514160156249999e-05 4.2551821035534623e-10
+ 3.9526367187499997e-05 4.2546625509512913e-10
+ 3.9538574218749996e-05 4.254143143852306e-10
+ 3.9550781249999994e-05 4.2536238822157581e-10
+ 3.956298828125e-05 4.2531047660009089e-10
+ 3.9575195312499999e-05 4.2525857951670346e-10
+ 3.9587402343749997e-05 4.252066969673418e-10
+ 3.9599609374999996e-05 4.2515482894793579e-10
+ 3.9611816406249995e-05 4.2510297545441604e-10
+ 3.96240234375e-05 4.2505113648271467e-10
+ 3.9636230468749999e-05 4.2499931202876474e-10
+ 3.9648437499999997e-05 4.2494750208850055e-10
+ 3.9660644531249996e-05 4.248957066578573e-10
+ 3.9672851562499995e-05 4.2482519493572964e-10
+ 3.968505859375e-05 4.2475256100502045e-10
+ 3.9697265624999999e-05 4.2468173951608737e-10
+ 3.9709472656249997e-05 4.2459666096075283e-10
+ 3.9721679687499996e-05 4.2448010616874532e-10
+ 3.9733886718749995e-05 4.242745676347303e-10
+ 3.9739990234374994e-05 4.2406762246865748e-10
+ 3.974609375e-05 4.2364446431160585e-10
+ 3.97491455078125e-05 4.2320637096990359e-10
+ 3.9752197265624999e-05 4.2237081875579266e-10
+ 3.9755249023437499e-05 4.2039912634768696e-10
+ 3.9756606790774091e-05 4.184858057925494e-10
+ 3.9756998216660864e-05 4.1769354662518729e-10
+ 3.9757389642547637e-05 4.1673967866159501e-10
+ 3.9758368207264579e-05 4.1328644574257995e-10
+ 3.975940950290819e-05 4.0647792025774505e-10
+ 3.9759970598735325e-05 4.0009399586852752e-10
+ 3.9760339629298371e-05 3.9400830485401903e-10
+ 3.9761110323815846e-05 3.7217296598144555e-10
+ 3.9761741481233849e-05 3.3482378565862255e-10
+ 3.9762113084009011e-05 2.9476725253157392e-10
+ 3.9762434193795789e-05 2.3913652951300332e-10
+ 3.9762647097925411e-05 2.1273235713088472e-10
+ 3.9762860002055033e-05 2.1207408791108858e-10
+ 3.9764989043351247e-05 2.1185023895337551e-10
+ 3.9777196074601246e-05 2.0757980032582087e-10
+ 3.9789403105851245e-05 1.9827504053149293e-10
+ 3.980161013710125e-05 1.8447156434439206e-10
+ 3.9813817168351249e-05 1.6696410651490149e-10
+ 3.9826024199601247e-05 1.4676018343964647e-10
+ 3.9838231230851246e-05 1.2502212943217047e-10
+ 3.9850438262101245e-05 1.0300022779102304e-10
+ 3.9862645293351243e-05 8.1960799754197404e-11
+ 3.9874852324601249e-05 6.311338755160194e-11
+ 3.9887059355851247e-05 4.7541218733423125e-11
+ 3.9899266387101246e-05 3.6138949326912032e-11
+ 3.9911473418351245e-05 2.9561263935700322e-11
+ 3.9923680449601243e-05 2.8185285811614418e-11
+ 3.9935887480851249e-05 3.2088955187765566e-11
+ 3.9948094512101248e-05 4.1046615499322252e-11
+ 3.9960301543351246e-05 5.4542057385810135e-11
+ 3.9972508574601245e-05 7.1798266491615728e-11
+ 3.9984715605851244e-05 9.1822160785597292e-11
+ 3.9996922637101249e-05 1.1346174161334856e-10
+ 4.0009129668351248e-05 1.3547236949090519e-10
+ 4.0021336699601246e-05 1.5658835172212636e-10
+ 4.0033543730851245e-05 1.7559572435646284e-10
+ 4.0045750762101244e-05 1.9140204326212496e-10
+ 4.0057957793351249e-05 2.030991720132836e-10
+ 4.0061009551163749e-05 2.0529687447679853e-10
+ 4.0061314726944994e-05 2.0549982177660819e-10
+ 4.0062077666398117e-05 2.0599366009052315e-10
+ 4.0062459136124685e-05 2.062333046850057e-10
+ 4.0062482977982596e-05 2.0624812098499301e-10
+ 4.0062487746354173e-05 2.0625108196291897e-10
+ 4.006249728309734e-05 2.0625700163649109e-10
+ 4.0062498046036789e-05 2.0625747507891284e-10
+ 4.0062499571915699e-05 2.0625842190532621e-10
+ 4.0062499693986008e-05 2.0625849764807365e-10
+ 4.0062499938126633e-05 2.0625864913207268e-10
+ 4.0062499957657885e-05 2.0625866125070641e-10
+ 4.0062499996720388e-05 2.0625868548793557e-10
+ 4.0062500074845388e-05 8.3574849775232329e-10
+ 4.0062500152970387e-05 2.8382408459534785e-09
+ 4.0062500934220384e-05 9.7910663945931592e-08
+ 4.0062508051845979e-05 6.9281309170090845e-06
+ 4.0062515169471573e-05 2.3496919613390592e-05
+ 4.0062522287097167e-05 4.8515586154137975e-05
+ 4.0062529404722768e-05 8.0864107426474553e-05
+ 4.0062536522348362e-05 0.0001195688537478285
+ 4.0062543639973957e-05 0.00016378325676260678
+ 4.0062550757599558e-05 0.00021277103077073492
+ 4.0062557875225152e-05 0.00026589161027525284
+ 4.0062564992850746e-05 0.00032258751106878353
+ 4.0062572110476347e-05 0.00038237336083026571
+ 4.0062579228101942e-05 0.00044482637875059637
+ 4.0062587807568574e-05 0.00052313156179263198
+ 4.0062596387035206e-05 0.00060422377214069478
+ 4.0062604966501838e-05 0.00068763160407692863
+ 4.006261354596847e-05 0.00077295453496090106
+ 4.0062622125435102e-05 0.00085985181282763258
+ 4.0062630704901734e-05 0.00094803308914625053
+ 4.0062639284368366e-05 0.0010372505228311898
+ 4.0062647863834998e-05 0.0011272921245865509
+ 4.0062658180770252e-05 0.0012364048498757886
+ 4.0062668497705512e-05 0.0013461799437633384
+ 4.0062678814640766e-05 0.0014563930288477433
+ 4.0062689131576019e-05 0.001566855276772596
+ 4.0062699448511273e-05 0.0016774068636345029
+ 4.0062709765446527e-05 0.001787911643031166
+ 4.0062720082381787e-05 0.0018982528107135616
+ 4.0062730399317041e-05 0.0020083293767566338
+ 4.0062742902012263e-05 0.002141246780886198
+ 4.0062755404707479e-05 0.0022735106700283729
+ 4.0062767907402702e-05 0.0024050029041599369
+ 4.0062780410097917e-05 0.0025356196305195535
+ 4.006279291279314e-05 0.0026652683340791378
+ 4.0062805415488355e-05 0.002793865545581445
+ 4.0062817918183578e-05 0.0029213350620943554
+ 4.00628304208788e-05 0.0030476065669750823
+ 4.0062845592253875e-05 0.0031991277392290247
+ 4.0062860763628957e-05 0.0033486794005026179
+ 4.0062875935004038e-05 0.0034961593179601309
+ 4.0062891106379113e-05 0.0036414711081661105
+ 4.0062906277754194e-05 0.0037845233735065873
+ 4.0062921449129276e-05 0.0039252290818992874
+ 4.0062936620504357e-05 0.0040635051254073566
+ 4.0062954860519562e-05 0.0042264209820281088
+ 4.0062973100534773e-05 0.0043855785109888799
+ 4.0062991340549977e-05 0.004540852807539594
+ 4.0063009580565181e-05 0.0046921255232483241
+ 4.0063027820580393e-05 0.004839284756390172
+ 4.0063046060595597e-05 0.0049822250059800644
+ 4.0063068199865845e-05 0.0051499118748984281
+ 4.00630903391361e-05 0.0053110729761570875
+ 4.0063112478406349e-05 0.0054655577982168782
+ 4.0063134617676597e-05 0.0056132299331846198
+ 4.0063161293011322e-05 0.0057819364493443522
+ 4.006318787309581e-05 0.0059398423573548687
+ 4.0063214453180297e-05 0.0060874136176253622
+ 4.0063248688484342e-05 0.0062620603819550135
+ 4.0063282923788387e-05 0.0064191641307141745
+ 4.0063315356127048e-05 0.0065517091134031152
+ 4.0063347788465716e-05 0.0066683776453289999
+ 4.0063380220804378e-05 0.0067692021882621509
+ 4.0063412653143039e-05 0.0068542763543729904
+ 4.0063445085481708e-05 0.0069237529436825757
+ 4.0063477517820369e-05 0.0069778416850672731
+ 4.0063509950159031e-05 0.0070168067033145008
+ 4.0063542382497692e-05 0.0070409637367341727
+ 4.0063569584998151e-05 0.0070500711051410814
+ 4.0063596787498602e-05 0.0070492564131712353
+ 4.0063623989999054e-05 0.0070387804986578604
+ 4.0063651192499513e-05 0.0070189238317284377
+ 4.0063678394999965e-05 0.0069899850256677273
+ 4.0063705597500417e-05 0.0069522793135452206
+ 4.0063732800000868e-05 0.0069061369988542495
+ 4.006376000250132e-05 0.0068519018883273245
+ 4.0063787205001779e-05 0.0067899297149596706
+ 4.0063814407502231e-05 0.0067205865590935169
+ 4.0063841610002683e-05 0.0066442472751925379
+ 4.0063868812503141e-05 0.006561293931672073
+ 4.0063896015003593e-05 0.0064721142708494637
+ 4.0063923217504045e-05 0.0063771001957435066
+ 4.0063950420004497e-05 0.0062766462900859356
+ 4.0063977622504948e-05 0.0061711483775146155
+ 4.0064004825005407e-05 0.0060610021255013743
+ 4.0064032027505859e-05 0.0059466016991306979
+ 4.0064059230006311e-05 0.0058283384693926773
+ 4.0064086432506769e-05 0.0057065997804302861
+ 4.00641153008835e-05 0.0055740309990659331
+ 4.0064144169260238e-05 0.0054384272991202893
+ 4.0064173037636968e-05 0.0053002282345430132
+ 4.0064201906013706e-05 0.0051598626838551204
+ 4.0064230774390443e-05 0.0050177476630414884
+ 4.0064259642767174e-05 0.0048742872442221231
+ 4.0064288511143912e-05 0.0047298715812966012
+ 4.0064317379520642e-05 0.0045848760430473451
+ 4.006434624789738e-05 0.0044396604535071188
+ 4.0064381135166682e-05 0.0042643637747592994
+ 4.0064416022435991e-05 0.0040898203879790361
+ 4.0064449985506052e-05 0.0039211359224094145
+ 4.0064483948576113e-05 0.0037541355090310092
+ 4.0064517911646181e-05 0.0035892460195200843
+ 4.0064551874716242e-05 0.0034268598627977894
+ 4.0064585837786303e-05 0.0032673350066711841
+ 4.0064627381082823e-05 0.0030765664536155394
+ 4.0064668924379336e-05 0.0028910852643209248
+ 4.0064710467675849e-05 0.0027113416169293153
+ 4.0064752010972368e-05 0.0025377141992044784
+ 4.0064802322523104e-05 0.0023360685105670866
+ 4.0064853125173636e-05 0.0021424443576868821
+ 4.0064903927824174e-05 0.001959156496722657
+ 4.0064971607266249e-05 0.0017313192252947558
+ 4.0065039286708323e-05 0.0015222190408349249
+ 4.006509191939657e-05 0.001372431253814393
+ 4.0065144552084817e-05 0.0012336381966261724
+ 4.0065197184773057e-05 0.0011055447342070166
+ 4.0065249817461304e-05 0.00098778684645394604
+ 4.0065297809929105e-05 0.00088906516794052203
+ 4.0065345802396907e-05 0.00079823747715313789
+ 4.0065393794864708e-05 0.00071492972227882204
+ 4.0065441787332517e-05 0.00063875107498295779
+ 4.0065489779800318e-05 0.00056929990178360005
+ 4.0065537261554869e-05 0.00050680910974394439
+ 4.0065584743309413e-05 0.00045011010916966049
+ 4.0065632225063965e-05 0.00039881145821643485
+ 4.0065679706818516e-05 0.00035252854906615789
+ 4.006572718857306e-05 0.00031088653907439246
+ 4.0065774670327611e-05 0.0002735227890958723
+ 4.0065824358583366e-05 0.00023862511600889196
+ 4.0065874046839127e-05 0.00020765025205703798
+ 4.0065923735094882e-05 0.00018023763188315632
+ 4.0065973423350637e-05 0.00015604795426756195
+ 4.0066023111606398e-05 0.0001347637411803884
+ 4.0066072799862153e-05 0.00011608953467670693
+ 4.0066127951386078e-05 9.8086983151495662e-05
+ 4.0066183102910003e-05 8.2620379659707852e-05
+ 4.0066238254433928e-05 6.937830638173144e-05
+ 4.0066293405957854e-05 5.8079646203919961e-05
+ 4.0066348557481779e-05 4.8471998343402797e-05
+ 4.0066411640520545e-05 3.9267448447275403e-05
+ 4.0066474723559303e-05 3.1683839518460041e-05
+ 4.0066537806598062e-05 2.5463033689023789e-05
+ 4.0066600889636821e-05 2.0382309617297274e-05
+ 4.0066674140146429e-05 1.5662206653736814e-05
+ 4.0066747390656036e-05 1.1971024407425274e-05
+ 4.006682064116565e-05 9.101093726216712e-06
+ 4.0066905619421589e-05 6.5781195004269459e-06
+ 4.0066990597677527e-05 4.7207090840830405e-06
+ 4.006709383684479e-05 3.1245246960755978e-06
+ 4.0067198171769414e-05 2.0371887602864823e-06
+ 4.0067302506694046e-05 1.3141391771344707e-06
+ 4.0067426664469164e-05 7.6923430377838728e-07
+ 4.006755082224429e-05 4.435788450454647e-07
+ 4.0067705800806534e-05 2.1851475951109054e-07
+ 4.0067884937131787e-05 9.3708673373505121e-08
+ 4.006809855660239e-05 3.2883700516734768e-08
+ 4.0068364485722958e-05 8.5309004428172277e-09
+ 4.0068717982712207e-05 1.4552417250701691e-09
+ 4.0069242097564149e-05 3.0578689270965244e-10
+ 4.0070136340120476e-05 2.4569663308855879e-10
+ 4.0072132807185041e-05 2.4259754686171839e-10
+ 4.0073988816858019e-05 2.4182034068072913e-10
+ 4.0076421668443083e-05 2.4138174969930913e-10
+ 4.0078854520028147e-05 2.4076582964276258e-10
+ 4.0081287371613212e-05 2.4012576594620444e-10
+ 4.0083720223198276e-05 2.4057963384973803e-10
+ 4.0086153074783333e-05 2.4092919901400983e-10
+ 4.0088585926368398e-05 2.401872610697499e-10
+ 4.0091018777953462e-05 2.3987554496708928e-10
+ 4.0093451629538526e-05 2.4037942571475707e-10
+ 4.0095767705239781e-05 2.4025247901632375e-10
+ 4.0098819440406719e-05 2.4017887589128354e-10
+ 4.0101871175573657e-05 2.4009951114703349e-10
+ 4.0104922910740602e-05 2.4004351142745323e-10
+ 4.0107974645907541e-05 2.4016098617015712e-10
+ 4.0111026381074479e-05 2.4071442426522539e-10
+ 4.0114078116241417e-05 2.3968616681674537e-10
+ 4.0117773618773604e-05 2.4003007462135484e-10
+ 4.0121134288610909e-05 2.4006402385879101e-10
+ 4.0124494958448221e-05 2.4006047129867007e-10
+ 4.0128620731690284e-05 2.4005210497337081e-10
+ 4.0132746504932341e-05 2.4004042399080182e-10
+ 4.0136872278174397e-05 2.4003044384477591e-10
+ 4.014099805141646e-05 2.4003749578386358e-10
+ 4.0145123824658517e-05 2.4008180521387353e-10
+ 4.01502511384371e-05 2.4016443526047099e-10
+ 4.0155378452215683e-05 2.3985136550844345e-10
+ 4.0160505765994266e-05 2.3994252727381691e-10
+ 4.0165633079772849e-05 2.4004700010028028e-10
+ 4.0171995979825156e-05 2.4004483697536087e-10
+ 4.0178358879877463e-05 2.3997024527683999e-10
+ 4.018472177992977e-05 2.3997592655072043e-10
+ 4.0192497256254514e-05 2.4000749931504923e-10
+ 4.0200272732579252e-05 2.4001269631983051e-10
+ 4.0208048208903997e-05 2.3999782508278659e-10
+ 4.0217983441936073e-05 2.3999355892689472e-10
+ 4.0227918674968142e-05 2.4000179472492324e-10
+ 4.0240125706218148e-05 2.4000339716614338e-10
+ 4.0252332737468146e-05 2.3999888202599127e-10
+ 4.0264539768718145e-05 2.3999830525938688e-10
+ 4.0276746799968144e-05 2.4000037974237526e-10
+ 4.0288953831218142e-05 2.4000087414852165e-10
+ 4.0301160862468148e-05 2.3999993966201389e-10
+ 4.0313367893718146e-05 2.3999960494882817e-10
+ 4.0325574924968145e-05 2.4000001432309894e-10
+ 4.0337781956218144e-05 2.4000021737723387e-10
+ 4.0349988987468142e-05 2.4000004462513988e-10
+ 4.0362196018718148e-05 2.3999993006727966e-10
+ 4.0374403049968146e-05 2.3999999917748096e-10
+ 4.0386610081218145e-05 2.4000006049017395e-10
+ 4.0398817112468144e-05 2.4000003421757239e-10
+ 4.0411024143718142e-05 2.4000000237870328e-10
+ 4.0423231174968141e-05 2.4000001256652595e-10
+ 4.0435438206218146e-05 2.4000002745854788e-10
+ 4.0447645237468145e-05 2.4000002475271839e-10
+ 4.0459852268718144e-05 2.4000001795384735e-10
+ 4.0472059299968142e-05 2.400000173879749e-10
+ 4.0484266331218141e-05 2.4000002070407596e-10
+ 4.0496473362468146e-05 2.4000002067419452e-10
+ 4.0508680393718145e-05 2.4000001976473751e-10
+ 4.0520887424968144e-05 2.40000019362722e-10
+ 4.0533094456218142e-05 2.4000002028128461e-10
+ 4.0545301487468141e-05 2.4000002060646208e-10
+ 4.055750851871814e-05 2.4000002008287723e-10
+ 4.0569715549968145e-05 2.4000001934276911e-10
+ 4.0581922581218144e-05 2.4000001968966948e-10
+ 4.0594129612468143e-05 2.4000002093381111e-10
+ 4.0606336643718141e-05 2.4000001965726013e-10
+ 4.061854367496814e-05 2.4000001961507071e-10
+ 4.0630750706218145e-05 2.4000002048512451e-10
+ 4.0642957737468144e-05 2.4000001998121006e-10
+ 4.0655164768718143e-05 2.400000199764228e-10
+ 4.0667371799968141e-05 2.4000001998665694e-10
+ 4.067957883121814e-05 2.4000001988395378e-10
+ 4.0691785862468145e-05 2.4000001969840786e-10
+ 4.0703992893718144e-05 2.4000001962628526e-10
+ 4.0716199924968143e-05 2.4000001985975601e-10
+ 4.0728406956218141e-05 2.4000001994562599e-10
+ 4.074061398746814e-05 2.4000001873790616e-10
+ 4.0752821018718145e-05 2.400000206888198e-10
+ 4.0765028049968144e-05 2.4000002115772409e-10
+ 4.0777235081218143e-05 2.4000001926167516e-10
+ 4.0789442112468141e-05 2.4000001865095655e-10
+ 4.080164914371814e-05 2.4000002024868279e-10
+ 4.0813856174968139e-05 2.4000002062807212e-10
+ 4.0826063206218144e-05 2.4000001971246058e-10
+ 4.0838270237468143e-05 2.4000001913611468e-10
+ 4.0850477268718141e-05 2.4000001939609548e-10
+ 4.086268429996814e-05 2.4000001928925776e-10
+ 4.0874891331218139e-05 2.4000002036211893e-10
+ 4.0887098362468144e-05 2.4000001948566678e-10
+ 4.0899305393718143e-05 2.40000020557049e-10
+ 4.0911512424968141e-05 2.400000203491446e-10
+ 4.092371945621814e-05 2.4000001961720044e-10
+ 4.0935926487468139e-05 2.400000200808237e-10
+ 4.0948133518718137e-05 2.4000002006495584e-10
+ 4.0960340549968143e-05 2.4000001941755901e-10
+ 4.0972547581218141e-05 2.4000001925514504e-10
+ 4.098475461246814e-05 2.4000001949494439e-10
+ 4.0996961643718139e-05 2.4000001987457185e-10
+ 4.1009168674968137e-05 2.4000001956535886e-10
+ 4.1021375706218143e-05 2.4000001976899341e-10
+ 4.1033582737468142e-05 2.4000001989767335e-10
+ 4.104578976871814e-05 2.4000002010421042e-10
+ 4.1057996799968139e-05 2.4000002031692612e-10
+ 4.1070203831218138e-05 2.4000001943796074e-10
+ 4.1082410862468143e-05 2.4000001979057998e-10
+ 4.1094617893718142e-05 2.4000001994141042e-10
+ 4.110682492496814e-05 2.4000001910787902e-10
+ 4.1119031956218139e-05 2.4000002014157438e-10
+ 4.1131238987468138e-05 2.4000002007976212e-10
+ 4.1143446018718143e-05 2.4000001897875313e-10
+ 4.1155653049968142e-05 2.4000002030066949e-10
+ 4.116786008121814e-05 2.4000002070432142e-10
+ 4.1180067112468139e-05 2.4000001950520541e-10
+ 4.1192274143718138e-05 2.4000001947980057e-10
+ 4.1204481174968136e-05 2.4000002027253361e-10
+ 4.1216688206218142e-05 2.40000020609859e-10
+ 4.122889523746814e-05 2.4000001911322354e-10
+ 4.1241102268718139e-05 2.4000001969739074e-10
+ 4.1253309299968138e-05 2.4000002073053612e-10
+ 4.1265516331218136e-05 2.4000001994814067e-10
+ 4.1277723362468142e-05 2.4000001923239209e-10
+ 4.128993039371814e-05 2.4000002015288261e-10
+ 4.1302137424968139e-05 2.4000001930210656e-10
+ 4.1314344456218138e-05 2.4000001837686493e-10
+ 4.1326551487468136e-05 2.4000001946449939e-10
+ 4.1338758518718142e-05 2.4000002038326192e-10
+ 4.135096554996814e-05 2.400000203109469e-10
+ 4.1363172581218139e-05 2.400000203952259e-10
+ 4.1375379612468138e-05 2.4000001970496741e-10
+ 4.1387586643718143e-05 2.4000001924454606e-10
+ 4.1399793674968142e-05 2.4000001905466872e-10
+ 4.1412000706218141e-05 2.400000204518705e-10
+ 4.1424207737468139e-05 2.4000002011557764e-10
+ 4.1436414768718145e-05 2.4000001946831419e-10
+ 4.1448621799968143e-05 2.4000001925940771e-10
+ 4.1460828831218142e-05 2.4000001980987061e-10
+ 4.1473035862468141e-05 2.4000002089319245e-10
+ 4.1485242893718146e-05 2.4000001973823067e-10
+ 4.1497449924968145e-05 2.4000001879346328e-10
+ 4.1509656956218143e-05 2.4000001869932423e-10
+ 4.1521863987468142e-05 2.4000002074828773e-10
+ 4.1534071018718147e-05 2.4000001934026167e-10
+ 4.1546278049968146e-05 2.4000001952115826e-10
+ 4.1558485081218145e-05 2.4000001987859593e-10
+ 4.1570692112468143e-05 2.400000198982881e-10
+ 4.1582899143718149e-05 2.40000018977687e-10
+ 4.1595106174968147e-05 2.4000001970468766e-10
+ 4.1607313206218146e-05 2.4000001969944985e-10
+ 4.1619520237468145e-05 2.4000002027367879e-10
+ 4.163172726871815e-05 2.4000001840031488e-10
+ 4.1643934299968149e-05 2.4000001957318321e-10
+ 4.1656141331218148e-05 2.400000188108562e-10
+ 4.1668348362468146e-05 2.4000002046679305e-10
+ 4.1680555393718152e-05 2.4000001950571268e-10
+ 4.169276242496815e-05 2.4000001838116472e-10
+ 4.1704969456218149e-05 2.4000001853089837e-10
+ 4.1717176487468148e-05 2.4000002004811227e-10
+ 4.1729383518718153e-05 2.4000001966057371e-10
+ 4.1741590549968152e-05 2.4000001941089245e-10
+ 4.175379758121815e-05 2.4000001913185568e-10
+ 4.1766004612468149e-05 2.4000001954838558e-10
+ 4.1778211643718154e-05 2.4000001920964592e-10
+ 4.1790418674968153e-05 2.4000001943469307e-10
+ 4.1802625706218152e-05 2.4000001866641258e-10
+ 4.181483273746815e-05 2.4000002020897109e-10
+ 4.1827039768718156e-05 2.4000001940179987e-10
+ 4.1839246799968154e-05 2.4000001993507329e-10
+ 4.1851453831218153e-05 2.4000002008198123e-10
+ 4.1863660862468152e-05 2.400000198005213e-10
+ 4.1875867893718157e-05 2.4000001916301211e-10
+ 4.1888074924968156e-05 2.4000001960280073e-10
+ 4.1900281956218155e-05 2.4000001963117276e-10
+ 4.1912488987468153e-05 2.400000196254434e-10
+ 4.1924696018718159e-05 2.4000002030623543e-10
+ 4.1936903049968157e-05 2.4000001985486468e-10
+ 4.1949110081218156e-05 2.4000001975560508e-10
+ 4.1961317112468155e-05 2.4000002002563028e-10
+ 4.197352414371816e-05 2.4000001880683233e-10
+ 4.1985731174968159e-05 2.400000186107882e-10
+ 4.1997938206218157e-05 2.4000002026174485e-10
+ 4.2010145237468156e-05 2.4000001964579944e-10
+ 4.2022352268718161e-05 2.4000001869414737e-10
+ 4.203455929996816e-05 2.4000002024855297e-10
+ 4.2046766331218159e-05 2.4000001886895933e-10
+ 4.2058973362468157e-05 2.4000001996539064e-10
+ 4.2071180393718163e-05 2.4000001852201533e-10
+ 4.2083387424968161e-05 2.4000001995376353e-10
+ 4.209559445621816e-05 2.4000001885033681e-10
+ 4.2107801487468159e-05 2.400000202275795e-10
+ 4.2120008518718164e-05 2.4000001938682899e-10
+ 4.2132215549968163e-05 2.400000185286626e-10
+ 4.2144422581218162e-05 2.4000002021567022e-10
+ 4.215662961246816e-05 2.4000001929093104e-10
+ 4.2168836643718166e-05 2.4000001945502139e-10
+ 4.2181043674968164e-05 2.4000001849176264e-10
+ 4.2193250706218163e-05 2.4000001899160695e-10
+ 4.2205457737468162e-05 2.4000001908469775e-10
+ 4.2217664768718167e-05 2.4000002021320925e-10
+ 4.2229871799968166e-05 2.4000001986077044e-10
+ 4.2242078831218164e-05 2.4000001985660228e-10
+ 4.2254285862468163e-05 2.4000001982734366e-10
+ 4.2266492893718168e-05 2.4000001909394165e-10
+ 4.2278699924968167e-05 2.4000001971428865e-10
+ 4.2290906956218166e-05 2.4000001921042243e-10
+ 4.2303113987468164e-05 2.400000190589926e-10
+ 4.231532101871817e-05 2.400000192770844e-10
+ 4.2327528049968168e-05 2.4000001876027354e-10
+ 4.2339735081218167e-05 2.4000001963225885e-10
+ 4.2351942112468166e-05 2.4000001898595255e-10
+ 4.2364149143718171e-05 2.4000001876650681e-10
+ 4.237635617496817e-05 2.4000001955479303e-10
+ 4.2388563206218168e-05 2.400000192149284e-10
+ 4.2400770237468167e-05 2.4000001962818762e-10
+ 4.2412977268718173e-05 2.400000192259498e-10
+ 4.2425184299968171e-05 2.4000001958046752e-10
+ 4.243739133121817e-05 2.4000001876653049e-10
+ 4.2449598362468169e-05 2.4000001901679062e-10
+ 4.2461805393718174e-05 2.4000001929188411e-10
+ 4.2474012424968173e-05 2.4000001878460593e-10
+ 4.2486219456218171e-05 2.4000001895149019e-10
+ 4.249842648746817e-05 2.4000001953324466e-10
+ 4.2510633518718175e-05 2.4000001930179932e-10
+ 4.2522840549968174e-05 2.4000001867284628e-10
+ 4.2535047581218173e-05 2.4000001876404646e-10
+ 4.2547254612468171e-05 2.4000001844012502e-10
+ 4.2559461643718177e-05 2.4000001847700822e-10
+ 4.2571668674968175e-05 2.4000001848915366e-10
+ 4.2583875706218174e-05 2.4000001847211049e-10
+ 4.2596082737468173e-05 2.4000001842583542e-10
+ 4.2608289768718178e-05 2.4000001874485954e-10
+ 4.2620496799968177e-05 2.4000001864470591e-10
+ 4.2632703831218175e-05 2.400000192645186e-10
+ 4.2644910862468174e-05 2.4000001911011029e-10
+ 4.265711789371818e-05 2.400000189594016e-10
+ 4.2669324924968178e-05 2.4000001834385696e-10
+ 4.2681531956218177e-05 2.4000001923683012e-10
+ 4.2693738987468176e-05 2.4000002008098464e-10
+ 4.2705946018718181e-05 2.400000183211859e-10
+ 4.271815304996818e-05 2.4000001983070817e-10
+ 4.2730360081218178e-05 2.4000001841550595e-10
+ 4.2742567112468177e-05 2.4000001987140726e-10
+ 4.2754774143718182e-05 2.4000001839799459e-10
+ 4.2766981174968181e-05 2.4000001979564812e-10
+ 4.277918820621818e-05 2.4000001826400317e-10
+ 4.2791395237468178e-05 2.3996544537098469e-10
+ 4.2803602268718184e-05 2.3996256464191007e-10
+ 4.2815809299968182e-05 2.3996062147298765e-10
+ 4.2828016331218181e-05 2.399538992151035e-10
+ 4.284022336246818e-05 2.3990864356794482e-10
+ 4.2852430393718185e-05 2.3980391697569448e-10
+ 4.2864637424968184e-05 2.3960325885649169e-10
+ 4.2870740940593183e-05 2.3930636780140344e-10
+ 4.2876844456218182e-05 2.3825018349924986e-10
+ 4.2879896214030682e-05 2.3664385617022961e-10
+ 4.2882947971843182e-05 2.313460144418538e-10
+ 4.2884473850749435e-05 2.2273712950258841e-10
+ 4.2885999729655681e-05 1.9502932447418286e-10
+ 4.2886991106889188e-05 1.3263414891107653e-10
+ 4.2887269733896248e-05 9.5672269136980181e-11
+ 4.28875483609033e-05 4.6113023016783446e-11
+ 4.2888098835627975e-05 4.077304569289076e-11
+ 4.2890875273912435e-05 4.2347131994264368e-11
+ 4.290308230516244e-05 4.4733371018365243e-11
+ 4.2915289336412439e-05 5.3058719093237963e-11
+ 4.2927496367662438e-05 6.5249849962529414e-11
+ 4.2939703398912443e-05 8.0586557341896391e-11
+ 4.2951910430162442e-05 9.8186059694000248e-11
+ 4.296411746141244e-05 1.1703587328666208e-10
+ 4.2976324492662439e-05 1.3605185310399104e-10
+ 4.2988531523912438e-05 1.5414054504639482e-10
+ 4.3000738555162443e-05 1.7026206156240515e-10
+ 4.3012945586412442e-05 1.8348986297121229e-10
+ 4.302515261766244e-05 1.9306400774952091e-10
+ 4.3037359648912446e-05 1.9843481134517081e-10
+ 4.3049566680162445e-05 1.9929440536940058e-10
+ 4.3061773711412443e-05 1.9559438520732841e-10
+ 4.3073980742662442e-05 1.8754853451668201e-10
+ 4.3086187773912441e-05 1.7562047328816539e-10
+ 4.3098394805162446e-05 1.6049694315998822e-10
+ 4.3110601836412445e-05 1.4304826930135124e-10
+ 4.3122808867662443e-05 1.2427827523140709e-10
+ 4.3135015898912449e-05 1.052665328361379e-10
+ 4.3147222930162447e-05 8.7106269937226752e-11
+ 4.3159429961412446e-05 7.0841506734532094e-11
+ 4.3171636992662445e-05 5.7407035899497847e-11
+ 4.3183844023912443e-05 4.7574696846103914e-11
+ 4.318689578172495e-05 4.5750674856066197e-11
+ 4.3187048369615569e-05 4.5666462612461995e-11
+ 4.3187429839342131e-05 4.5458870923120094e-11
+ 4.3187467986314792e-05 4.5438342991126504e-11
+ 4.3187475615709324e-05 4.5434242455099145e-11
+ 4.3187490874498382e-05 4.5426046434154427e-11
+ 4.3187496978014011e-05 4.5422769911655126e-11
+ 4.318749941942026e-05 4.542145960441293e-11
+ 4.3187499604455786e-05 4.5421360302533612e-11
+ 4.3187499974526846e-05 4.5421161701746532e-11
+ 4.3187500714668951e-05 5.7234708751505077e-08
+ 4.3187501454811057e-05 2.3609835104101694e-07
+ 4.3187508856232153e-05 8.3378657603255145e-06
+ 4.3187516257653236e-05 2.6804211983519737e-05
+ 4.3187523659074333e-05 5.4212572160978158e-05
+ 4.3187531060495416e-05 8.9333429400249197e-05
+ 4.3187538461916512e-05 0.00013110387761772142
+ 4.3187547512355689e-05 0.00018988604042548046
+ 4.3187556562794873e-05 0.000255812068272275
+ 4.318756561323405e-05 0.00032768193023753725
+ 4.3187574663673233e-05 0.00040448949601993325
+ 4.3187583714112417e-05 0.00048539058840956265
+ 4.3187595044533515e-05 0.00059137048504824714
+ 4.3187606374954614e-05 0.00070151686849491022
+ 4.3187617705375712e-05 0.0008149054011463608
+ 4.3187629035796811e-05 0.00093078918228233572
+ 4.3187643214653366e-05 0.0010784080416500865
+ 4.318765739350992e-05 0.0012280520970111633
+ 4.3187671572366475e-05 0.0013789889014004875
+ 4.318768903239694e-05 0.0015657925325384681
+ 4.3187706492427404e-05 0.0017528666320927736
+ 4.3187723952457862e-05 0.0019395804048633696
+ 4.3187746268477832e-05 0.0021769293571718938
+ 4.3187768584497802e-05 0.0024120996791847497
+ 4.3187790900517771e-05 0.0026444704336099976
+ 4.3187819090217241e-05 0.0029332237971511233
+ 4.318784727991671e-05 0.0032158629328255771
+ 4.3187875469616186e-05 0.0034916668520790159
+ 4.3187903659315655e-05 0.0037599988278231356
+ 4.3187931849015125e-05 0.0040202830355208904
+ 4.3187960038714594e-05 0.0042719918874605982
+ 4.3187988228414063e-05 0.0045146394015623476
+ 4.3188019414106479e-05 0.0047719795450323309
+ 4.3188050599798888e-05 0.0050171295125712645
+ 4.3188081785491296e-05 0.0052495906087394869
+ 4.3188112971183712e-05 0.0054689190353913904
+ 4.3188150418414338e-05 0.0057143885297757718
+ 4.318818786564497e-05 0.0059397992525804574
+ 4.3188225312875596e-05 0.006144702220679193
+ 4.3188270844195813e-05 0.0063657430322260553
+ 4.3188316375516023e-05 0.0065556175023236875
+ 4.3188361906836239e-05 0.0067142112673811444
+ 4.3188407438156449e-05 0.0068416534980290083
+ 4.3188441084028115e-05 0.0069160175765833089
+ 4.318847472989978e-05 0.0069737900261410465
+ 4.3188508375771446e-05 0.0070152594941248576
+ 4.3188542021643111e-05 0.0070407746969006688
+ 4.3188575667514777e-05 0.007050740823760393
+ 4.3188609313386442e-05 0.0070456156939712805
+ 4.3188642959258108e-05 0.007025905702338452
+ 4.3188676605129773e-05 0.0069921615895264296
+ 4.3188710251001439e-05 0.0069449740739896257
+ 4.3188736870668149e-05 0.006898526876910809
+ 4.3188763490334858e-05 0.0068443802044164921
+ 4.3188790110001568e-05 0.0067828688534493494
+ 4.3188816729668278e-05 0.0067143369242957376
+ 4.3188843349334995e-05 0.0066391364097472113
+ 4.3188869969001705e-05 0.0065576257964309343
+ 4.3188896588668415e-05 0.0064701686843428533
+ 4.3188923208335125e-05 0.0063771324303375145
+ 4.3188949828001835e-05 0.0062788868210215225
+ 4.3188976447668544e-05 0.0061758027801676225
+ 4.3189003067335254e-05 0.0060682511154162089
+ 4.3189029687001971e-05 0.0059566013086644297
+ 4.3189056306668681e-05 0.0058412203541628417
+ 4.3189082926335391e-05 0.0057224716479485063
+ 4.3189109546002101e-05 0.0056007139318451742
+ 4.3189136165668811e-05 0.0054763002948580381
+ 4.3189162785335521e-05 0.0053495772343856614
+ 4.318918940500223e-05 0.0052208837792675896
+ 4.318921602466894e-05 0.0050905506764474901
+ 4.318923940493523e-05 0.0049749804171373225
+ 4.318926278520152e-05 0.0048586054363550972
+ 4.318928616546781e-05 0.0047416314482211135
+ 4.3189309545734093e-05 0.0046242577652878883
+ 4.3189332926000383e-05 0.0045066770343838705
+ 4.3189356306266673e-05 0.0043890750025309139
+ 4.3189379686532963e-05 0.0042716303126259531
+ 4.3189403066799246e-05 0.0041545143284691553
+ 4.3189426447065536e-05 0.0040378909886185305
+ 4.3189449827331826e-05 0.0039219166884552218
+ 4.3189473207598116e-05 0.0038067401897542695
+ 4.3189496587864399e-05 0.0036925025569730643
+ 4.3189519968130689e-05 0.0035793371193940525
+ 4.3189543348396979e-05 0.0034673694581895016
+ 4.3189566728663269e-05 0.0033567174174145066
+ 4.3189590108929552e-05 0.0032474911378798247
+ 4.3189613489195842e-05 0.0031397931128086067
+ 4.3189636869462131e-05 0.0030337182641405314
+ 4.3189660249728421e-05 0.0029293540383132049
+ 4.3189683629994704e-05 0.0028267805203238136
+ 4.3189707010260994e-05 0.0027260705648536779
+ 4.3189735591237522e-05 0.0026055855381113117
+ 4.3189764172214042e-05 0.0024880893416989024
+ 4.3189792753190569e-05 0.0023736731389782805
+ 4.318982133416709e-05 0.0022624136400195647
+ 4.3189849915143617e-05 0.0021543736566158275
+ 4.3189886199806215e-05 0.0020219271947776738
+ 4.3189925453373382e-05 0.0018846580284455387
+ 4.3189946977215268e-05 0.0018120618774395494
+ 4.3189973696714704e-05 0.0017245821083065652
+ 4.319000041621414e-05 0.0016400258203643724
+ 4.3190027135713576e-05 0.0015583844444338579
+ 4.3190053855213012e-05 0.0014796423351417674
+ 4.3190080574712448e-05 0.0014037772468436488
+ 4.3190107294211884e-05 0.0013307608065583204
+ 4.319013401371132e-05 0.0012605589819463642
+ 4.3190160733210756e-05 0.0011931325425094006
+ 4.3190187452710192e-05 0.0011284375123336611
+ 4.3190214172209628e-05 0.0010664256128491564
+ 4.3190240891709064e-05 0.0010070446942234952
+ 4.3190262548859618e-05 0.00096080661895637035
+ 4.3190284206010165e-05 0.0009162294538821239
+ 4.3190305863160718e-05 0.00087328092606094238
+ 4.3190327520311271e-05 0.00083192771752318962
+ 4.3190349177461818e-05 0.00079213559354230647
+ 4.3190370834612372e-05 0.00075386952625768001
+ 4.3190392491762925e-05 0.00071709381353394315
+ 4.3190414148913478e-05 0.00068177219296354193
+ 4.3190435806064032e-05 0.00064786795094112185
+ 4.3190457463214578e-05 0.00061534402675914772
+ 4.3190479120365132e-05 0.00058416311167918647
+ 4.3190496765399607e-05 0.00055972551886932095
+ 4.3190514410434081e-05 0.00053613426244406741
+ 4.3190532055468556e-05 0.00051336904748169171
+ 4.3190549700503024e-05 0.00049140960981622914
+ 4.3190567345537498e-05 0.00047023574348777509
+ 4.3190584990571973e-05 0.00044982732676715286
+ 4.3190602635606447e-05 0.00043016434677204047
+ 4.3190620280640922e-05 0.00041122692269401575
+ 4.3190637925675397e-05 0.00039299532765819798
+ 4.3190655570709871e-05 0.00037545000923921415
+ 4.3190673215744346e-05 0.00035857160865911174
+ 4.3190690860778821e-05 0.00034234097869457157
+ 4.3190708505813288e-05 0.00032673920032235228
+ 4.3190726150847763e-05 0.00031174759813332067
+ 4.3190743795882238e-05 0.00029734775454669758
+ 4.3190761440916712e-05 0.00028352152285727745
+ 4.3190779085951187e-05 0.0002702510391493668
+ 4.3190796730985661e-05 0.00025751873311203796
+ 4.3190814376020136e-05 0.00024530733779101174
+ 4.3190832021054604e-05 0.00023359989831307307
+ 4.3190849666089078e-05 0.00022237977961939102
+ 4.3190867311123553e-05 0.00021163067324446447
+ 4.3190884956158028e-05 0.00020133660317765155
+ 4.3190902601192502e-05 0.00019148193084437179
+ 4.3190920246226977e-05 0.00018205135924409671
+ 4.3190937891261452e-05 0.00017302993628217709
+ 4.3190955536295926e-05 0.00016440305733239472
+ 4.3190973181330401e-05 0.00015615646706688136
+ 4.3190990826364869e-05 0.00014827626058972067
+ 4.3191008471399343e-05 0.00014074888391014853
+ 4.3191026116433818e-05 0.00013356113379079491
+ 4.3191043761468292e-05 0.00012670015700587552
+ 4.3191061406502767e-05 0.00012015344904364461
+ 4.3191079051537242e-05 0.00011390885228677083
+ 4.3191096696571716e-05 0.00010795455370359766
+ 4.3191114341606184e-05 0.00010227908208250491
+ 4.3191131986640659e-05 9.687130484080241e-05
+ 4.3191149631675133e-05 9.1720424438765868e-05
+ 4.3191167276709608e-05 8.6815974428572379e-05
+ 4.3191184921744083e-05 8.2147815167013072e-05
+ 4.3191202566778557e-05 7.7706129219957601e-05
+ 4.3191220211813032e-05 7.3481416485622882e-05
+ 4.3191237856847506e-05 6.9464489062760908e-05
+ 4.3191255501881981e-05 6.5646465888930612e-05
+ 4.3191273146916449e-05 6.2018767173060703e-05
+ 4.3191290791950924e-05 5.8573108645546759e-05
+ 4.3191308436985398e-05 5.5301495648160228e-05
+ 4.3191326082019873e-05 5.2196217085081444e-05
+ 4.3191343727054347e-05 4.9249839255407143e-05
+ 4.3191361372088822e-05 4.6455199586526805e-05
+ 4.3191379017123297e-05 4.3805400286814076e-05
+ 4.3191396662157764e-05 4.1293801935142287e-05
+ 4.3191414307192239e-05 3.8914017023807698e-05
+ 4.3191431952226714e-05 3.6659903470533496e-05
+ 4.3191449597261188e-05 3.4525558114332587e-05
+ 4.3191467242295663e-05 3.2505310209129923e-05
+ 4.3191484887330138e-05 3.0593714928186798e-05
+ 4.3191502532364612e-05 2.878554689153125e-05
+ 4.3191520177399087e-05 2.7075793727781893e-05
+ 4.3191537822433561e-05 2.5459649680957857e-05
+ 4.3191555467468029e-05 2.3932509272096093e-05
+ 4.3191573112502504e-05 2.2489961024749567e-05
+ 4.3191590757536978e-05 2.1127781262716843e-05
+ 4.3191608402571453e-05 1.9841927987655173e-05
+ 4.3191626047605928e-05 1.8628534843556469e-05
+ 4.3191643692640402e-05 1.7483905174418017e-05
+ 4.3191661337674877e-05 1.6404506180818473e-05
+ 4.3191682620107575e-05 1.5184596516820046e-05
+ 4.3191702745281679e-05 1.4108722156777394e-05
+ 4.3191722870455782e-05 1.3103783271809466e-05
+ 4.3191742995629885e-05 1.2165512099818384e-05
+ 4.3191763120803989e-05 1.1289867233639744e-05
+ 4.3191783245978092e-05 1.0473023791237365e-05
+ 4.3191803371152196e-05 9.711363860421274e-06
+ 4.3191823496326299e-05 9.0014672215583367e-06
+ 4.3191843621500403e-05 8.3401023506671107e-06
+ 4.3191863746674499e-05 7.7242177042852387e-06
+ 4.3191888110746132e-05 7.0353574872189284e-06
+ 4.3191912474817758e-05 6.4041509733236313e-06
+ 4.3191936838889384e-05 5.8261375978047346e-06
+ 4.3191961202961009e-05 5.2971679183216326e-06
+ 4.3191985567032642e-05 4.8133849648221628e-06
+ 4.3192009931104268e-05 4.3712064413582404e-06
+ 4.3192034295175894e-05 3.9673077642003495e-06
+ 4.3192058659247519e-05 3.5986059186122073e-06
+ 4.3192083023319152e-05 3.2622441148827113e-06
+ 4.3192107387390778e-05 2.955577222710442e-06
+ 4.3192136719683571e-05 2.6223173518557521e-06
+ 4.3192166051976364e-05 2.3246430183300364e-06
+ 4.3192195384269164e-05 2.0589938235170389e-06
+ 4.3192224716561957e-05 1.8221375097881734e-06
+ 4.319225404885475e-05 1.6111428978970881e-06
+ 4.3192283381147543e-05 1.4233547079677823e-06
+ 4.3192312713440343e-05 1.2563701699769522e-06
+ 4.3192342045733136e-05 1.1080173307665688e-06
+ 4.3192377848029201e-05 9.4935328593955194e-07
+ 4.3192412335454628e-05 8.1703614317247063e-07
+ 4.3192446822880063e-05 7.0231034037170861e-07
+ 4.3192481310305497e-05 6.0295931014601184e-07
+ 4.3192515797730932e-05 5.1702814794412422e-07
+ 4.319255782832121e-05 4.2796498791424164e-07
+ 4.3192599858911488e-05 3.5358466304975593e-07
+ 4.3192641889501772e-05 2.9157919961691281e-07
+ 4.319268392009205e-05 2.3998333476715486e-07
+ 4.3192725950682328e-05 1.9712710629082681e-07
+ 4.3192777518503427e-05 1.5442331314774624e-07
+ 4.3192828186666486e-05 1.2110746118199679e-07
+ 4.3192878854829544e-05 9.4668212428266369e-08
+ 4.3192929522992596e-05 7.3741045625230226e-08
+ 4.319299321514346e-05 5.3572482382509411e-08
+ 4.3193056907294325e-05 3.8650410566722333e-08
+ 4.3193120599445189e-05 2.7655607125139506e-08
+ 4.3193198945610716e-05 1.80624388894615e-08
+ 4.3193278657649694e-05 1.1455385675920075e-08
+ 4.3193358369688672e-05 7.0279116712338033e-09
+ 4.3193461292370768e-05 3.42722610432318e-09
+ 4.3193569508909824e-05 1.2415251844169095e-09
+ 4.3193701914804442e-05 -1.7423168879043324e-10
+ 4.3193847065030184e-05 -9.0046498724308251e-10
+ 4.3194034315235685e-05 -1.2675598336250834e-09
+ 4.3194255865010426e-05 -1.390661486095478e-09
+ 4.3194554034092509e-05 -1.4079464626524889e-09
+ 4.3194998769870892e-05 -1.3781166774969621e-09
+ 4.3195805003988994e-05 -1.313948994893242e-09
+ 4.3196711764368321e-05 -1.2450592154006523e-09
+ 4.3197737475686442e-05 -1.1711746826522686e-09
+ 4.3198801143402346e-05 -1.0985374417948889e-09
+ 4.3199944764949546e-05 -1.0244977902794022e-09
+ 4.3202231646278911e-05 -8.876839903243166e-10
+ 4.3204182681216659e-05 -7.8153991862173163e-10
+ 4.3206291228517253e-05 -6.7660226349856925e-10
+ 4.3208581467436162e-05 -5.7299433820914436e-10
+ 4.3210926666850026e-05 -4.7698621811411996e-10
+ 4.3213271866263891e-05 -3.901690868650475e-10
+ 4.3215590537179634e-05 -3.1248869476676087e-10
+ 4.3218474569484281e-05 -2.2600941125466692e-10
+ 4.3221358601788934e-05 -1.4953972152878652e-10
+ 4.3224242634093581e-05 -8.1909642546355165e-11
+ 4.3227126666398227e-05 -2.2097231394821104e-11
+ 4.3230010698702881e-05 3.0804763949844941e-11
+ 4.3232894731007527e-05 7.7599184420572088e-11
+ 4.323577876331218e-05 1.1899177680085989e-10
+ 4.3239342797663597e-05 1.6360497315690482e-10
+ 4.3242906832015015e-05 2.0194460469335925e-10
+ 4.3246470866366438e-05 2.3489304324568193e-10
+ 4.3250034900717855e-05 2.6320792465228799e-10
+ 4.3253598935069272e-05 2.8754418863776942e-10
+ 4.3257899961127366e-05 3.124003450031708e-10
+ 4.3262200987185452e-05 3.3310188136055884e-10
+ 4.3266502013243545e-05 3.5034335018174361e-10
+ 4.3270803039301631e-05 3.6470346013268147e-10
+ 4.3275104065359718e-05 3.7666442373221598e-10
+ 4.3280502505986988e-05 3.8888313831481749e-10
+ 4.3285900946614252e-05 3.9859542479219459e-10
+ 4.3291299387241516e-05 4.0629545583254085e-10
+ 4.3296697827868786e-05 4.1242659596079512e-10
+ 4.3303468247657474e-05 4.1836450212166619e-10
+ 4.3310238667446162e-05 4.228142873871682e-10
+ 4.3317009087234849e-05 4.2614500842071573e-10
+ 4.3325385304343962e-05 4.2912633403108892e-10
+ 4.3333761521453074e-05 4.3120345772378355e-10
+ 4.3342137738562187e-05 4.3264838822889765e-10
+ 4.3353043385488659e-05 4.3388610175178318e-10
+ 4.3363949032415132e-05 4.3464666000495187e-10
+ 4.3376156063665137e-05 4.3514763453961883e-10
+ 4.3388363094915136e-05 4.3542384097085643e-10
+ 4.3400570126165134e-05 4.3556624282357159e-10
+ 4.3412777157415133e-05 4.3562884855868211e-10
+ 4.3424984188665132e-05 4.3564390919099658e-10
+ 4.3437191219915137e-05 4.3563071731303817e-10
+ 4.3449398251165136e-05 4.3560072832369711e-10
+ 4.3461605282415134e-05 4.3556071800624522e-10
+ 4.347381231366514e-05 4.3551473285478916e-10
+ 4.3486019344915139e-05 4.3546520640556509e-10
+ 4.3498226376165137e-05 4.3541358487496968e-10
+ 4.3510433407415136e-05 4.3536071753580087e-10
+ 4.3522640438665135e-05 4.353071102954193e-10
+ 4.353484746991514e-05 4.3525307030070124e-10
+ 4.3547054501165139e-05 4.3519878102624261e-10
+ 4.3559261532415137e-05 4.3514434891989702e-10
+ 4.3571468563665143e-05 4.3508983678706616e-10
+ 4.3583675594915141e-05 4.3503528333983576e-10
+ 4.359588262616514e-05 4.3498071205926307e-10
+ 4.3608089657415139e-05 4.3492613633167183e-10
+ 4.3620296688665137e-05 4.348715638520445e-10
+ 4.3632503719915143e-05 4.3481699946235471e-10
+ 4.3644710751165141e-05 4.3476244620745766e-10
+ 4.365691778241514e-05 4.3470790578886986e-10
+ 4.3669124813665145e-05 4.3465337912630206e-10
+ 4.3681331844915144e-05 4.3459886680952396e-10
+ 4.3693538876165143e-05 4.3454436923774573e-10
+ 4.3705745907415141e-05 4.3448988663097442e-10
+ 4.371795293866514e-05 4.3443541909242035e-10
+ 4.3730159969915146e-05 4.3438096668679938e-10
+ 4.3742367001165144e-05 4.3432652946422885e-10
+ 4.375e-05 4.3429323819786375e-10
+ 4.3762207031249998e-05 4.3423882549145797e-10
+ 4.3774414062499997e-05 4.3418442800650571e-10
+ 4.3786621093750002e-05 4.3413004574565444e-10
+ 4.3798828125000001e-05 4.3407567870875607e-10
+ 4.381103515625e-05 4.3402132689399754e-10
+ 4.3823242187499998e-05 4.3396699029857563e-10
+ 4.3835449218749997e-05 4.3391266891909689e-10
+ 4.3847656250000002e-05 4.338583627518177e-10
+ 4.3859863281250001e-05 4.338040717927861e-10
+ 4.38720703125e-05 4.3374979603792648e-10
+ 4.3884277343749998e-05 4.3369553548309005e-10
+ 4.3896484374999997e-05 4.3364129012408513e-10
+ 4.3908691406250002e-05 4.3358705995669485e-10
+ 4.3920898437500001e-05 4.3353284497668784e-10
+ 4.393310546875e-05 4.3347864517982436e-10
+ 4.3945312499999998e-05 4.3342446056186068e-10
+ 4.3957519531249997e-05 4.3337029111855061e-10
+ 4.3969726562500002e-05 4.3331613684564742e-10
+ 4.3981933593750001e-05 4.3326199773890431e-10
+ 4.3994140625e-05 4.3320787379407488e-10
+ 4.4006347656249998e-05 4.3315376500691365e-10
+ 4.4018554687499997e-05 4.3309967137317592e-10
+ 4.4030761718750003e-05 4.3304559288861817e-10
+ 4.4042968750000001e-05 4.3299152954899793e-10
+ 4.405517578125e-05 4.3293748135007384e-10
+ 4.4067382812499998e-05 4.3288344828760572e-10
+ 4.4079589843749997e-05 4.3282943035735457e-10
+ 4.4091796875000003e-05 4.3277542755508266e-10
+ 4.4104003906250001e-05 4.327214398765532e-10
+ 4.41162109375e-05 4.3266746731753079e-10
+ 4.4128417968749999e-05 4.3261350987378112e-10
+ 4.4140624999999997e-05 4.3255956754107106e-10
+ 4.4152832031250003e-05 4.3250564031516869e-10
+ 4.4165039062500001e-05 4.324517281918434e-10
+ 4.417724609375e-05 4.3239783116686546e-10
+ 4.4189453124999999e-05 4.3234394923600652e-10
+ 4.4201660156249997e-05 4.3229008239503964e-10
+ 4.4213867187499996e-05 4.322362306397386e-10
+ 4.4226074218750001e-05 4.3218239396587857e-10
+ 4.423828125e-05 4.3212857236923607e-10
+ 4.4250488281249999e-05 4.3207476584558855e-10
+ 4.4262695312499997e-05 4.3202097439071481e-10
+ 4.4274902343750003e-05 4.3196719800039462e-10
+ 4.4287109375000001e-05 4.3191343667040926e-10
+ 4.429931640625e-05 4.3185969039654094e-10
+ 4.4311523437499999e-05 4.3180595917457319e-10
+ 4.4323730468749997e-05 4.3175224300029046e-10
+ 4.4335937500000003e-05 4.3169854186947872e-10
+ 4.4348144531250001e-05 4.3164485577792515e-10
+ 4.43603515625e-05 4.3159118472141752e-10
+ 4.4372558593749999e-05 4.315375286957455e-10
+ 4.4384765624999997e-05 4.3148388769669956e-10
+ 4.4396972656250003e-05 4.3143026172007142e-10
+ 4.4409179687500001e-05 4.3137665076165393e-10
+ 4.442138671875e-05 4.3132305481724119e-10
+ 4.4433593749999999e-05 4.3126947388262849e-10
+ 4.4445800781249997e-05 4.3121590795361226e-10
+ 4.4458007812500003e-05 4.3116235702599014e-10
+ 4.4470214843750002e-05 4.311088210955608e-10
+ 4.4482421875e-05 4.3105530015812432e-10
+ 4.4494628906249999e-05 4.3100179420948178e-10
+ 4.4506835937499998e-05 4.3094830324543561e-10
+ 4.4519042968750003e-05 4.3089482726178914e-10
+ 4.4531250000000002e-05 4.3084136625434698e-10
+ 4.454345703125e-05 4.3078792021891527e-10
+ 4.4555664062499999e-05 4.3073448915130076e-10
+ 4.4567871093749998e-05 4.3068107304731183e-10
+ 4.4580078125000003e-05 4.3062767190275767e-10
+ 4.4592285156250002e-05 4.3057428571344897e-10
+ 4.46044921875e-05 4.305209144751974e-10
+ 4.4616699218749999e-05 4.3046755818381573e-10
+ 4.4628906249999998e-05 4.3041421683511815e-10
+ 4.4641113281250003e-05 4.3036089042491982e-10
+ 4.4653320312500002e-05 4.3030757894903721e-10
+ 4.466552734375e-05 4.3025428240328784e-10
+ 4.4677734374999999e-05 4.3020100078349046e-10
+ 4.4689941406249998e-05 4.3014773408546503e-10
+ 4.4702148437500003e-05 4.3009448230503257e-10
+ 4.4714355468750002e-05 4.3004124543801536e-10
+ 4.47265625e-05 4.2998802348023685e-10
+ 4.4738769531249999e-05 4.2993481642752165e-10
+ 4.4750976562499998e-05 4.298816242756955e-10
+ 4.4763183593750003e-05 4.2982844702058526e-10
+ 4.4775390625000002e-05 4.2977528465801911e-10
+ 4.478759765625e-05 4.2972213718382639e-10
+ 4.4799804687499999e-05 4.296690045938374e-10
+ 4.4812011718749998e-05 4.2961588688388387e-10
+ 4.4824218749999996e-05 4.2956278404979846e-10
+ 4.4836425781250002e-05 4.2950969608741529e-10
+ 4.4848632812500001e-05 4.2945662299256918e-10
+ 4.4860839843749999e-05 4.2940356476109669e-10
+ 4.4873046874999998e-05 4.2935052138883517e-10
+ 4.4885253906249996e-05 4.2929749287162315e-10
+ 4.4897460937500002e-05 4.2924447920530045e-10
+ 4.4909667968750001e-05 4.2919148038570803e-10
+ 4.4921874999999999e-05 4.2913849640868801e-10
+ 4.4934082031249998e-05 4.2908552727008359e-10
+ 4.4946289062499997e-05 4.2903257296573924e-10
+ 4.4958496093750002e-05 4.2897963349150058e-10
+ 4.4970703125000001e-05 4.2892670884321429e-10
+ 4.4982910156249999e-05 4.288737990167283e-10
+ 4.4995117187499998e-05 4.2882090400789185e-10
+ 4.5007324218749997e-05 4.2876802381255504e-10
+ 4.5019531250000002e-05 4.2871515842656934e-10
+ 4.5031738281250001e-05 4.2866230784578723e-10
+ 4.5043945312499999e-05 4.2860947206606246e-10
+ 4.5056152343749998e-05 4.2855665108325002e-10
+ 4.5068359374999997e-05 4.2850384489320595e-10
+ 4.5080566406249995e-05 4.2845105349178732e-10
+ 4.5092773437500001e-05 4.2839827687485269e-10
+ 4.5104980468749999e-05 4.2834551503826145e-10
+ 4.5117187499999998e-05 4.2829276797787439e-10
+ 4.5129394531249997e-05 4.2824003568955333e-10
+ 4.5141601562499995e-05 4.2818731816916134e-10
+ 4.5153808593750001e-05 4.2813461541256231e-10
+ 4.5166015624999999e-05 4.2808192741562203e-10
+ 4.5178222656249998e-05 4.2802925417420679e-10
+ 4.5190429687499997e-05 4.2797659568418397e-10
+ 4.5202636718749995e-05 4.2792395194142275e-10
+ 4.5214843749999994e-05 4.2787132294179297e-10
+ 4.522705078125e-05 4.2781870868116553e-10
+ 4.5239257812499998e-05 4.2776610915541303e-10
+ 4.5251464843749997e-05 4.2771352436040875e-10
+ 4.5263671874999995e-05 4.2766095429202714e-10
+ 4.5275878906249994e-05 4.2760839894614423e-10
+ 4.52880859375e-05 4.2755585831863669e-10
+ 4.5300292968749998e-05 4.2750333240538267e-10
+ 4.5312499999999997e-05 4.2745082120226136e-10
+ 4.5324707031249996e-05 4.2739832470515305e-10
+ 4.5336914062499994e-05 4.273458429099393e-10
+ 4.534912109375e-05 4.2729337581250278e-10
+ 4.5361328124999998e-05 4.2724092340872732e-10
+ 4.5373535156249997e-05 4.2718848569449787e-10
+ 4.5385742187499996e-05 4.2713606266570053e-10
+ 4.5397949218749994e-05 4.2708365431822263e-10
+ 4.541015625e-05 4.270312606479525e-10
+ 4.5422363281249998e-05 4.2697888165077988e-10
+ 4.5434570312499997e-05 4.2692651732259529e-10
+ 4.5446777343749996e-05 4.2687416765929084e-10
+ 4.5458984374999994e-05 4.2682183265675928e-10
+ 4.5471191406249993e-05 4.2676951231089505e-10
+ 4.5483398437499998e-05 4.2671720661759342e-10
+ 4.5495605468749997e-05 4.2666491557275079e-10
+ 4.5507812499999996e-05 4.2661263917226478e-10
+ 4.5520019531249994e-05 4.265603774120343e-10
+ 4.5532226562499993e-05 4.265081302879591e-10
+ 4.5544433593749998e-05 4.2645589779594043e-10
+ 4.5556640624999997e-05 4.2640367993188038e-10
+ 4.5568847656249996e-05 4.2635147669168246e-10
+ 4.5581054687499994e-05 4.2629928807125108e-10
+ 4.5593261718749993e-05 4.2624711406649186e-10
+ 4.5605468749999992e-05 4.2619495467331169e-10
+ 4.5617675781249997e-05 4.2614280988761856e-10
+ 4.5629882812499996e-05 4.2609067970532156e-10
+ 4.5642089843749994e-05 4.2603856412233079e-10
+ 4.5654296874999993e-05 4.2598646313455786e-10
+ 4.5666503906249992e-05 4.2593437673791515e-10
+ 4.5678710937499997e-05 4.2588230492831644e-10
+ 4.5690917968749996e-05 4.2583024770167654e-10
+ 4.5703124999999995e-05 4.2577820505391141e-10
+ 4.5715332031249993e-05 4.2572617698093814e-10
+ 4.5727539062499992e-05 4.2567416347867499e-10
+ 4.5739746093749997e-05 4.2562216454304139e-10
+ 4.5751953124999996e-05 4.2557018016995789e-10
+ 4.5764160156249995e-05 4.2551821035534623e-10
+ 4.5776367187499993e-05 4.2546625509512913e-10
+ 4.5788574218749992e-05 4.254143143852306e-10
+ 4.5800781249999997e-05 4.2536238822157581e-10
+ 4.5812988281249996e-05 4.2531047660009089e-10
+ 4.5825195312499995e-05 4.2525857951670346e-10
+ 4.5837402343749993e-05 4.252066969673418e-10
+ 4.5849609374999992e-05 4.2515482894793579e-10
+ 4.5861816406249991e-05 4.2510297545441604e-10
+ 4.5874023437499996e-05 4.2505113648271467e-10
+ 4.5886230468749995e-05 4.2499931202876474e-10
+ 4.5898437499999993e-05 4.2494750208850055e-10
+ 4.5910644531249992e-05 4.248957066578573e-10
+ 4.5922851562499991e-05 4.2482519493572964e-10
+ 4.5935058593749996e-05 4.2475256100502045e-10
+ 4.5947265624999995e-05 4.2468173951608737e-10
+ 4.5959472656249993e-05 4.2459666096075283e-10
+ 4.5971679687499992e-05 4.2448010616874532e-10
+ 4.5983886718749991e-05 4.242745676347303e-10
+ 4.598999023437499e-05 4.2406762246865748e-10
+ 4.5996093749999989e-05 4.2364446431160585e-10
+ 4.5999145507812496e-05 4.2320637096990359e-10
+ 4.6002197265624995e-05 4.2237081875579266e-10
+ 4.6005249023437495e-05 4.2039912634768696e-10
+ 4.6006606790774087e-05 4.184858057925494e-10
+ 4.600699821666086e-05 4.1769354662518729e-10
+ 4.6007389642547633e-05 4.1673967866159501e-10
+ 4.6008368207264575e-05 4.1328644574257995e-10
+ 4.6009409502908186e-05 4.0647792025774505e-10
+ 4.6009970598735321e-05 4.0009399586852752e-10
+ 4.6010339629298367e-05 3.9400830485401903e-10
+ 4.6011110323815842e-05 3.7217296598144555e-10
+ 4.6011741481233845e-05 3.3482378565862255e-10
+ 4.6012113084009007e-05 2.9476725253157392e-10
+ 4.6012434193795792e-05 2.3913652951300332e-10
+ 4.6012647097925407e-05 2.1273235713088472e-10
+ 4.6012860002055029e-05 2.1207408791108858e-10
+ 4.6014989043351243e-05 2.1185023895337551e-10
+ 4.6027196074601242e-05 2.0757980032582087e-10
+ 4.6039403105851241e-05 1.9827504053149293e-10
+ 4.6051610137101246e-05 1.8447156434439206e-10
+ 4.6063817168351245e-05 1.6696410651490149e-10
+ 4.6076024199601244e-05 1.4676018343964647e-10
+ 4.6088231230851242e-05 1.2502212943217047e-10
+ 4.6100438262101241e-05 1.0300022779102304e-10
+ 4.6112645293351246e-05 8.1960799754197404e-11
+ 4.6124852324601245e-05 6.311338755160194e-11
+ 4.6137059355851244e-05 4.7541218733423125e-11
+ 4.6149266387101242e-05 3.6138949326912032e-11
+ 4.6161473418351241e-05 2.9561263935700322e-11
+ 4.617368044960124e-05 2.8185285811614418e-11
+ 4.6185887480851245e-05 3.2088955187765566e-11
+ 4.6198094512101244e-05 4.1046615499322252e-11
+ 4.6210301543351242e-05 5.4542057385810135e-11
+ 4.6222508574601241e-05 7.1798266491615728e-11
+ 4.623471560585124e-05 9.1822160785597292e-11
+ 4.6246922637101245e-05 1.1346174161334856e-10
+ 4.6259129668351244e-05 1.3547236949090519e-10
+ 4.6271336699601242e-05 1.5658835172212636e-10
+ 4.6283543730851241e-05 1.7559572435646284e-10
+ 4.629575076210124e-05 1.9140204326212496e-10
+ 4.6307957793351238e-05 2.030991720132836e-10
+ 4.6311009551163745e-05 2.0529687447679853e-10
+ 4.631131472694499e-05 2.0549982177660819e-10
+ 4.631207766639812e-05 2.0599366009052315e-10
+ 4.6312459136124682e-05 2.062333046850057e-10
+ 4.6312482977982586e-05 2.0624812098499301e-10
+ 4.6312487746354169e-05 2.0625108196291897e-10
+ 4.6312497283097336e-05 2.0625700163649109e-10
+ 4.6312498046036785e-05 2.0625747507891284e-10
+ 4.6312499571915695e-05 2.0625842190532621e-10
+ 4.6312499693986004e-05 2.0625849764807365e-10
+ 4.6312499938126629e-05 2.0625864913207268e-10
+ 4.6312499957657881e-05 2.0625866125070641e-10
+ 4.6312499996720384e-05 2.0625868548793557e-10
+ 4.6312500074845384e-05 8.3574849775232329e-10
+ 4.6312500152970384e-05 2.8382408459534785e-09
+ 4.631250093422038e-05 9.7910663945931592e-08
+ 4.6312508051845975e-05 6.9281309170090845e-06
+ 4.6312515169471569e-05 2.3496919613390592e-05
+ 4.631252228709717e-05 4.8515586154137975e-05
+ 4.6312529404722764e-05 8.0864107426474553e-05
+ 4.6312536522348359e-05 0.0001195688537478285
+ 4.6312543639973953e-05 0.00016378325676260678
+ 4.6312550757599554e-05 0.00021277103077073492
+ 4.6312557875225148e-05 0.00026589161027525284
+ 4.6312564992850742e-05 0.00032258751106878353
+ 4.6312572110476343e-05 0.00038237336083026571
+ 4.6312579228101938e-05 0.00044482637875059637
+ 4.631258780756857e-05 0.00052313156179263198
+ 4.6312596387035202e-05 0.00060422377214069478
+ 4.6312604966501834e-05 0.00068763160407692863
+ 4.6312613545968466e-05 0.00077295453496090106
+ 4.6312622125435098e-05 0.00085985181282763258
+ 4.631263070490173e-05 0.00094803308914625053
+ 4.6312639284368362e-05 0.0010372505228311898
+ 4.6312647863834994e-05 0.0011272921245865509
+ 4.6312658180770248e-05 0.0012364048498757886
+ 4.6312668497705501e-05 0.0013461799437633384
+ 4.6312678814640762e-05 0.0014563930288477433
+ 4.6312689131576016e-05 0.001566855276772596
+ 4.6312699448511269e-05 0.0016774068636345029
+ 4.631270976544653e-05 0.001787911643031166
+ 4.6312720082381783e-05 0.0018982528107135616
+ 4.6312730399317037e-05 0.0020083293767566338
+ 4.631274290201226e-05 0.002141246780886198
+ 4.6312755404707475e-05 0.0022735106700283729
+ 4.6312767907402698e-05 0.0024050029041599369
+ 4.6312780410097913e-05 0.0025356196305195535
+ 4.6312792912793136e-05 0.0026652683340791378
+ 4.6312805415488351e-05 0.002793865545581445
+ 4.6312817918183574e-05 0.0029213350620943554
+ 4.631283042087879e-05 0.0030476065669750823
+ 4.6312845592253871e-05 0.0031991277392290247
+ 4.6312860763628953e-05 0.0033486794005026179
+ 4.6312875935004034e-05 0.0034961593179601309
+ 4.6312891106379116e-05 0.0036414711081661105
+ 4.631290627775419e-05 0.0037845233735065873
+ 4.6312921449129272e-05 0.0039252290818992874
+ 4.6312936620504353e-05 0.0040635051254073566
+ 4.6312954860519558e-05 0.0042264209820281088
+ 4.6312973100534769e-05 0.0043855785109888799
+ 4.6312991340549973e-05 0.004540852807539594
+ 4.6313009580565184e-05 0.0046921255232483241
+ 4.6313027820580389e-05 0.004839284756390172
+ 4.6313046060595593e-05 0.0049822250059800644
+ 4.6313068199865841e-05 0.0051499118748984281
+ 4.631309033913609e-05 0.0053110729761570875
+ 4.6313112478406345e-05 0.0054655577982168782
+ 4.6313134617676593e-05 0.0056132299331846198
+ 4.6313161293011318e-05 0.0057819364493443522
+ 4.6313187873095806e-05 0.0059398423573548687
+ 4.6313214453180293e-05 0.0060874136176253622
+ 4.6313248688484338e-05 0.0062620603819550135
+ 4.6313282923788383e-05 0.0064191641307141745
+ 4.6313315356127044e-05 0.0065517091134031152
+ 4.6313347788465712e-05 0.0066683776453289999
+ 4.6313380220804374e-05 0.0067692021882621509
+ 4.6313412653143035e-05 0.0068542763543729904
+ 4.6313445085481704e-05 0.0069237529436825757
+ 4.6313477517820365e-05 0.0069778416850672731
+ 4.6313509950159027e-05 0.0070168067033145008
+ 4.6313542382497695e-05 0.0070409637367341727
+ 4.6313569584998147e-05 0.0070500711051410814
+ 4.6313596787498599e-05 0.0070492564131712353
+ 4.631362398999905e-05 0.0070387804986578604
+ 4.6313651192499502e-05 0.0070189238317284377
+ 4.6313678394999961e-05 0.0069899850256677273
+ 4.6313705597500413e-05 0.0069522793135452206
+ 4.6313732800000864e-05 0.0069061369988542495
+ 4.6313760002501323e-05 0.0068519018883273245
+ 4.6313787205001775e-05 0.0067899297149596706
+ 4.6313814407502227e-05 0.0067205865590935169
+ 4.6313841610002679e-05 0.0066442472751925379
+ 4.631386881250313e-05 0.006561293931672073
+ 4.6313896015003589e-05 0.0064721142708494637
+ 4.6313923217504041e-05 0.0063771001957435066
+ 4.6313950420004493e-05 0.0062766462900859356
+ 4.6313977622504951e-05 0.0061711483775146155
+ 4.6314004825005403e-05 0.0060610021255013743
+ 4.6314032027505855e-05 0.0059466016991306979
+ 4.6314059230006307e-05 0.0058283384693926773
+ 4.6314086432506759e-05 0.0057065997804302861
+ 4.6314115300883496e-05 0.0055740309990659331
+ 4.6314144169260234e-05 0.0054384272991202893
+ 4.6314173037636964e-05 0.0053002282345430132
+ 4.6314201906013702e-05 0.0051598626838551204
+ 4.6314230774390439e-05 0.0050177476630414884
+ 4.631425964276717e-05 0.0048742872442221231
+ 4.6314288511143908e-05 0.0047298715812966012
+ 4.6314317379520645e-05 0.0045848760430473451
+ 4.6314346247897376e-05 0.0044396604535071188
+ 4.6314381135166685e-05 0.0042643637747592994
+ 4.6314416022435987e-05 0.0040898203879790361
+ 4.6314449985506048e-05 0.0039211359224094145
+ 4.6314483948576109e-05 0.0037541355090310092
+ 4.6314517911646177e-05 0.0035892460195200843
+ 4.6314551874716238e-05 0.0034268598627977894
+ 4.63145858377863e-05 0.0032673350066711841
+ 4.6314627381082819e-05 0.0030765664536155394
+ 4.6314668924379332e-05 0.0028910852643209248
+ 4.6314710467675845e-05 0.0027113416169293153
+ 4.6314752010972364e-05 0.0025377141992044784
+ 4.63148023225231e-05 0.0023360685105670866
+ 4.6314853125173632e-05 0.0021424443576868821
+ 4.631490392782417e-05 0.001959156496722657
+ 4.6314971607266245e-05 0.0017313192252947558
+ 4.6315039286708319e-05 0.0015222190408349249
+ 4.6315091919396566e-05 0.001372431253814393
+ 4.6315144552084813e-05 0.0012336381966261724
+ 4.6315197184773053e-05 0.0011055447342070166
+ 4.63152498174613e-05 0.00098778684645394604
+ 4.6315297809929101e-05 0.00088906516794052203
+ 4.6315345802396903e-05 0.00079823747715313789
+ 4.6315393794864711e-05 0.00071492972227882204
+ 4.6315441787332513e-05 0.00063875107498295779
+ 4.6315489779800314e-05 0.00056929990178360005
+ 4.6315537261554865e-05 0.00050680910974394439
+ 4.631558474330941e-05 0.00045011010916966049
+ 4.6315632225063961e-05 0.00039881145821643485
+ 4.6315679706818512e-05 0.00035252854906615789
+ 4.6315727188573056e-05 0.00031088653907439246
+ 4.6315774670327607e-05 0.0002735227890958723
+ 4.6315824358583362e-05 0.00023862511600889196
+ 4.6315874046839123e-05 0.00020765025205703798
+ 4.6315923735094878e-05 0.00018023763188315632
+ 4.6315973423350633e-05 0.00015604795426756195
+ 4.6316023111606394e-05 0.0001347637411803884
+ 4.6316072799862149e-05 0.00011608953467670693
+ 4.6316127951386074e-05 9.8086983151495662e-05
+ 4.6316183102909999e-05 8.2620379659707852e-05
+ 4.6316238254433925e-05 6.937830638173144e-05
+ 4.631629340595785e-05 5.8079646203919961e-05
+ 4.6316348557481782e-05 4.8471998343402797e-05
+ 4.6316411640520541e-05 3.9267448447275403e-05
+ 4.6316474723559299e-05 3.1683839518460041e-05
+ 4.6316537806598058e-05 2.5463033689023789e-05
+ 4.6316600889636817e-05 2.0382309617297274e-05
+ 4.6316674140146425e-05 1.5662206653736814e-05
+ 4.6316747390656032e-05 1.1971024407425274e-05
+ 4.631682064116564e-05 9.101093726216712e-06
+ 4.6316905619421585e-05 6.5781195004269459e-06
+ 4.6316990597677523e-05 4.7207090840830405e-06
+ 4.6317093836844786e-05 3.1245246960755978e-06
+ 4.631719817176941e-05 2.0371887602864823e-06
+ 4.6317302506694042e-05 1.3141391771344707e-06
+ 4.631742666446916e-05 7.6923430377838728e-07
+ 4.6317550822244286e-05 4.435788450454647e-07
+ 4.631770580080653e-05 2.1851475951109054e-07
+ 4.6317884937131783e-05 9.3708673373505121e-08
+ 4.6318098556602386e-05 3.2883700516734768e-08
+ 4.6318364485722955e-05 8.5309004428172277e-09
+ 4.6318717982712203e-05 1.4552417250701691e-09
+ 4.6319242097564145e-05 3.0578689270965244e-10
+ 4.6320136340120472e-05 2.4569663308855879e-10
+ 4.6322132807185037e-05 2.4259754686171839e-10
+ 4.6323988816858015e-05 2.4182034068072913e-10
+ 4.6326421668443079e-05 2.4138174969930913e-10
+ 4.6328854520028143e-05 2.4076582964276258e-10
+ 4.6331287371613208e-05 2.4012576594620444e-10
+ 4.6333720223198272e-05 2.4057963384973803e-10
+ 4.6336153074783329e-05 2.4092919901400983e-10
+ 4.6338585926368394e-05 2.401872610697499e-10
+ 4.6341018777953458e-05 2.3987554496708928e-10
+ 4.6343451629538522e-05 2.4037942571475707e-10
+ 4.6345767705239777e-05 2.4025247901632375e-10
+ 4.6348819440406715e-05 2.4017887589128354e-10
+ 4.635187117557366e-05 2.4009951114703349e-10
+ 4.6354922910740598e-05 2.4004351142745323e-10
+ 4.6357974645907537e-05 2.4016098617015712e-10
+ 4.6361026381074475e-05 2.4071442426522539e-10
+ 4.6364078116241413e-05 2.3968616681674537e-10
+ 4.63677736187736e-05 2.4003007462135484e-10
+ 4.6371134288610905e-05 2.4006402385879101e-10
+ 4.6374494958448217e-05 2.4006047129867007e-10
+ 4.637862073169028e-05 2.4005210497337081e-10
+ 4.6382746504932337e-05 2.4004042399080182e-10
+ 4.6386872278174393e-05 2.4003044384477591e-10
+ 4.6390998051416456e-05 2.4003749578386358e-10
+ 4.6395123824658513e-05 2.4008180521387353e-10
+ 4.6400251138437096e-05 2.4016443526047099e-10
+ 4.6405378452215679e-05 2.3985136550844345e-10
+ 4.6410505765994262e-05 2.3994252727381691e-10
+ 4.6415633079772845e-05 2.4004700010028028e-10
+ 4.6421995979825152e-05 2.4004483697536087e-10
+ 4.6428358879877459e-05 2.3997024527683999e-10
+ 4.6434721779929766e-05 2.3997592655072043e-10
+ 4.644249725625451e-05 2.4000749931504923e-10
+ 4.6450272732579248e-05 2.4001269631983051e-10
+ 4.6458048208903993e-05 2.3999782508278659e-10
+ 4.6467983441936069e-05 2.3999355892689472e-10
+ 4.6477918674968138e-05 2.4000179472492324e-10
+ 4.6490125706218144e-05 2.4000339716614338e-10
+ 4.6502332737468142e-05 2.3999888202599127e-10
+ 4.6514539768718141e-05 2.3999830525938688e-10
+ 4.652674679996814e-05 2.4000037974237526e-10
+ 4.6538953831218138e-05 2.4000087414852165e-10
+ 4.6551160862468144e-05 2.3999993966201389e-10
+ 4.6563367893718142e-05 2.3999960494882817e-10
+ 4.6575574924968141e-05 2.4000001432309894e-10
+ 4.658778195621814e-05 2.4000021737723387e-10
+ 4.6599988987468138e-05 2.4000004462513988e-10
+ 4.6612196018718137e-05 2.3999993006727966e-10
+ 4.6624403049968142e-05 2.3999999917748096e-10
+ 4.6636610081218141e-05 2.4000006049017395e-10
+ 4.664881711246814e-05 2.4000003421757239e-10
+ 4.6661024143718138e-05 2.4000000237870328e-10
+ 4.6673231174968137e-05 2.4000001256652595e-10
+ 4.6685438206218142e-05 2.4000002745854788e-10
+ 4.6697645237468141e-05 2.4000002475271839e-10
+ 4.670985226871814e-05 2.4000001795384735e-10
+ 4.6722059299968138e-05 2.400000173879749e-10
+ 4.6734266331218137e-05 2.4000002070407596e-10
+ 4.6746473362468143e-05 2.4000002067419452e-10
+ 4.6758680393718141e-05 2.4000001976473751e-10
+ 4.677088742496814e-05 2.40000019362722e-10
+ 4.6783094456218139e-05 2.4000002028128461e-10
+ 4.6795301487468137e-05 2.4000002060646208e-10
+ 4.6807508518718143e-05 2.4000002008287723e-10
+ 4.6819715549968141e-05 2.4000001934276911e-10
+ 4.683192258121814e-05 2.4000001968966948e-10
+ 4.6844129612468139e-05 2.4000002093381111e-10
+ 4.6856336643718137e-05 2.4000001965726013e-10
+ 4.6868543674968136e-05 2.4000001961507071e-10
+ 4.6880750706218141e-05 2.4000002048512451e-10
+ 4.689295773746814e-05 2.4000001998121006e-10
+ 4.6905164768718139e-05 2.400000199764228e-10
+ 4.6917371799968137e-05 2.4000001998665694e-10
+ 4.6929578831218136e-05 2.4000001988395378e-10
+ 4.6941785862468141e-05 2.4000001969840786e-10
+ 4.695399289371814e-05 2.4000001962628526e-10
+ 4.6966199924968139e-05 2.4000001985975601e-10
+ 4.6978406956218137e-05 2.4000001994562599e-10
+ 4.6990613987468136e-05 2.4000001873790616e-10
+ 4.7002821018718135e-05 2.400000206888198e-10
+ 4.701502804996814e-05 2.4000002115772409e-10
+ 4.7027235081218139e-05 2.4000001926167516e-10
+ 4.7039442112468137e-05 2.4000001865095655e-10
+ 4.7051649143718136e-05 2.4000002024868279e-10
+ 4.7063856174968135e-05 2.4000002062807212e-10
+ 4.707606320621814e-05 2.4000001971246058e-10
+ 4.7088270237468139e-05 2.4000001913611468e-10
+ 4.7100477268718137e-05 2.4000001939609548e-10
+ 4.7112684299968136e-05 2.4000001928925776e-10
+ 4.7124891331218135e-05 2.4000002036211893e-10
+ 4.713709836246814e-05 2.4000001948566678e-10
+ 4.7149305393718139e-05 2.40000020557049e-10
+ 4.7161512424968138e-05 2.400000203491446e-10
+ 4.7173719456218136e-05 2.4000001961720044e-10
+ 4.7185926487468135e-05 2.400000200808237e-10
+ 4.719813351871814e-05 2.4000002006495584e-10
+ 4.7210340549968139e-05 2.4000001941755901e-10
+ 4.7222547581218138e-05 2.4000001925514504e-10
+ 4.7234754612468136e-05 2.4000001949494439e-10
+ 4.7246961643718135e-05 2.4000001987457185e-10
+ 4.7259168674968134e-05 2.4000001956535886e-10
+ 4.7271375706218139e-05 2.4000001976899341e-10
+ 4.7283582737468138e-05 2.4000001989767335e-10
+ 4.7295789768718136e-05 2.4000002010421042e-10
+ 4.7307996799968135e-05 2.4000002031692612e-10
+ 4.7320203831218134e-05 2.4000001943796074e-10
+ 4.7332410862468139e-05 2.4000001979057998e-10
+ 4.7344617893718138e-05 2.4000001994141042e-10
+ 4.7356824924968136e-05 2.4000001910787902e-10
+ 4.7369031956218135e-05 2.4000002014157438e-10
+ 4.7381238987468134e-05 2.4000002007976212e-10
+ 4.7393446018718132e-05 2.4000001897875313e-10
+ 4.7405653049968138e-05 2.4000002030066949e-10
+ 4.7417860081218136e-05 2.4000002070432142e-10
+ 4.7430067112468135e-05 2.4000001950520541e-10
+ 4.7442274143718134e-05 2.4000001947980057e-10
+ 4.7454481174968132e-05 2.4000002027253361e-10
+ 4.7466688206218138e-05 2.40000020609859e-10
+ 4.7478895237468136e-05 2.4000001911322354e-10
+ 4.7491102268718135e-05 2.4000001969739074e-10
+ 4.7503309299968134e-05 2.4000002073053612e-10
+ 4.7515516331218132e-05 2.4000001994814067e-10
+ 4.7527723362468138e-05 2.4000001923239209e-10
+ 4.7539930393718136e-05 2.4000002015288261e-10
+ 4.7552137424968135e-05 2.4000001930210656e-10
+ 4.7564344456218134e-05 2.4000001837686493e-10
+ 4.7576551487468132e-05 2.4000001946449939e-10
+ 4.7588758518718138e-05 2.4000002038326192e-10
+ 4.7600965549968137e-05 2.400000203109469e-10
+ 4.7613172581218135e-05 2.400000203952259e-10
+ 4.7625379612468134e-05 2.4000001970496741e-10
+ 4.7637586643718139e-05 2.4000001924454606e-10
+ 4.7649793674968138e-05 2.4000001905466872e-10
+ 4.7662000706218137e-05 2.400000204518705e-10
+ 4.7674207737468135e-05 2.4000002011557764e-10
+ 4.7686414768718141e-05 2.4000001946831419e-10
+ 4.7698621799968139e-05 2.4000001925940771e-10
+ 4.7710828831218138e-05 2.4000001980987061e-10
+ 4.7723035862468137e-05 2.4000002089319245e-10
+ 4.7735242893718142e-05 2.4000001973823067e-10
+ 4.7747449924968141e-05 2.4000001879346328e-10
+ 4.7759656956218139e-05 2.4000001869932423e-10
+ 4.7771863987468138e-05 2.4000002074828773e-10
+ 4.7784071018718143e-05 2.4000001934026167e-10
+ 4.7796278049968142e-05 2.4000001952115826e-10
+ 4.7808485081218141e-05 2.4000001987859593e-10
+ 4.7820692112468139e-05 2.400000198982881e-10
+ 4.7832899143718145e-05 2.40000018977687e-10
+ 4.7845106174968144e-05 2.4000001970468766e-10
+ 4.7857313206218142e-05 2.4000001969944985e-10
+ 4.7869520237468141e-05 2.4000002027367879e-10
+ 4.7881727268718146e-05 2.4000001840031488e-10
+ 4.7893934299968145e-05 2.4000001957318321e-10
+ 4.7906141331218144e-05 2.400000188108562e-10
+ 4.7918348362468142e-05 2.4000002046679305e-10
+ 4.7930555393718148e-05 2.4000001950571268e-10
+ 4.7942762424968146e-05 2.4000001838116472e-10
+ 4.7954969456218145e-05 2.4000001853089837e-10
+ 4.7967176487468144e-05 2.4000002004811227e-10
+ 4.7979383518718149e-05 2.4000001966057371e-10
+ 4.7991590549968148e-05 2.4000001941089245e-10
+ 4.8003797581218146e-05 2.4000001913185568e-10
+ 4.8016004612468145e-05 2.4000001954838558e-10
+ 4.802821164371815e-05 2.4000001920964592e-10
+ 4.8040418674968149e-05 2.4000001943469307e-10
+ 4.8052625706218148e-05 2.4000001866641258e-10
+ 4.8064832737468146e-05 2.4000002020897109e-10
+ 4.8077039768718152e-05 2.4000001940179987e-10
+ 4.8089246799968151e-05 2.4000001993507329e-10
+ 4.8101453831218149e-05 2.4000002008198123e-10
+ 4.8113660862468148e-05 2.400000198005213e-10
+ 4.8125867893718153e-05 2.4000001916301211e-10
+ 4.8138074924968152e-05 2.4000001960280073e-10
+ 4.8150281956218151e-05 2.4000001963117276e-10
+ 4.8162488987468149e-05 2.400000196254434e-10
+ 4.8174696018718155e-05 2.4000002030623543e-10
+ 4.8186903049968153e-05 2.4000001985486468e-10
+ 4.8199110081218152e-05 2.4000001975560508e-10
+ 4.8211317112468151e-05 2.4000002002563028e-10
+ 4.8223524143718156e-05 2.4000001880683233e-10
+ 4.8235731174968155e-05 2.400000186107882e-10
+ 4.8247938206218153e-05 2.4000002026174485e-10
+ 4.8260145237468152e-05 2.4000001964579944e-10
+ 4.8272352268718157e-05 2.4000001869414737e-10
+ 4.8284559299968156e-05 2.4000002024855297e-10
+ 4.8296766331218155e-05 2.4000001886895933e-10
+ 4.8308973362468153e-05 2.4000001996539064e-10
+ 4.8321180393718159e-05 2.4000001852201533e-10
+ 4.8333387424968158e-05 2.4000001995376353e-10
+ 4.8345594456218156e-05 2.4000001885033681e-10
+ 4.8357801487468155e-05 2.400000202275795e-10
+ 4.837000851871816e-05 2.4000001938682899e-10
+ 4.8382215549968159e-05 2.400000185286626e-10
+ 4.8394422581218158e-05 2.4000002021567022e-10
+ 4.8406629612468156e-05 2.4000001929093104e-10
+ 4.8418836643718162e-05 2.4000001945502139e-10
+ 4.843104367496816e-05 2.4000001849176264e-10
+ 4.8443250706218159e-05 2.4000001899160695e-10
+ 4.8455457737468158e-05 2.4000001908469775e-10
+ 4.8467664768718163e-05 2.4000002021320925e-10
+ 4.8479871799968162e-05 2.4000001986077044e-10
+ 4.849207883121816e-05 2.4000001985660228e-10
+ 4.8504285862468159e-05 2.4000001982734366e-10
+ 4.8516492893718164e-05 2.4000001909394165e-10
+ 4.8528699924968163e-05 2.4000001971428865e-10
+ 4.8540906956218162e-05 2.4000001921042243e-10
+ 4.855311398746816e-05 2.400000190589926e-10
+ 4.8565321018718166e-05 2.400000192770844e-10
+ 4.8577528049968165e-05 2.4000001876027354e-10
+ 4.8589735081218163e-05 2.4000001963225885e-10
+ 4.8601942112468162e-05 2.4000001898595255e-10
+ 4.8614149143718167e-05 2.4000001876650681e-10
+ 4.8626356174968166e-05 2.4000001955479303e-10
+ 4.8638563206218165e-05 2.400000192149284e-10
+ 4.8650770237468163e-05 2.4000001962818762e-10
+ 4.8662977268718169e-05 2.400000192259498e-10
+ 4.8675184299968167e-05 2.4000001958046752e-10
+ 4.8687391331218166e-05 2.4000001876653049e-10
+ 4.8699598362468165e-05 2.4000001901679062e-10
+ 4.871180539371817e-05 2.4000001929188411e-10
+ 4.8724012424968169e-05 2.4000001878460593e-10
+ 4.8736219456218167e-05 2.4000001895149019e-10
+ 4.8748426487468166e-05 2.4000001953324466e-10
+ 4.8760633518718171e-05 2.4000001930179932e-10
+ 4.877284054996817e-05 2.4000001867284628e-10
+ 4.8785047581218169e-05 2.4000001876404646e-10
+ 4.8797254612468167e-05 2.4000001844012502e-10
+ 4.8809461643718173e-05 2.4000001847700822e-10
+ 4.8821668674968172e-05 2.4000001848915366e-10
+ 4.883387570621817e-05 2.4000001847211049e-10
+ 4.8846082737468169e-05 2.4000001842583542e-10
+ 4.8858289768718174e-05 2.4000001874485954e-10
+ 4.8870496799968173e-05 2.4000001864470591e-10
+ 4.8882703831218172e-05 2.400000192645186e-10
+ 4.889491086246817e-05 2.4000001911011029e-10
+ 4.8907117893718176e-05 2.400000189594016e-10
+ 4.8919324924968174e-05 2.4000001834385696e-10
+ 4.8931531956218173e-05 2.4000001923683012e-10
+ 4.8943738987468172e-05 2.4000002008098464e-10
+ 4.8955946018718177e-05 2.400000183211859e-10
+ 4.8968153049968176e-05 2.4000001983070817e-10
+ 4.8980360081218174e-05 2.4000001841550595e-10
+ 4.8992567112468173e-05 2.4000001987140726e-10
+ 4.9004774143718178e-05 2.4000001839799459e-10
+ 4.9016981174968177e-05 2.4000001979564812e-10
+ 4.9029188206218176e-05 2.4000001826400317e-10
+ 4.9041395237468174e-05 2.3996544537098469e-10
+ 4.905360226871818e-05 2.3996256464191007e-10
+ 4.9065809299968178e-05 2.3996062147298765e-10
+ 4.9078016331218177e-05 2.399538992151035e-10
+ 4.9090223362468176e-05 2.3990864356794482e-10
+ 4.9102430393718181e-05 2.3980391697569448e-10
+ 4.911463742496818e-05 2.3960325885649169e-10
+ 4.9120740940593179e-05 2.3930636780140344e-10
+ 4.9126844456218179e-05 2.3825018349924986e-10
+ 4.9129896214030678e-05 2.3664385617022961e-10
+ 4.9132947971843178e-05 2.313460144418538e-10
+ 4.9134473850749431e-05 2.2273712950258841e-10
+ 4.9135999729655678e-05 1.9502932447418286e-10
+ 4.9136991106889184e-05 1.3263414891107653e-10
+ 4.9137269733896244e-05 9.5672269136980181e-11
+ 4.9137548360903296e-05 4.6113023016783446e-11
+ 4.9138098835627971e-05 4.077304569289076e-11
+ 4.9140875273912438e-05 4.2347131994264368e-11
+ 4.9153082305162436e-05 4.4733371018365243e-11
+ 4.9165289336412435e-05 5.3058719093237963e-11
+ 4.9177496367662434e-05 6.5249849962529414e-11
+ 4.9189703398912432e-05 8.0586557341896391e-11
+ 4.9201910430162438e-05 9.8186059694000248e-11
+ 4.9214117461412436e-05 1.1703587328666208e-10
+ 4.9226324492662435e-05 1.3605185310399104e-10
+ 4.9238531523912441e-05 1.5414054504639482e-10
+ 4.9250738555162439e-05 1.7026206156240515e-10
+ 4.9262945586412438e-05 1.8348986297121229e-10
+ 4.9275152617662437e-05 1.9306400774952091e-10
+ 4.9287359648912435e-05 1.9843481134517081e-10
+ 4.9299566680162441e-05 1.9929440536940058e-10
+ 4.9311773711412439e-05 1.9559438520732841e-10
+ 4.9323980742662438e-05 1.8754853451668201e-10
+ 4.9336187773912443e-05 1.7562047328816539e-10
+ 4.9348394805162442e-05 1.6049694315998822e-10
+ 4.9360601836412441e-05 1.4304826930135124e-10
+ 4.9372808867662439e-05 1.2427827523140709e-10
+ 4.9385015898912438e-05 1.052665328361379e-10
+ 4.9397222930162443e-05 8.7106269937226752e-11
+ 4.9409429961412442e-05 7.0841506734532094e-11
+ 4.9421636992662441e-05 5.7407035899497847e-11
+ 4.9433844023912446e-05 4.7574696846103914e-11
+ 4.9436895781724939e-05 4.5750674856066197e-11
+ 4.9437048369615565e-05 4.5666462612461995e-11
+ 4.9437429839342133e-05 4.5458870923120094e-11
+ 4.9437467986314788e-05 4.5438342991126504e-11
+ 4.9437475615709321e-05 4.5434242455099145e-11
+ 4.9437490874498378e-05 4.5426046434154427e-11
+ 4.9437496978014007e-05 4.5422769911655126e-11
+ 4.9437499419420256e-05 4.542145960441293e-11
+ 4.9437499604455782e-05 4.5421360302533612e-11
+ 4.9437499974526835e-05 4.5421161701746532e-11
+ 4.9437500714668947e-05 5.7234708751505077e-08
+ 4.943750145481106e-05 2.3609835104101694e-07
+ 4.9437508856232143e-05 8.3378657603255145e-06
+ 4.9437516257653239e-05 2.6804211983519737e-05
+ 4.9437523659074322e-05 5.4212572160978158e-05
+ 4.9437531060495419e-05 8.9333429400249197e-05
+ 4.9437538461916502e-05 0.00013110387761772142
+ 4.9437547512355685e-05 0.00018988604042548046
+ 4.9437556562794869e-05 0.000255812068272275
+ 4.9437565613234046e-05 0.00032768193023753725
+ 4.9437574663673229e-05 0.00040448949601993325
+ 4.9437583714112413e-05 0.00048539058840956265
+ 4.9437595044533512e-05 0.00059137048504824714
+ 4.943760637495461e-05 0.00070151686849491022
+ 4.9437617705375708e-05 0.0008149054011463608
+ 4.9437629035796807e-05 0.00093078918228233572
+ 4.9437643214653362e-05 0.0010784080416500865
+ 4.9437657393509916e-05 0.0012280520970111633
+ 4.9437671572366471e-05 0.0013789889014004875
+ 4.9437689032396936e-05 0.0015657925325384681
+ 4.9437706492427394e-05 0.0017528666320927736
+ 4.9437723952457858e-05 0.0019395804048633696
+ 4.9437746268477828e-05 0.0021769293571718938
+ 4.9437768584497798e-05 0.0024120996791847497
+ 4.9437790900517768e-05 0.0026444704336099976
+ 4.9437819090217237e-05 0.0029332237971511233
+ 4.9437847279916713e-05 0.0032158629328255771
+ 4.9437875469616182e-05 0.0034916668520790159
+ 4.9437903659315652e-05 0.0037599988278231356
+ 4.9437931849015121e-05 0.0040202830355208904
+ 4.943796003871459e-05 0.0042719918874605982
+ 4.9437988228414059e-05 0.0045146394015623476
+ 4.9438019414106468e-05 0.0047719795450323309
+ 4.9438050599798884e-05 0.0050171295125712645
+ 4.9438081785491292e-05 0.0052495906087394869
+ 4.9438112971183708e-05 0.0054689190353913904
+ 4.9438150418414334e-05 0.0057143885297757718
+ 4.9438187865644966e-05 0.0059397992525804574
+ 4.9438225312875599e-05 0.006144702220679193
+ 4.9438270844195809e-05 0.0063657430322260553
+ 4.9438316375516019e-05 0.0065556175023236875
+ 4.9438361906836236e-05 0.0067142112673811444
+ 4.9438407438156445e-05 0.0068416534980290083
+ 4.9438441084028111e-05 0.0069160175765833089
+ 4.9438474729899776e-05 0.0069737900261410465
+ 4.9438508375771442e-05 0.0070152594941248576
+ 4.9438542021643107e-05 0.0070407746969006688
+ 4.9438575667514773e-05 0.007050740823760393
+ 4.9438609313386438e-05 0.0070456156939712805
+ 4.9438642959258104e-05 0.007025905702338452
+ 4.9438676605129769e-05 0.0069921615895264296
+ 4.9438710251001435e-05 0.0069449740739896257
+ 4.9438736870668145e-05 0.006898526876910809
+ 4.9438763490334855e-05 0.0068443802044164921
+ 4.9438790110001564e-05 0.0067828688534493494
+ 4.9438816729668281e-05 0.0067143369242957376
+ 4.9438843349334991e-05 0.0066391364097472113
+ 4.9438869969001701e-05 0.0065576257964309343
+ 4.9438896588668411e-05 0.0064701686843428533
+ 4.9438923208335121e-05 0.0063771324303375145
+ 4.9438949828001831e-05 0.0062788868210215225
+ 4.9438976447668541e-05 0.0061758027801676225
+ 4.943900306733525e-05 0.0060682511154162089
+ 4.943902968700196e-05 0.0059566013086644297
+ 4.9439056306668677e-05 0.0058412203541628417
+ 4.9439082926335387e-05 0.0057224716479485063
+ 4.9439109546002097e-05 0.0056007139318451742
+ 4.9439136165668807e-05 0.0054763002948580381
+ 4.9439162785335517e-05 0.0053495772343856614
+ 4.9439189405002227e-05 0.0052208837792675896
+ 4.9439216024668936e-05 0.0050905506764474901
+ 4.9439239404935226e-05 0.0049749804171373225
+ 4.9439262785201516e-05 0.0048586054363550972
+ 4.9439286165467806e-05 0.0047416314482211135
+ 4.9439309545734089e-05 0.0046242577652878883
+ 4.9439332926000379e-05 0.0045066770343838705
+ 4.9439356306266669e-05 0.0043890750025309139
+ 4.9439379686532959e-05 0.0042716303126259531
+ 4.9439403066799242e-05 0.0041545143284691553
+ 4.9439426447065532e-05 0.0040378909886185305
+ 4.9439449827331822e-05 0.0039219166884552218
+ 4.9439473207598112e-05 0.0038067401897542695
+ 4.9439496587864395e-05 0.0036925025569730643
+ 4.9439519968130685e-05 0.0035793371193940525
+ 4.9439543348396975e-05 0.0034673694581895016
+ 4.9439566728663265e-05 0.0033567174174145066
+ 4.9439590108929548e-05 0.0032474911378798247
+ 4.9439613489195838e-05 0.0031397931128086067
+ 4.9439636869462128e-05 0.0030337182641405314
+ 4.9439660249728417e-05 0.0029293540383132049
+ 4.9439683629994701e-05 0.0028267805203238136
+ 4.943970701026099e-05 0.0027260705648536779
+ 4.9439735591237518e-05 0.0026055855381113117
+ 4.9439764172214038e-05 0.0024880893416989024
+ 4.9439792753190565e-05 0.0023736731389782805
+ 4.9439821334167086e-05 0.0022624136400195647
+ 4.9439849915143613e-05 0.0021543736566158275
+ 4.9439886199806211e-05 0.0020219271947776738
+ 4.9439925453373378e-05 0.0018846580284455387
+ 4.9439946977215264e-05 0.0018120618774395494
+ 4.94399736967147e-05 0.0017245821083065652
+ 4.9440000416214136e-05 0.0016400258203643724
+ 4.9440027135713572e-05 0.0015583844444338579
+ 4.9440053855213008e-05 0.0014796423351417674
+ 4.9440080574712444e-05 0.0014037772468436488
+ 4.944010729421188e-05 0.0013307608065583204
+ 4.9440134013711316e-05 0.0012605589819463642
+ 4.9440160733210752e-05 0.0011931325425094006
+ 4.9440187452710188e-05 0.0011284375123336611
+ 4.9440214172209624e-05 0.0010664256128491564
+ 4.9440240891709061e-05 0.0010070446942234952
+ 4.9440262548859607e-05 0.00096080661895637035
+ 4.9440284206010161e-05 0.0009162294538821239
+ 4.9440305863160714e-05 0.00087328092606094238
+ 4.9440327520311267e-05 0.00083192771752318962
+ 4.9440349177461821e-05 0.00079213559354230647
+ 4.9440370834612368e-05 0.00075386952625768001
+ 4.9440392491762921e-05 0.00071709381353394315
+ 4.9440414148913474e-05 0.00068177219296354193
+ 4.9440435806064021e-05 0.00064786795094112185
+ 4.9440457463214575e-05 0.00061534402675914772
+ 4.9440479120365128e-05 0.00058416311167918647
+ 4.9440496765399603e-05 0.00055972551886932095
+ 4.9440514410434077e-05 0.00053613426244406741
+ 4.9440532055468552e-05 0.00051336904748169171
+ 4.9440549700503026e-05 0.00049140960981622914
+ 4.9440567345537494e-05 0.00047023574348777509
+ 4.9440584990571969e-05 0.00044982732676715286
+ 4.9440602635606444e-05 0.00043016434677204047
+ 4.9440620280640918e-05 0.00041122692269401575
+ 4.9440637925675393e-05 0.00039299532765819798
+ 4.9440655570709867e-05 0.00037545000923921415
+ 4.9440673215744342e-05 0.00035857160865911174
+ 4.944069086077881e-05 0.00034234097869457157
+ 4.9440708505813284e-05 0.00032673920032235228
+ 4.9440726150847759e-05 0.00031174759813332067
+ 4.9440743795882234e-05 0.00029734775454669758
+ 4.9440761440916708e-05 0.00028352152285727745
+ 4.9440779085951183e-05 0.0002702510391493668
+ 4.9440796730985657e-05 0.00025751873311203796
+ 4.9440814376020132e-05 0.00024530733779101174
+ 4.9440832021054607e-05 0.00023359989831307307
+ 4.9440849666089075e-05 0.00022237977961939102
+ 4.9440867311123549e-05 0.00021163067324446447
+ 4.9440884956158024e-05 0.00020133660317765155
+ 4.9440902601192498e-05 0.00019148193084437179
+ 4.9440920246226973e-05 0.00018205135924409671
+ 4.9440937891261448e-05 0.00017302993628217709
+ 4.9440955536295922e-05 0.00016440305733239472
+ 4.944097318133039e-05 0.00015615646706688136
+ 4.9440990826364865e-05 0.00014827626058972067
+ 4.9441008471399339e-05 0.00014074888391014853
+ 4.9441026116433814e-05 0.00013356113379079491
+ 4.9441043761468289e-05 0.00012670015700587552
+ 4.9441061406502763e-05 0.00012015344904364461
+ 4.9441079051537238e-05 0.00011390885228677083
+ 4.9441096696571712e-05 0.00010795455370359766
+ 4.9441114341606187e-05 0.00010227908208250491
+ 4.9441131986640655e-05 9.687130484080241e-05
+ 4.9441149631675129e-05 9.1720424438765868e-05
+ 4.9441167276709604e-05 8.6815974428572379e-05
+ 4.9441184921744079e-05 8.2147815167013072e-05
+ 4.9441202566778553e-05 7.7706129219957601e-05
+ 4.9441220211813028e-05 7.3481416485622882e-05
+ 4.9441237856847503e-05 6.9464489062760908e-05
+ 4.944125550188197e-05 6.5646465888930612e-05
+ 4.9441273146916445e-05 6.2018767173060703e-05
+ 4.944129079195092e-05 5.8573108645546759e-05
+ 4.9441308436985394e-05 5.5301495648160228e-05
+ 4.9441326082019869e-05 5.2196217085081444e-05
+ 4.9441343727054343e-05 4.9249839255407143e-05
+ 4.9441361372088818e-05 4.6455199586526805e-05
+ 4.9441379017123293e-05 4.3805400286814076e-05
+ 4.9441396662157767e-05 4.1293801935142287e-05
+ 4.9441414307192235e-05 3.8914017023807698e-05
+ 4.944143195222671e-05 3.6659903470533496e-05
+ 4.9441449597261184e-05 3.4525558114332587e-05
+ 4.9441467242295659e-05 3.2505310209129923e-05
+ 4.9441484887330134e-05 3.0593714928186798e-05
+ 4.9441502532364608e-05 2.878554689153125e-05
+ 4.9441520177399083e-05 2.7075793727781893e-05
+ 4.9441537822433551e-05 2.5459649680957857e-05
+ 4.9441555467468025e-05 2.3932509272096093e-05
+ 4.94415731125025e-05 2.2489961024749567e-05
+ 4.9441590757536974e-05 2.1127781262716843e-05
+ 4.9441608402571449e-05 1.9841927987655173e-05
+ 4.9441626047605924e-05 1.8628534843556469e-05
+ 4.9441643692640398e-05 1.7483905174418017e-05
+ 4.9441661337674873e-05 1.6404506180818473e-05
+ 4.9441682620107578e-05 1.5184596516820046e-05
+ 4.9441702745281675e-05 1.4108722156777394e-05
+ 4.9441722870455778e-05 1.3103783271809466e-05
+ 4.9441742995629881e-05 1.2165512099818384e-05
+ 4.9441763120803985e-05 1.1289867233639744e-05
+ 4.9441783245978088e-05 1.0473023791237365e-05
+ 4.9441803371152192e-05 9.711363860421274e-06
+ 4.9441823496326295e-05 9.0014672215583367e-06
+ 4.9441843621500392e-05 8.3401023506671107e-06
+ 4.9441863746674495e-05 7.7242177042852387e-06
+ 4.9441888110746128e-05 7.0353574872189284e-06
+ 4.9441912474817754e-05 6.4041509733236313e-06
+ 4.944193683888938e-05 5.8261375978047346e-06
+ 4.9441961202961005e-05 5.2971679183216326e-06
+ 4.9441985567032638e-05 4.8133849648221628e-06
+ 4.9442009931104264e-05 4.3712064413582404e-06
+ 4.944203429517589e-05 3.9673077642003495e-06
+ 4.9442058659247515e-05 3.5986059186122073e-06
+ 4.9442083023319148e-05 3.2622441148827113e-06
+ 4.9442107387390774e-05 2.955577222710442e-06
+ 4.9442136719683567e-05 2.6223173518557521e-06
+ 4.944216605197636e-05 2.3246430183300364e-06
+ 4.944219538426916e-05 2.0589938235170389e-06
+ 4.9442224716561953e-05 1.8221375097881734e-06
+ 4.9442254048854746e-05 1.6111428978970881e-06
+ 4.9442283381147539e-05 1.4233547079677823e-06
+ 4.9442312713440339e-05 1.2563701699769522e-06
+ 4.9442342045733132e-05 1.1080173307665688e-06
+ 4.9442377848029197e-05 9.4935328593955194e-07
+ 4.9442412335454631e-05 8.1703614317247063e-07
+ 4.9442446822880059e-05 7.0231034037170861e-07
+ 4.9442481310305493e-05 6.0295931014601184e-07
+ 4.9442515797730928e-05 5.1702814794412422e-07
+ 4.9442557828321206e-05 4.2796498791424164e-07
+ 4.9442599858911484e-05 3.5358466304975593e-07
+ 4.9442641889501762e-05 2.9157919961691281e-07
+ 4.9442683920092046e-05 2.3998333476715486e-07
+ 4.9442725950682324e-05 1.9712710629082681e-07
+ 4.9442777518503423e-05 1.5442331314774624e-07
+ 4.9442828186666482e-05 1.2110746118199679e-07
+ 4.944287885482954e-05 9.4668212428266369e-08
+ 4.9442929522992599e-05 7.3741045625230226e-08
+ 4.9442993215143463e-05 5.3572482382509411e-08
+ 4.9443056907294328e-05 3.8650410566722333e-08
+ 4.9443120599445192e-05 2.7655607125139506e-08
+ 4.9443198945610712e-05 1.80624388894615e-08
+ 4.944327865764969e-05 1.1455385675920075e-08
+ 4.9443358369688668e-05 7.0279116712338033e-09
+ 4.9443461292370764e-05 3.42722610432318e-09
+ 4.944356950890982e-05 1.2415251844169095e-09
+ 4.9443701914804438e-05 -1.7423168879043324e-10
+ 4.944384706503018e-05 -9.0046498724308251e-10
+ 4.9444034315235681e-05 -1.2675598336250834e-09
+ 4.9444255865010422e-05 -1.390661486095478e-09
+ 4.9444554034092499e-05 -1.4079464626524889e-09
+ 4.9444998769870888e-05 -1.3781166774969621e-09
+ 4.944580500398899e-05 -1.313948994893242e-09
+ 4.9446711764368311e-05 -1.2450592154006523e-09
+ 4.9447737475686438e-05 -1.1711746826522686e-09
+ 4.9448801143402342e-05 -1.0985374417948889e-09
+ 4.9449944764949548e-05 -1.0244977902794022e-09
+ 4.9452231646278907e-05 -8.876839903243166e-10
+ 4.9454182681216655e-05 -7.8153991862173163e-10
+ 4.9456291228517249e-05 -6.7660226349856925e-10
+ 4.9458581467436158e-05 -5.7299433820914436e-10
+ 4.9460926666850022e-05 -4.7698621811411996e-10
+ 4.9463271866263887e-05 -3.901690868650475e-10
+ 4.9465590537179631e-05 -3.1248869476676087e-10
+ 4.9468474569484277e-05 -2.2600941125466692e-10
+ 4.947135860178893e-05 -1.4953972152878652e-10
+ 4.9474242634093577e-05 -8.1909642546355165e-11
+ 4.9477126666398223e-05 -2.2097231394821104e-11
+ 4.9480010698702877e-05 3.0804763949844941e-11
+ 4.9482894731007523e-05 7.7599184420572088e-11
+ 4.948577876331217e-05 1.1899177680085989e-10
+ 4.9489342797663594e-05 1.6360497315690482e-10
+ 4.9492906832015011e-05 2.0194460469335925e-10
+ 4.9496470866366434e-05 2.3489304324568193e-10
+ 4.9500034900717851e-05 2.6320792465228799e-10
+ 4.9503598935069269e-05 2.8754418863776942e-10
+ 4.9507899961127362e-05 3.124003450031708e-10
+ 4.9512200987185448e-05 3.3310188136055884e-10
+ 4.9516502013243534e-05 3.5034335018174361e-10
+ 4.9520803039301628e-05 3.6470346013268147e-10
+ 4.9525104065359714e-05 3.7666442373221598e-10
+ 4.9530502505986984e-05 3.8888313831481749e-10
+ 4.9535900946614248e-05 3.9859542479219459e-10
+ 4.9541299387241512e-05 4.0629545583254085e-10
+ 4.9546697827868782e-05 4.1242659596079512e-10
+ 4.955346824765747e-05 4.1836450212166619e-10
+ 4.9560238667446158e-05 4.228142873871682e-10
+ 4.9567009087234845e-05 4.2614500842071573e-10
+ 4.9575385304343958e-05 4.2912633403108892e-10
+ 4.958376152145307e-05 4.3120345772378355e-10
+ 4.9592137738562183e-05 4.3264838822889765e-10
+ 4.9603043385488655e-05 4.3388610175178318e-10
+ 4.9613949032415128e-05 4.3464666000495187e-10
+ 4.9626156063665126e-05 4.3514763453961883e-10
+ 4.9638363094915132e-05 4.3542384097085643e-10
+ 4.965057012616513e-05 4.3556624282357159e-10
+ 4.9662777157415129e-05 4.3562884855868211e-10
+ 4.9674984188665135e-05 4.3564390919099658e-10
+ 4.9687191219915133e-05 4.3563071731303817e-10
+ 4.9699398251165132e-05 4.3560072832369711e-10
+ 4.9711605282415131e-05 4.3556071800624522e-10
+ 4.9723812313665129e-05 4.3551473285478916e-10
+ 4.9736019344915135e-05 4.3546520640556509e-10
+ 4.9748226376165133e-05 4.3541358487496968e-10
+ 4.9760433407415132e-05 4.3536071753580087e-10
+ 4.9772640438665137e-05 4.353071102954193e-10
+ 4.9784847469915136e-05 4.3525307030070124e-10
+ 4.9797054501165135e-05 4.3519878102624261e-10
+ 4.9809261532415133e-05 4.3514434891989702e-10
+ 4.9821468563665132e-05 4.3508983678706616e-10
+ 4.9833675594915137e-05 4.3503528333983576e-10
+ 4.9845882626165136e-05 4.3498071205926307e-10
+ 4.9858089657415135e-05 4.3492613633167183e-10
+ 4.987029668866514e-05 4.348715638520445e-10
+ 4.9882503719915139e-05 4.3481699946235471e-10
+ 4.9894710751165137e-05 4.3476244620745766e-10
+ 4.9906917782415136e-05 4.3470790578886986e-10
+ 4.9919124813665135e-05 4.3465337912630206e-10
+ 4.993133184491514e-05 4.3459886680952396e-10
+ 4.9943538876165139e-05 4.3454436923774573e-10
+ 4.9955745907415138e-05 4.3448988663097442e-10
+ 4.9967952938665143e-05 4.3443541909242035e-10
+ 4.9980159969915142e-05 4.3438096668679938e-10
+ 4.999236700116514e-05 4.3432652946422885e-10
+ 5.0000000000000002e-05 4.3429323819786375e-10
+ 5.0012207031250001e-05 4.3423882549145797e-10
+ 5.00244140625e-05 4.3418442800650571e-10
+ 5.0036621093750005e-05 4.3413004574565444e-10
+ 5.0048828125000004e-05 4.3407567870875607e-10
+ 5.0061035156250002e-05 4.3402132689399754e-10
+ 5.0073242187500001e-05 4.3396699029857563e-10
+ 5.008544921875e-05 4.3391266891909689e-10
+ 5.0097656250000005e-05 4.338583627518177e-10
+ 5.0109863281250004e-05 4.338040717927861e-10
+ 5.0122070312500003e-05 4.3374979603792648e-10
+ 5.0134277343750001e-05 4.3369553548309005e-10
+ 5.0146484375e-05 4.3364129012408513e-10
+ 5.0158691406250005e-05 4.3358705995669485e-10
+ 5.0170898437500004e-05 4.3353284497668784e-10
+ 5.0183105468750003e-05 4.3347864517982436e-10
+ 5.0195312500000001e-05 4.3342446056186068e-10
+ 5.020751953125e-05 4.3337029111855061e-10
+ 5.0219726562500005e-05 4.3331613684564742e-10
+ 5.0231933593750004e-05 4.3326199773890431e-10
+ 5.0244140625000003e-05 4.3320787379407488e-10
+ 5.0256347656250001e-05 4.3315376500691365e-10
+ 5.02685546875e-05 4.3309967137317592e-10
+ 5.0280761718750005e-05 4.3304559288861817e-10
+ 5.0292968750000004e-05 4.3299152954899793e-10
+ 5.0305175781250003e-05 4.3293748135007384e-10
+ 5.0317382812500001e-05 4.3288344828760572e-10
+ 5.032958984375e-05 4.3282943035735457e-10
+ 5.0341796875000005e-05 4.3277542755508266e-10
+ 5.0354003906250004e-05 4.327214398765532e-10
+ 5.0366210937500003e-05 4.3266746731753079e-10
+ 5.0378417968750001e-05 4.3261350987378112e-10
+ 5.0390625e-05 4.3255956754107106e-10
+ 5.0402832031250005e-05 4.3250564031516869e-10
+ 5.0415039062500004e-05 4.324517281918434e-10
+ 5.0427246093750003e-05 4.3239783116686546e-10
+ 5.0439453125000001e-05 4.3234394923600652e-10
+ 5.045166015625e-05 4.3229008239503964e-10
+ 5.0463867187499999e-05 4.322362306397386e-10
+ 5.0476074218750004e-05 4.3218239396587857e-10
+ 5.0488281250000003e-05 4.3212857236923607e-10
+ 5.0500488281250001e-05 4.3207476584558855e-10
+ 5.05126953125e-05 4.3202097439071481e-10
+ 5.0524902343750006e-05 4.3196719800039462e-10
+ 5.0537109375000004e-05 4.3191343667040926e-10
+ 5.0549316406250003e-05 4.3185969039654094e-10
+ 5.0561523437500002e-05 4.3180595917457319e-10
+ 5.057373046875e-05 4.3175224300029046e-10
+ 5.0585937500000006e-05 4.3169854186947872e-10
+ 5.0598144531250004e-05 4.3164485577792515e-10
+ 5.0610351562500003e-05 4.3159118472141752e-10
+ 5.0622558593750002e-05 4.315375286957455e-10
+ 5.0634765625e-05 4.3148388769669956e-10
+ 5.0646972656250006e-05 4.3143026172007142e-10
+ 5.0659179687500004e-05 4.3137665076165393e-10
+ 5.0671386718750003e-05 4.3132305481724119e-10
+ 5.0683593750000002e-05 4.3126947388262849e-10
+ 5.069580078125e-05 4.3121590795361226e-10
+ 5.0708007812500006e-05 4.3116235702599014e-10
+ 5.0720214843750004e-05 4.311088210955608e-10
+ 5.0732421875000003e-05 4.3105530015812432e-10
+ 5.0744628906250002e-05 4.3100179420948178e-10
+ 5.07568359375e-05 4.3094830324543561e-10
+ 5.0769042968750006e-05 4.3089482726178914e-10
+ 5.0781250000000004e-05 4.3084136625434698e-10
+ 5.0793457031250003e-05 4.3078792021891527e-10
+ 5.0805664062500002e-05 4.3073448915130076e-10
+ 5.081787109375e-05 4.3068107304731183e-10
+ 5.0830078125000006e-05 4.3062767190275767e-10
+ 5.0842285156250004e-05 4.3057428571344897e-10
+ 5.0854492187500003e-05 4.305209144751974e-10
+ 5.0866699218750002e-05 4.3046755818381573e-10
+ 5.087890625e-05 4.3041421683511815e-10
+ 5.0891113281250006e-05 4.3036089042491982e-10
+ 5.0903320312500005e-05 4.3030757894903721e-10
+ 5.0915527343750003e-05 4.3025428240328784e-10
+ 5.0927734375000002e-05 4.3020100078349046e-10
+ 5.0939941406250001e-05 4.3014773408546503e-10
+ 5.0952148437500006e-05 4.3009448230503257e-10
+ 5.0964355468750005e-05 4.3004124543801536e-10
+ 5.0976562500000003e-05 4.2998802348023685e-10
+ 5.0988769531250002e-05 4.2993481642752165e-10
+ 5.1000976562500001e-05 4.298816242756955e-10
+ 5.1013183593750006e-05 4.2982844702058526e-10
+ 5.1025390625000005e-05 4.2977528465801911e-10
+ 5.1037597656250003e-05 4.2972213718382639e-10
+ 5.1049804687500002e-05 4.296690045938374e-10
+ 5.1062011718750001e-05 4.2961588688388387e-10
+ 5.1074218749999999e-05 4.2956278404979846e-10
+ 5.1086425781250005e-05 4.2950969608741529e-10
+ 5.1098632812500003e-05 4.2945662299256918e-10
+ 5.1110839843750002e-05 4.2940356476109669e-10
+ 5.1123046875000001e-05 4.2935052138883517e-10
+ 5.1135253906249999e-05 4.2929749287162315e-10
+ 5.1147460937500005e-05 4.2924447920530045e-10
+ 5.1159667968750003e-05 4.2919148038570803e-10
+ 5.1171875000000002e-05 4.2913849640868801e-10
+ 5.1184082031250001e-05 4.2908552727008359e-10
+ 5.1196289062499999e-05 4.2903257296573924e-10
+ 5.1208496093750005e-05 4.2897963349150058e-10
+ 5.1220703125000003e-05 4.2892670884321429e-10
+ 5.1232910156250002e-05 4.288737990167283e-10
+ 5.1245117187500001e-05 4.2882090400789185e-10
+ 5.1257324218749999e-05 4.2876802381255504e-10
+ 5.1269531250000005e-05 4.2871515842656934e-10
+ 5.1281738281250004e-05 4.2866230784578723e-10
+ 5.1293945312500002e-05 4.2860947206606246e-10
+ 5.1306152343750001e-05 4.2855665108325002e-10
+ 5.1318359375e-05 4.2850384489320595e-10
+ 5.1330566406249998e-05 4.2845105349178732e-10
+ 5.1342773437500004e-05 4.2839827687485269e-10
+ 5.1354980468750002e-05 4.2834551503826145e-10
+ 5.1367187500000001e-05 4.2829276797787439e-10
+ 5.137939453125e-05 4.2824003568955333e-10
+ 5.1391601562499998e-05 4.2818731816916134e-10
+ 5.1403808593750004e-05 4.2813461541256231e-10
+ 5.1416015625000002e-05 4.2808192741562203e-10
+ 5.1428222656250001e-05 4.2802925417420679e-10
+ 5.14404296875e-05 4.2797659568418397e-10
+ 5.1452636718749998e-05 4.2792395194142275e-10
+ 5.1464843749999997e-05 4.2787132294179297e-10
+ 5.1477050781250002e-05 4.2781870868116553e-10
+ 5.1489257812500001e-05 4.2776610915541303e-10
+ 5.150146484375e-05 4.2771352436040875e-10
+ 5.1513671874999998e-05 4.2766095429202714e-10
+ 5.1525878906249997e-05 4.2760839894614423e-10
+ 5.1538085937500002e-05 4.2755585831863669e-10
+ 5.1550292968750001e-05 4.2750333240538267e-10
+ 5.15625e-05 4.2745082120226136e-10
+ 5.1574707031249998e-05 4.2739832470515305e-10
+ 5.1586914062499997e-05 4.273458429099393e-10
+ 5.1599121093750002e-05 4.2729337581250278e-10
+ 5.1611328125000001e-05 4.2724092340872732e-10
+ 5.162353515625e-05 4.2718848569449787e-10
+ 5.1635742187499998e-05 4.2713606266570053e-10
+ 5.1647949218749997e-05 4.2708365431822263e-10
+ 5.1660156250000003e-05 4.270312606479525e-10
+ 5.1672363281250001e-05 4.2697888165077988e-10
+ 5.16845703125e-05 4.2692651732259529e-10
+ 5.1696777343749998e-05 4.2687416765929084e-10
+ 5.1708984374999997e-05 4.2682183265675928e-10
+ 5.1721191406249996e-05 4.2676951231089505e-10
+ 5.1733398437500001e-05 4.2671720661759342e-10
+ 5.174560546875e-05 4.2666491557275079e-10
+ 5.1757812499999999e-05 4.2661263917226478e-10
+ 5.1770019531249997e-05 4.265603774120343e-10
+ 5.1782226562499996e-05 4.265081302879591e-10
+ 5.1794433593750001e-05 4.2645589779594043e-10
+ 5.1806640625e-05 4.2640367993188038e-10
+ 5.1818847656249999e-05 4.2635147669168246e-10
+ 5.1831054687499997e-05 4.2629928807125108e-10
+ 5.1843261718749996e-05 4.2624711406649186e-10
+ 5.1855468749999995e-05 4.2619495467331169e-10
+ 5.186767578125e-05 4.2614280988761856e-10
+ 5.1879882812499999e-05 4.2609067970532156e-10
+ 5.1892089843749997e-05 4.2603856412233079e-10
+ 5.1904296874999996e-05 4.2598646313455786e-10
+ 5.1916503906249995e-05 4.2593437673791515e-10
+ 5.19287109375e-05 4.2588230492831644e-10
+ 5.1940917968749999e-05 4.2583024770167654e-10
+ 5.1953124999999997e-05 4.2577820505391141e-10
+ 5.1965332031249996e-05 4.2572617698093814e-10
+ 5.1977539062499995e-05 4.2567416347867499e-10
+ 5.198974609375e-05 4.2562216454304139e-10
+ 5.2001953124999999e-05 4.2557018016995789e-10
+ 5.2014160156249997e-05 4.2551821035534623e-10
+ 5.2026367187499996e-05 4.2546625509512913e-10
+ 5.2038574218749995e-05 4.254143143852306e-10
+ 5.205078125e-05 4.2536238822157581e-10
+ 5.2062988281249999e-05 4.2531047660009089e-10
+ 5.2075195312499997e-05 4.2525857951670346e-10
+ 5.2087402343749996e-05 4.252066969673418e-10
+ 5.2099609374999995e-05 4.2515482894793579e-10
+ 5.2111816406249993e-05 4.2510297545441604e-10
+ 5.2124023437499999e-05 4.2505113648271467e-10
+ 5.2136230468749998e-05 4.2499931202876474e-10
+ 5.2148437499999996e-05 4.2494750208850055e-10
+ 5.2160644531249995e-05 4.248957066578573e-10
+ 5.2172851562499993e-05 4.2482519493572964e-10
+ 5.2185058593749999e-05 4.2475256100502045e-10
+ 5.2197265624999998e-05 4.2468173951608737e-10
+ 5.2209472656249996e-05 4.2459666096075283e-10
+ 5.2221679687499995e-05 4.2448010616874532e-10
+ 5.2233886718749994e-05 4.242745676347303e-10
+ 5.2239990234374993e-05 4.2406762246865748e-10
+ 5.2246093749999992e-05 4.2364446431160585e-10
+ 5.2249145507812499e-05 4.2320637096990359e-10
+ 5.2252197265624998e-05 4.2237081875579266e-10
+ 5.2255249023437498e-05 4.2039912634768696e-10
+ 5.225660679077409e-05 4.184858057925494e-10
+ 5.2256998216660863e-05 4.1769354662518729e-10
+ 5.2257389642547636e-05 4.1673967866159501e-10
+ 5.2258368207264578e-05 4.1328644574257995e-10
+ 5.2259409502908188e-05 4.0647792025774505e-10
+ 5.2259970598735324e-05 4.0009399586852752e-10
+ 5.226033962929837e-05 3.9400830485401903e-10
+ 5.2261110323815845e-05 3.7217296598144555e-10
+ 5.2261741481233848e-05 3.3482378565862255e-10
+ 5.226211308400901e-05 2.9476725253157392e-10
+ 5.2262434193795794e-05 2.3913652951300332e-10
+ 5.226264709792541e-05 2.1273235713088472e-10
+ 5.2262860002055032e-05 2.1207408791108858e-10
+ 5.2264989043351246e-05 2.1185023895337551e-10
+ 5.2277196074601245e-05 2.0757980032582087e-10
+ 5.2289403105851244e-05 1.9827504053149293e-10
+ 5.2301610137101249e-05 1.8447156434439206e-10
+ 5.2313817168351248e-05 1.6696410651490149e-10
+ 5.2326024199601246e-05 1.4676018343964647e-10
+ 5.2338231230851245e-05 1.2502212943217047e-10
+ 5.2350438262101244e-05 1.0300022779102304e-10
+ 5.2362645293351249e-05 8.1960799754197404e-11
+ 5.2374852324601248e-05 6.311338755160194e-11
+ 5.2387059355851246e-05 4.7541218733423125e-11
+ 5.2399266387101245e-05 3.6138949326912032e-11
+ 5.2411473418351244e-05 2.9561263935700322e-11
+ 5.2423680449601242e-05 2.8185285811614418e-11
+ 5.2435887480851248e-05 3.2088955187765566e-11
+ 5.2448094512101246e-05 4.1046615499322252e-11
+ 5.2460301543351245e-05 5.4542057385810135e-11
+ 5.2472508574601244e-05 7.1798266491615728e-11
+ 5.2484715605851242e-05 9.1822160785597292e-11
+ 5.2496922637101248e-05 1.1346174161334856e-10
+ 5.2509129668351247e-05 1.3547236949090519e-10
+ 5.2521336699601245e-05 1.5658835172212636e-10
+ 5.2533543730851244e-05 1.7559572435646284e-10
+ 5.2545750762101242e-05 1.9140204326212496e-10
+ 5.2557957793351241e-05 2.030991720132836e-10
+ 5.2561009551163748e-05 2.0529687447679853e-10
+ 5.2561314726944993e-05 2.0549982177660819e-10
+ 5.2562077666398123e-05 2.0599366009052315e-10
+ 5.2562459136124684e-05 2.062333046850057e-10
+ 5.2562482977982589e-05 2.0624812098499301e-10
+ 5.2562487746354172e-05 2.0625108196291897e-10
+ 5.2562497283097339e-05 2.0625700163649109e-10
+ 5.2562498046036788e-05 2.0625747507891284e-10
+ 5.2562499571915698e-05 2.0625842190532621e-10
+ 5.2562499693986007e-05 2.0625849764807365e-10
+ 5.2562499938126632e-05 2.0625864913207268e-10
+ 5.2562499957657884e-05 2.0625866125070641e-10
+ 5.2562499996720387e-05 2.0625868548793557e-10
+ 5.2562500074845387e-05 8.3574849775232329e-10
+ 5.2562500152970386e-05 2.8382408459534785e-09
+ 5.2562500934220383e-05 9.7910663945931592e-08
+ 5.2562508051845978e-05 6.9281309170090845e-06
+ 5.2562515169471572e-05 2.3496919613390592e-05
+ 5.2562522287097173e-05 4.8515586154137975e-05
+ 5.2562529404722767e-05 8.0864107426474553e-05
+ 5.2562536522348361e-05 0.0001195688537478285
+ 5.2562543639973956e-05 0.00016378325676260678
+ 5.2562550757599557e-05 0.00021277103077073492
+ 5.2562557875225151e-05 0.00026589161027525284
+ 5.2562564992850745e-05 0.00032258751106878353
+ 5.2562572110476346e-05 0.00038237336083026571
+ 5.2562579228101941e-05 0.00044482637875059637
+ 5.2562587807568573e-05 0.00052313156179263198
+ 5.2562596387035205e-05 0.00060422377214069478
+ 5.2562604966501837e-05 0.00068763160407692863
+ 5.2562613545968469e-05 0.00077295453496090106
+ 5.2562622125435101e-05 0.00085985181282763258
+ 5.2562630704901733e-05 0.00094803308914625053
+ 5.2562639284368365e-05 0.0010372505228311898
+ 5.2562647863834997e-05 0.0011272921245865509
+ 5.256265818077025e-05 0.0012364048498757886
+ 5.2562668497705504e-05 0.0013461799437633384
+ 5.2562678814640765e-05 0.0014563930288477433
+ 5.2562689131576018e-05 0.001566855276772596
+ 5.2562699448511272e-05 0.0016774068636345029
+ 5.2562709765446533e-05 0.001787911643031166
+ 5.2562720082381786e-05 0.0018982528107135616
+ 5.256273039931704e-05 0.0020083293767566338
+ 5.2562742902012262e-05 0.002141246780886198
+ 5.2562755404707478e-05 0.0022735106700283729
+ 5.25627679074027e-05 0.0024050029041599369
+ 5.2562780410097916e-05 0.0025356196305195535
+ 5.2562792912793139e-05 0.0026652683340791378
+ 5.2562805415488354e-05 0.002793865545581445
+ 5.2562817918183577e-05 0.0029213350620943554
+ 5.2562830420878792e-05 0.0030476065669750823
+ 5.2562845592253874e-05 0.0031991277392290247
+ 5.2562860763628955e-05 0.0033486794005026179
+ 5.2562875935004037e-05 0.0034961593179601309
+ 5.2562891106379118e-05 0.0036414711081661105
+ 5.2562906277754193e-05 0.0037845233735065873
+ 5.2562921449129275e-05 0.0039252290818992874
+ 5.2562936620504356e-05 0.0040635051254073566
+ 5.2562954860519561e-05 0.0042264209820281088
+ 5.2562973100534772e-05 0.0043855785109888799
+ 5.2562991340549976e-05 0.004540852807539594
+ 5.2563009580565187e-05 0.0046921255232483241
+ 5.2563027820580391e-05 0.004839284756390172
+ 5.2563046060595596e-05 0.0049822250059800644
+ 5.2563068199865844e-05 0.0051499118748984281
+ 5.2563090339136093e-05 0.0053110729761570875
+ 5.2563112478406348e-05 0.0054655577982168782
+ 5.2563134617676596e-05 0.0056132299331846198
+ 5.2563161293011321e-05 0.0057819364493443522
+ 5.2563187873095808e-05 0.0059398423573548687
+ 5.2563214453180296e-05 0.0060874136176253622
+ 5.2563248688484341e-05 0.0062620603819550135
+ 5.2563282923788386e-05 0.0064191641307141745
+ 5.2563315356127047e-05 0.0065517091134031152
+ 5.2563347788465715e-05 0.0066683776453289999
+ 5.2563380220804377e-05 0.0067692021882621509
+ 5.2563412653143038e-05 0.0068542763543729904
+ 5.2563445085481706e-05 0.0069237529436825757
+ 5.2563477517820368e-05 0.0069778416850672731
+ 5.2563509950159029e-05 0.0070168067033145008
+ 5.2563542382497698e-05 0.0070409637367341727
+ 5.256356958499815e-05 0.0070500711051410814
+ 5.2563596787498601e-05 0.0070492564131712353
+ 5.2563623989999053e-05 0.0070387804986578604
+ 5.2563651192499505e-05 0.0070189238317284377
+ 5.2563678394999964e-05 0.0069899850256677273
+ 5.2563705597500415e-05 0.0069522793135452206
+ 5.2563732800000867e-05 0.0069061369988542495
+ 5.2563760002501326e-05 0.0068519018883273245
+ 5.2563787205001778e-05 0.0067899297149596706
+ 5.256381440750223e-05 0.0067205865590935169
+ 5.2563841610002681e-05 0.0066442472751925379
+ 5.2563868812503133e-05 0.006561293931672073
+ 5.2563896015003592e-05 0.0064721142708494637
+ 5.2563923217504044e-05 0.0063771001957435066
+ 5.2563950420004496e-05 0.0062766462900859356
+ 5.2563977622504954e-05 0.0061711483775146155
+ 5.2564004825005406e-05 0.0060610021255013743
+ 5.2564032027505858e-05 0.0059466016991306979
+ 5.256405923000631e-05 0.0058283384693926773
+ 5.2564086432506762e-05 0.0057065997804302861
+ 5.2564115300883499e-05 0.0055740309990659331
+ 5.2564144169260237e-05 0.0054384272991202893
+ 5.2564173037636967e-05 0.0053002282345430132
+ 5.2564201906013705e-05 0.0051598626838551204
+ 5.2564230774390442e-05 0.0050177476630414884
+ 5.2564259642767173e-05 0.0048742872442221231
+ 5.256428851114391e-05 0.0047298715812966012
+ 5.2564317379520648e-05 0.0045848760430473451
+ 5.2564346247897379e-05 0.0044396604535071188
+ 5.2564381135166688e-05 0.0042643637747592994
+ 5.256441602243599e-05 0.0040898203879790361
+ 5.2564449985506051e-05 0.0039211359224094145
+ 5.2564483948576112e-05 0.0037541355090310092
+ 5.256451791164618e-05 0.0035892460195200843
+ 5.2564551874716241e-05 0.0034268598627977894
+ 5.2564585837786302e-05 0.0032673350066711841
+ 5.2564627381082822e-05 0.0030765664536155394
+ 5.2564668924379335e-05 0.0028910852643209248
+ 5.2564710467675848e-05 0.0027113416169293153
+ 5.2564752010972367e-05 0.0025377141992044784
+ 5.2564802322523103e-05 0.0023360685105670866
+ 5.2564853125173635e-05 0.0021424443576868821
+ 5.2564903927824173e-05 0.001959156496722657
+ 5.2564971607266248e-05 0.0017313192252947558
+ 5.2565039286708322e-05 0.0015222190408349249
+ 5.2565091919396569e-05 0.001372431253814393
+ 5.2565144552084816e-05 0.0012336381966261724
+ 5.2565197184773056e-05 0.0011055447342070166
+ 5.2565249817461303e-05 0.00098778684645394604
+ 5.2565297809929104e-05 0.00088906516794052203
+ 5.2565345802396906e-05 0.00079823747715313789
+ 5.2565393794864714e-05 0.00071492972227882204
+ 5.2565441787332515e-05 0.00063875107498295779
+ 5.2565489779800317e-05 0.00056929990178360005
+ 5.2565537261554868e-05 0.00050680910974394439
+ 5.2565584743309412e-05 0.00045011010916966049
+ 5.2565632225063963e-05 0.00039881145821643485
+ 5.2565679706818515e-05 0.00035252854906615789
+ 5.2565727188573059e-05 0.00031088653907439246
+ 5.256577467032761e-05 0.0002735227890958723
+ 5.2565824358583365e-05 0.00023862511600889196
+ 5.2565874046839126e-05 0.00020765025205703798
+ 5.2565923735094881e-05 0.00018023763188315632
+ 5.2565973423350635e-05 0.00015604795426756195
+ 5.2566023111606397e-05 0.0001347637411803884
+ 5.2566072799862151e-05 0.00011608953467670693
+ 5.2566127951386077e-05 9.8086983151495662e-05
+ 5.2566183102910002e-05 8.2620379659707852e-05
+ 5.2566238254433927e-05 6.937830638173144e-05
+ 5.2566293405957853e-05 5.8079646203919961e-05
+ 5.2566348557481785e-05 4.8471998343402797e-05
+ 5.2566411640520544e-05 3.9267448447275403e-05
+ 5.2566474723559302e-05 3.1683839518460041e-05
+ 5.2566537806598061e-05 2.5463033689023789e-05
+ 5.256660088963682e-05 2.0382309617297274e-05
+ 5.2566674140146427e-05 1.5662206653736814e-05
+ 5.2566747390656035e-05 1.1971024407425274e-05
+ 5.2566820641165643e-05 9.101093726216712e-06
+ 5.2566905619421588e-05 6.5781195004269459e-06
+ 5.2566990597677526e-05 4.7207090840830405e-06
+ 5.2567093836844789e-05 3.1245246960755978e-06
+ 5.2567198171769413e-05 2.0371887602864823e-06
+ 5.2567302506694045e-05 1.3141391771344707e-06
+ 5.2567426664469163e-05 7.6923430377838728e-07
+ 5.2567550822244289e-05 4.435788450454647e-07
+ 5.2567705800806533e-05 2.1851475951109054e-07
+ 5.2567884937131786e-05 9.3708673373505121e-08
+ 5.2568098556602389e-05 3.2883700516734768e-08
+ 5.2568364485722957e-05 8.5309004428172277e-09
+ 5.2568717982712206e-05 1.4552417250701691e-09
+ 5.2569242097564148e-05 3.0578689270965244e-10
+ 5.2570136340120474e-05 2.4569663308855879e-10
+ 5.257213280718504e-05 2.4259754686171839e-10
+ 5.2573988816858017e-05 2.4182034068072913e-10
+ 5.2576421668443082e-05 2.4138174969930913e-10
+ 5.2578854520028146e-05 2.4076582964276258e-10
+ 5.258128737161321e-05 2.4012576594620444e-10
+ 5.2583720223198275e-05 2.4057963384973803e-10
+ 5.2586153074783332e-05 2.4092919901400983e-10
+ 5.2588585926368397e-05 2.401872610697499e-10
+ 5.2591018777953461e-05 2.3987554496708928e-10
+ 5.2593451629538525e-05 2.4037942571475707e-10
+ 5.2595767705239779e-05 2.4025247901632375e-10
+ 5.2598819440406718e-05 2.4017887589128354e-10
+ 5.2601871175573663e-05 2.4009951114703349e-10
+ 5.2604922910740601e-05 2.4004351142745323e-10
+ 5.2607974645907539e-05 2.4016098617015712e-10
+ 5.2611026381074478e-05 2.4071442426522539e-10
+ 5.2614078116241416e-05 2.3968616681674537e-10
+ 5.2617773618773603e-05 2.4003007462135484e-10
+ 5.2621134288610908e-05 2.4006402385879101e-10
+ 5.262449495844822e-05 2.4006047129867007e-10
+ 5.2628620731690283e-05 2.4005210497337081e-10
+ 5.263274650493234e-05 2.4004042399080182e-10
+ 5.2636872278174396e-05 2.4003044384477591e-10
+ 5.2640998051416459e-05 2.4003749578386358e-10
+ 5.2645123824658516e-05 2.4008180521387353e-10
+ 5.2650251138437099e-05 2.4016443526047099e-10
+ 5.2655378452215682e-05 2.3985136550844345e-10
+ 5.2660505765994265e-05 2.3994252727381691e-10
+ 5.2665633079772848e-05 2.4004700010028028e-10
+ 5.2671995979825155e-05 2.4004483697536087e-10
+ 5.2678358879877462e-05 2.3997024527683999e-10
+ 5.2684721779929769e-05 2.3997592655072043e-10
+ 5.2692497256254513e-05 2.4000749931504923e-10
+ 5.2700272732579251e-05 2.4001269631983051e-10
+ 5.2708048208903995e-05 2.3999782508278659e-10
+ 5.2717983441936072e-05 2.3999355892689472e-10
+ 5.2727918674968141e-05 2.4000179472492324e-10
+ 5.2740125706218147e-05 2.4000339716614338e-10
+ 5.2752332737468145e-05 2.3999888202599127e-10
+ 5.2764539768718144e-05 2.3999830525938688e-10
+ 5.2776746799968142e-05 2.4000037974237526e-10
+ 5.2788953831218141e-05 2.4000087414852165e-10
+ 5.2801160862468147e-05 2.3999993966201389e-10
+ 5.2813367893718145e-05 2.3999960494882817e-10
+ 5.2825574924968144e-05 2.4000001432309894e-10
+ 5.2837781956218143e-05 2.4000021737723387e-10
+ 5.2849988987468141e-05 2.4000004462513988e-10
+ 5.286219601871814e-05 2.3999993006727966e-10
+ 5.2874403049968145e-05 2.3999999917748096e-10
+ 5.2886610081218144e-05 2.4000006049017395e-10
+ 5.2898817112468143e-05 2.4000003421757239e-10
+ 5.2911024143718141e-05 2.4000000237870328e-10
+ 5.292323117496814e-05 2.4000001256652595e-10
+ 5.2935438206218145e-05 2.4000002745854788e-10
+ 5.2947645237468144e-05 2.4000002475271839e-10
+ 5.2959852268718143e-05 2.4000001795384735e-10
+ 5.2972059299968141e-05 2.400000173879749e-10
+ 5.298426633121814e-05 2.4000002070407596e-10
+ 5.2996473362468145e-05 2.4000002067419452e-10
+ 5.3008680393718144e-05 2.4000001976473751e-10
+ 5.3020887424968143e-05 2.40000019362722e-10
+ 5.3033094456218141e-05 2.4000002028128461e-10
+ 5.304530148746814e-05 2.4000002060646208e-10
+ 5.3057508518718145e-05 2.4000002008287723e-10
+ 5.3069715549968144e-05 2.4000001934276911e-10
+ 5.3081922581218143e-05 2.4000001968966948e-10
+ 5.3094129612468141e-05 2.4000002093381111e-10
+ 5.310633664371814e-05 2.4000001965726013e-10
+ 5.3118543674968139e-05 2.4000001961507071e-10
+ 5.3130750706218144e-05 2.4000002048512451e-10
+ 5.3142957737468143e-05 2.4000001998121006e-10
+ 5.3155164768718141e-05 2.400000199764228e-10
+ 5.316737179996814e-05 2.4000001998665694e-10
+ 5.3179578831218139e-05 2.4000001988395378e-10
+ 5.3191785862468144e-05 2.4000001969840786e-10
+ 5.3203992893718143e-05 2.4000001962628526e-10
+ 5.3216199924968142e-05 2.4000001985975601e-10
+ 5.322840695621814e-05 2.4000001994562599e-10
+ 5.3240613987468139e-05 2.4000001873790616e-10
+ 5.3252821018718137e-05 2.400000206888198e-10
+ 5.3265028049968143e-05 2.4000002115772409e-10
+ 5.3277235081218142e-05 2.4000001926167516e-10
+ 5.328944211246814e-05 2.4000001865095655e-10
+ 5.3301649143718139e-05 2.4000002024868279e-10
+ 5.3313856174968138e-05 2.4000002062807212e-10
+ 5.3326063206218143e-05 2.4000001971246058e-10
+ 5.3338270237468142e-05 2.4000001913611468e-10
+ 5.335047726871814e-05 2.4000001939609548e-10
+ 5.3362684299968139e-05 2.4000001928925776e-10
+ 5.3374891331218138e-05 2.4000002036211893e-10
+ 5.3387098362468143e-05 2.4000001948566678e-10
+ 5.3399305393718142e-05 2.40000020557049e-10
+ 5.341151242496814e-05 2.400000203491446e-10
+ 5.3423719456218139e-05 2.4000001961720044e-10
+ 5.3435926487468138e-05 2.400000200808237e-10
+ 5.3448133518718143e-05 2.4000002006495584e-10
+ 5.3460340549968142e-05 2.4000001941755901e-10
+ 5.347254758121814e-05 2.4000001925514504e-10
+ 5.3484754612468139e-05 2.4000001949494439e-10
+ 5.3496961643718138e-05 2.4000001987457185e-10
+ 5.3509168674968136e-05 2.4000001956535886e-10
+ 5.3521375706218142e-05 2.4000001976899341e-10
+ 5.353358273746814e-05 2.4000001989767335e-10
+ 5.3545789768718139e-05 2.4000002010421042e-10
+ 5.3557996799968138e-05 2.4000002031692612e-10
+ 5.3570203831218136e-05 2.4000001943796074e-10
+ 5.3582410862468142e-05 2.4000001979057998e-10
+ 5.3594617893718141e-05 2.4000001994141042e-10
+ 5.3606824924968139e-05 2.4000001910787902e-10
+ 5.3619031956218138e-05 2.4000002014157438e-10
+ 5.3631238987468136e-05 2.4000002007976212e-10
+ 5.3643446018718135e-05 2.4000001897875313e-10
+ 5.3655653049968141e-05 2.4000002030066949e-10
+ 5.3667860081218139e-05 2.4000002070432142e-10
+ 5.3680067112468138e-05 2.4000001950520541e-10
+ 5.3692274143718137e-05 2.4000001947980057e-10
+ 5.3704481174968135e-05 2.4000002027253361e-10
+ 5.3716688206218141e-05 2.40000020609859e-10
+ 5.3728895237468139e-05 2.4000001911322354e-10
+ 5.3741102268718138e-05 2.4000001969739074e-10
+ 5.3753309299968137e-05 2.4000002073053612e-10
+ 5.3765516331218135e-05 2.4000001994814067e-10
+ 5.3777723362468141e-05 2.4000001923239209e-10
+ 5.3789930393718139e-05 2.4000002015288261e-10
+ 5.3802137424968138e-05 2.4000001930210656e-10
+ 5.3814344456218137e-05 2.4000001837686493e-10
+ 5.3826551487468135e-05 2.4000001946449939e-10
+ 5.3838758518718141e-05 2.4000002038326192e-10
+ 5.3850965549968139e-05 2.400000203109469e-10
+ 5.3863172581218138e-05 2.400000203952259e-10
+ 5.3875379612468137e-05 2.4000001970496741e-10
+ 5.3887586643718142e-05 2.4000001924454606e-10
+ 5.3899793674968141e-05 2.4000001905466872e-10
+ 5.3912000706218139e-05 2.400000204518705e-10
+ 5.3924207737468138e-05 2.4000002011557764e-10
+ 5.3936414768718144e-05 2.4000001946831419e-10
+ 5.3948621799968142e-05 2.4000001925940771e-10
+ 5.3960828831218141e-05 2.4000001980987061e-10
+ 5.3973035862468139e-05 2.4000002089319245e-10
+ 5.3985242893718145e-05 2.4000001973823067e-10
+ 5.3997449924968144e-05 2.4000001879346328e-10
+ 5.4009656956218142e-05 2.4000001869932423e-10
+ 5.4021863987468141e-05 2.4000002074828773e-10
+ 5.4034071018718146e-05 2.4000001934026167e-10
+ 5.4046278049968145e-05 2.4000001952115826e-10
+ 5.4058485081218144e-05 2.4000001987859593e-10
+ 5.4070692112468142e-05 2.400000198982881e-10
+ 5.4082899143718148e-05 2.40000018977687e-10
+ 5.4095106174968146e-05 2.4000001970468766e-10
+ 5.4107313206218145e-05 2.4000001969944985e-10
+ 5.4119520237468144e-05 2.4000002027367879e-10
+ 5.4131727268718149e-05 2.4000001840031488e-10
+ 5.4143934299968148e-05 2.4000001957318321e-10
+ 5.4156141331218146e-05 2.400000188108562e-10
+ 5.4168348362468145e-05 2.4000002046679305e-10
+ 5.4180555393718151e-05 2.4000001950571268e-10
+ 5.4192762424968149e-05 2.4000001838116472e-10
+ 5.4204969456218148e-05 2.4000001853089837e-10
+ 5.4217176487468146e-05 2.4000002004811227e-10
+ 5.4229383518718152e-05 2.4000001966057371e-10
+ 5.4241590549968151e-05 2.4000001941089245e-10
+ 5.4253797581218149e-05 2.4000001913185568e-10
+ 5.4266004612468148e-05 2.4000001954838558e-10
+ 5.4278211643718153e-05 2.4000001920964592e-10
+ 5.4290418674968152e-05 2.4000001943469307e-10
+ 5.4302625706218151e-05 2.4000001866641258e-10
+ 5.4314832737468149e-05 2.4000002020897109e-10
+ 5.4327039768718155e-05 2.4000001940179987e-10
+ 5.4339246799968153e-05 2.4000001993507329e-10
+ 5.4351453831218152e-05 2.4000002008198123e-10
+ 5.4363660862468151e-05 2.400000198005213e-10
+ 5.4375867893718156e-05 2.4000001916301211e-10
+ 5.4388074924968155e-05 2.4000001960280073e-10
+ 5.4400281956218153e-05 2.4000001963117276e-10
+ 5.4412488987468152e-05 2.400000196254434e-10
+ 5.4424696018718158e-05 2.4000002030623543e-10
+ 5.4436903049968156e-05 2.4000001985486468e-10
+ 5.4449110081218155e-05 2.4000001975560508e-10
+ 5.4461317112468153e-05 2.4000002002563028e-10
+ 5.4473524143718159e-05 2.4000001880683233e-10
+ 5.4485731174968158e-05 2.400000186107882e-10
+ 5.4497938206218156e-05 2.4000002026174485e-10
+ 5.4510145237468155e-05 2.4000001964579944e-10
+ 5.452235226871816e-05 2.4000001869414737e-10
+ 5.4534559299968159e-05 2.4000002024855297e-10
+ 5.4546766331218158e-05 2.4000001886895933e-10
+ 5.4558973362468156e-05 2.4000001996539064e-10
+ 5.4571180393718162e-05 2.4000001852201533e-10
+ 5.458338742496816e-05 2.4000001995376353e-10
+ 5.4595594456218159e-05 2.4000001885033681e-10
+ 5.4607801487468158e-05 2.400000202275795e-10
+ 5.4620008518718163e-05 2.4000001938682899e-10
+ 5.4632215549968162e-05 2.400000185286626e-10
+ 5.464442258121816e-05 2.4000002021567022e-10
+ 5.4656629612468159e-05 2.4000001929093104e-10
+ 5.4668836643718164e-05 2.4000001945502139e-10
+ 5.4681043674968163e-05 2.4000001849176264e-10
+ 5.4693250706218162e-05 2.4000001899160695e-10
+ 5.470545773746816e-05 2.4000001908469775e-10
+ 5.4717664768718166e-05 2.4000002021320925e-10
+ 5.4729871799968165e-05 2.4000001986077044e-10
+ 5.4742078831218163e-05 2.4000001985660228e-10
+ 5.4754285862468162e-05 2.4000001982734366e-10
+ 5.4766492893718167e-05 2.4000001909394165e-10
+ 5.4778699924968166e-05 2.4000001971428865e-10
+ 5.4790906956218165e-05 2.4000001921042243e-10
+ 5.4803113987468163e-05 2.400000190589926e-10
+ 5.4815321018718169e-05 2.400000192770844e-10
+ 5.4827528049968167e-05 2.4000001876027354e-10
+ 5.4839735081218166e-05 2.4000001963225885e-10
+ 5.4851942112468165e-05 2.4000001898595255e-10
+ 5.486414914371817e-05 2.4000001876650681e-10
+ 5.4876356174968169e-05 2.4000001955479303e-10
+ 5.4888563206218167e-05 2.400000192149284e-10
+ 5.4900770237468166e-05 2.4000001962818762e-10
+ 5.4912977268718171e-05 2.400000192259498e-10
+ 5.492518429996817e-05 2.4000001958046752e-10
+ 5.4937391331218169e-05 2.4000001876653049e-10
+ 5.4949598362468167e-05 2.4000001901679062e-10
+ 5.4961805393718173e-05 2.4000001929188411e-10
+ 5.4974012424968172e-05 2.4000001878460593e-10
+ 5.498621945621817e-05 2.4000001895149019e-10
+ 5.4998426487468169e-05 2.4000001953324466e-10
+ 5.5010633518718174e-05 2.4000001930179932e-10
+ 5.5022840549968173e-05 2.4000001867284628e-10
+ 5.5035047581218172e-05 2.4000001876404646e-10
+ 5.504725461246817e-05 2.4000001844012502e-10
+ 5.5059461643718176e-05 2.4000001847700822e-10
+ 5.5071668674968174e-05 2.4000001848915366e-10
+ 5.5083875706218173e-05 2.4000001847211049e-10
+ 5.5096082737468172e-05 2.4000001842583542e-10
+ 5.5108289768718177e-05 2.4000001874485954e-10
+ 5.5120496799968176e-05 2.4000001864470591e-10
+ 5.5132703831218174e-05 2.400000192645186e-10
+ 5.5144910862468173e-05 2.4000001911011029e-10
+ 5.5157117893718178e-05 2.400000189594016e-10
+ 5.5169324924968177e-05 2.4000001834385696e-10
+ 5.5181531956218176e-05 2.4000001923683012e-10
+ 5.5193738987468174e-05 2.4000002008098464e-10
+ 5.520594601871818e-05 2.400000183211859e-10
+ 5.5218153049968179e-05 2.4000001983070817e-10
+ 5.5230360081218177e-05 2.4000001841550595e-10
+ 5.5242567112468176e-05 2.4000001987140726e-10
+ 5.5254774143718181e-05 2.4000001839799459e-10
+ 5.526698117496818e-05 2.4000001979564812e-10
+ 5.5279188206218179e-05 2.4000001826400317e-10
+ 5.5291395237468177e-05 2.3996544537098469e-10
+ 5.5303602268718183e-05 2.3996256464191007e-10
+ 5.5315809299968181e-05 2.3996062147298765e-10
+ 5.532801633121818e-05 2.399538992151035e-10
+ 5.5340223362468179e-05 2.3990864356794482e-10
+ 5.5352430393718184e-05 2.3980391697569448e-10
+ 5.5364637424968183e-05 2.3960325885649169e-10
+ 5.5370740940593182e-05 2.3930636780140344e-10
+ 5.5376844456218181e-05 2.3825018349924986e-10
+ 5.5379896214030681e-05 2.3664385617022961e-10
+ 5.5382947971843181e-05 2.313460144418538e-10
+ 5.5384473850749434e-05 2.2273712950258841e-10
+ 5.538599972965568e-05 1.9502932447418286e-10
+ 5.5386991106889187e-05 1.3263414891107653e-10
+ 5.5387269733896247e-05 9.5672269136980181e-11
+ 5.5387548360903299e-05 4.6113023016783446e-11
+ 5.5388098835627974e-05 4.077304569289076e-11
+ 5.5390875273912441e-05 4.2347131994264368e-11
+ 5.5403082305162439e-05 4.4733371018365243e-11
+ 5.5415289336412438e-05 5.3058719093237963e-11
+ 5.5427496367662437e-05 6.5249849962529414e-11
+ 5.5439703398912435e-05 8.0586557341896391e-11
+ 5.5451910430162441e-05 9.8186059694000248e-11
+ 5.5464117461412439e-05 1.1703587328666208e-10
+ 5.5476324492662438e-05 1.3605185310399104e-10
+ 5.5488531523912443e-05 1.5414054504639482e-10
+ 5.5500738555162442e-05 1.7026206156240515e-10
+ 5.5512945586412441e-05 1.8348986297121229e-10
+ 5.5525152617662439e-05 1.9306400774952091e-10
+ 5.5537359648912438e-05 1.9843481134517081e-10
+ 5.5549566680162443e-05 1.9929440536940058e-10
+ 5.5561773711412442e-05 1.9559438520732841e-10
+ 5.5573980742662441e-05 1.8754853451668201e-10
+ 5.5586187773912446e-05 1.7562047328816539e-10
+ 5.5598394805162445e-05 1.6049694315998822e-10
+ 5.5610601836412443e-05 1.4304826930135124e-10
+ 5.5622808867662442e-05 1.2427827523140709e-10
+ 5.5635015898912441e-05 1.052665328361379e-10
+ 5.5647222930162446e-05 8.7106269937226752e-11
+ 5.5659429961412445e-05 7.0841506734532094e-11
+ 5.5671636992662444e-05 5.7407035899497847e-11
+ 5.5683844023912449e-05 4.7574696846103914e-11
+ 5.5686895781724942e-05 4.5750674856066197e-11
+ 5.5687048369615568e-05 4.5666462612461995e-11
+ 5.5687429839342136e-05 4.5458870923120094e-11
+ 5.5687467986314791e-05 4.5438342991126504e-11
+ 5.5687475615709323e-05 4.5434242455099145e-11
+ 5.5687490874498381e-05 4.5426046434154427e-11
+ 5.568749697801401e-05 4.5422769911655126e-11
+ 5.5687499419420259e-05 4.542145960441293e-11
+ 5.5687499604455785e-05 4.5421360302533612e-11
+ 5.5687499974526838e-05 4.5421161701746532e-11
+ 5.568750071466895e-05 5.7234708751505077e-08
+ 5.5687501454811062e-05 2.3609835104101694e-07
+ 5.5687508856232145e-05 8.3378657603255145e-06
+ 5.5687516257653242e-05 2.6804211983519737e-05
+ 5.5687523659074325e-05 5.4212572160978158e-05
+ 5.5687531060495422e-05 8.9333429400249197e-05
+ 5.5687538461916505e-05 0.00013110387761772142
+ 5.5687547512355688e-05 0.00018988604042548046
+ 5.5687556562794872e-05 0.000255812068272275
+ 5.5687565613234049e-05 0.00032768193023753725
+ 5.5687574663673232e-05 0.00040448949601993325
+ 5.5687583714112416e-05 0.00048539058840956265
+ 5.5687595044533514e-05 0.00059137048504824714
+ 5.5687606374954613e-05 0.00070151686849491022
+ 5.5687617705375711e-05 0.0008149054011463608
+ 5.568762903579681e-05 0.00093078918228233572
+ 5.5687643214653364e-05 0.0010784080416500865
+ 5.5687657393509919e-05 0.0012280520970111633
+ 5.5687671572366474e-05 0.0013789889014004875
+ 5.5687689032396939e-05 0.0015657925325384681
+ 5.5687706492427397e-05 0.0017528666320927736
+ 5.5687723952457861e-05 0.0019395804048633696
+ 5.5687746268477831e-05 0.0021769293571718938
+ 5.5687768584497801e-05 0.0024120996791847497
+ 5.568779090051777e-05 0.0026444704336099976
+ 5.568781909021724e-05 0.0029332237971511233
+ 5.5687847279916716e-05 0.0032158629328255771
+ 5.5687875469616185e-05 0.0034916668520790159
+ 5.5687903659315654e-05 0.0037599988278231356
+ 5.5687931849015124e-05 0.0040202830355208904
+ 5.5687960038714593e-05 0.0042719918874605982
+ 5.5687988228414062e-05 0.0045146394015623476
+ 5.5688019414106471e-05 0.0047719795450323309
+ 5.5688050599798886e-05 0.0050171295125712645
+ 5.5688081785491295e-05 0.0052495906087394869
+ 5.5688112971183711e-05 0.0054689190353913904
+ 5.5688150418414337e-05 0.0057143885297757718
+ 5.5688187865644969e-05 0.0059397992525804574
+ 5.5688225312875602e-05 0.006144702220679193
+ 5.5688270844195812e-05 0.0063657430322260553
+ 5.5688316375516022e-05 0.0065556175023236875
+ 5.5688361906836238e-05 0.0067142112673811444
+ 5.5688407438156448e-05 0.0068416534980290083
+ 5.5688441084028114e-05 0.0069160175765833089
+ 5.5688474729899779e-05 0.0069737900261410465
+ 5.5688508375771445e-05 0.0070152594941248576
+ 5.568854202164311e-05 0.0070407746969006688
+ 5.5688575667514776e-05 0.007050740823760393
+ 5.5688609313386441e-05 0.0070456156939712805
+ 5.5688642959258107e-05 0.007025905702338452
+ 5.5688676605129772e-05 0.0069921615895264296
+ 5.5688710251001438e-05 0.0069449740739896257
+ 5.5688736870668147e-05 0.006898526876910809
+ 5.5688763490334857e-05 0.0068443802044164921
+ 5.5688790110001567e-05 0.0067828688534493494
+ 5.5688816729668284e-05 0.0067143369242957376
+ 5.5688843349334994e-05 0.0066391364097472113
+ 5.5688869969001704e-05 0.0065576257964309343
+ 5.5688896588668414e-05 0.0064701686843428533
+ 5.5688923208335124e-05 0.0063771324303375145
+ 5.5688949828001833e-05 0.0062788868210215225
+ 5.5688976447668543e-05 0.0061758027801676225
+ 5.5689003067335253e-05 0.0060682511154162089
+ 5.5689029687001963e-05 0.0059566013086644297
+ 5.568905630666868e-05 0.0058412203541628417
+ 5.568908292633539e-05 0.0057224716479485063
+ 5.56891095460021e-05 0.0056007139318451742
+ 5.568913616566881e-05 0.0054763002948580381
+ 5.5689162785335519e-05 0.0053495772343856614
+ 5.5689189405002229e-05 0.0052208837792675896
+ 5.5689216024668939e-05 0.0050905506764474901
+ 5.5689239404935229e-05 0.0049749804171373225
+ 5.5689262785201519e-05 0.0048586054363550972
+ 5.5689286165467809e-05 0.0047416314482211135
+ 5.5689309545734092e-05 0.0046242577652878883
+ 5.5689332926000382e-05 0.0045066770343838705
+ 5.5689356306266672e-05 0.0043890750025309139
+ 5.5689379686532962e-05 0.0042716303126259531
+ 5.5689403066799245e-05 0.0041545143284691553
+ 5.5689426447065535e-05 0.0040378909886185305
+ 5.5689449827331825e-05 0.0039219166884552218
+ 5.5689473207598115e-05 0.0038067401897542695
+ 5.5689496587864398e-05 0.0036925025569730643
+ 5.5689519968130688e-05 0.0035793371193940525
+ 5.5689543348396978e-05 0.0034673694581895016
+ 5.5689566728663267e-05 0.0033567174174145066
+ 5.5689590108929551e-05 0.0032474911378798247
+ 5.568961348919584e-05 0.0031397931128086067
+ 5.568963686946213e-05 0.0030337182641405314
+ 5.568966024972842e-05 0.0029293540383132049
+ 5.5689683629994703e-05 0.0028267805203238136
+ 5.5689707010260993e-05 0.0027260705648536779
+ 5.5689735591237521e-05 0.0026055855381113117
+ 5.5689764172214041e-05 0.0024880893416989024
+ 5.5689792753190568e-05 0.0023736731389782805
+ 5.5689821334167089e-05 0.0022624136400195647
+ 5.5689849915143616e-05 0.0021543736566158275
+ 5.5689886199806214e-05 0.0020219271947776738
+ 5.5689925453373381e-05 0.0018846580284455387
+ 5.5689946977215266e-05 0.0018120618774395494
+ 5.5689973696714703e-05 0.0017245821083065652
+ 5.5690000416214139e-05 0.0016400258203643724
+ 5.5690027135713575e-05 0.0015583844444338579
+ 5.5690053855213011e-05 0.0014796423351417674
+ 5.5690080574712447e-05 0.0014037772468436488
+ 5.5690107294211883e-05 0.0013307608065583204
+ 5.5690134013711319e-05 0.0012605589819463642
+ 5.5690160733210755e-05 0.0011931325425094006
+ 5.5690187452710191e-05 0.0011284375123336611
+ 5.5690214172209627e-05 0.0010664256128491564
+ 5.5690240891709063e-05 0.0010070446942234952
+ 5.569026254885961e-05 0.00096080661895637035
+ 5.5690284206010163e-05 0.0009162294538821239
+ 5.5690305863160717e-05 0.00087328092606094238
+ 5.569032752031127e-05 0.00083192771752318962
+ 5.5690349177461824e-05 0.00079213559354230647
+ 5.569037083461237e-05 0.00075386952625768001
+ 5.5690392491762924e-05 0.00071709381353394315
+ 5.5690414148913477e-05 0.00068177219296354193
+ 5.5690435806064024e-05 0.00064786795094112185
+ 5.5690457463214577e-05 0.00061534402675914772
+ 5.5690479120365131e-05 0.00058416311167918647
+ 5.5690496765399605e-05 0.00055972551886932095
+ 5.569051441043408e-05 0.00053613426244406741
+ 5.5690532055468555e-05 0.00051336904748169171
+ 5.5690549700503029e-05 0.00049140960981622914
+ 5.5690567345537497e-05 0.00047023574348777509
+ 5.5690584990571972e-05 0.00044982732676715286
+ 5.5690602635606446e-05 0.00043016434677204047
+ 5.5690620280640921e-05 0.00041122692269401575
+ 5.5690637925675396e-05 0.00039299532765819798
+ 5.569065557070987e-05 0.00037545000923921415
+ 5.5690673215744345e-05 0.00035857160865911174
+ 5.5690690860778813e-05 0.00034234097869457157
+ 5.5690708505813287e-05 0.00032673920032235228
+ 5.5690726150847762e-05 0.00031174759813332067
+ 5.5690743795882236e-05 0.00029734775454669758
+ 5.5690761440916711e-05 0.00028352152285727745
+ 5.5690779085951186e-05 0.0002702510391493668
+ 5.569079673098566e-05 0.00025751873311203796
+ 5.5690814376020135e-05 0.00024530733779101174
+ 5.569083202105461e-05 0.00023359989831307307
+ 5.5690849666089077e-05 0.00022237977961939102
+ 5.5690867311123552e-05 0.00021163067324446447
+ 5.5690884956158027e-05 0.00020133660317765155
+ 5.5690902601192501e-05 0.00019148193084437179
+ 5.5690920246226976e-05 0.00018205135924409671
+ 5.569093789126145e-05 0.00017302993628217709
+ 5.5690955536295925e-05 0.00016440305733239472
+ 5.5690973181330393e-05 0.00015615646706688136
+ 5.5690990826364868e-05 0.00014827626058972067
+ 5.5691008471399342e-05 0.00014074888391014853
+ 5.5691026116433817e-05 0.00013356113379079491
+ 5.5691043761468291e-05 0.00012670015700587552
+ 5.5691061406502766e-05 0.00012015344904364461
+ 5.5691079051537241e-05 0.00011390885228677083
+ 5.5691096696571715e-05 0.00010795455370359766
+ 5.569111434160619e-05 0.00010227908208250491
+ 5.5691131986640658e-05 9.687130484080241e-05
+ 5.5691149631675132e-05 9.1720424438765868e-05
+ 5.5691167276709607e-05 8.6815974428572379e-05
+ 5.5691184921744082e-05 8.2147815167013072e-05
+ 5.5691202566778556e-05 7.7706129219957601e-05
+ 5.5691220211813031e-05 7.3481416485622882e-05
+ 5.5691237856847505e-05 6.9464489062760908e-05
+ 5.5691255501881973e-05 6.5646465888930612e-05
+ 5.5691273146916448e-05 6.2018767173060703e-05
+ 5.5691290791950922e-05 5.8573108645546759e-05
+ 5.5691308436985397e-05 5.5301495648160228e-05
+ 5.5691326082019872e-05 5.2196217085081444e-05
+ 5.5691343727054346e-05 4.9249839255407143e-05
+ 5.5691361372088821e-05 4.6455199586526805e-05
+ 5.5691379017123296e-05 4.3805400286814076e-05
+ 5.569139666215777e-05 4.1293801935142287e-05
+ 5.5691414307192238e-05 3.8914017023807698e-05
+ 5.5691431952226713e-05 3.6659903470533496e-05
+ 5.5691449597261187e-05 3.4525558114332587e-05
+ 5.5691467242295662e-05 3.2505310209129923e-05
+ 5.5691484887330136e-05 3.0593714928186798e-05
+ 5.5691502532364611e-05 2.878554689153125e-05
+ 5.5691520177399086e-05 2.7075793727781893e-05
+ 5.5691537822433553e-05 2.5459649680957857e-05
+ 5.5691555467468028e-05 2.3932509272096093e-05
+ 5.5691573112502503e-05 2.2489961024749567e-05
+ 5.5691590757536977e-05 2.1127781262716843e-05
+ 5.5691608402571452e-05 1.9841927987655173e-05
+ 5.5691626047605927e-05 1.8628534843556469e-05
+ 5.5691643692640401e-05 1.7483905174418017e-05
+ 5.5691661337674876e-05 1.6404506180818473e-05
+ 5.5691682620107581e-05 1.5184596516820046e-05
+ 5.5691702745281677e-05 1.4108722156777394e-05
+ 5.5691722870455781e-05 1.3103783271809466e-05
+ 5.5691742995629884e-05 1.2165512099818384e-05
+ 5.5691763120803988e-05 1.1289867233639744e-05
+ 5.5691783245978091e-05 1.0473023791237365e-05
+ 5.5691803371152195e-05 9.711363860421274e-06
+ 5.5691823496326298e-05 9.0014672215583367e-06
+ 5.5691843621500395e-05 8.3401023506671107e-06
+ 5.5691863746674498e-05 7.7242177042852387e-06
+ 5.5691888110746131e-05 7.0353574872189284e-06
+ 5.5691912474817757e-05 6.4041509733236313e-06
+ 5.5691936838889382e-05 5.8261375978047346e-06
+ 5.5691961202961008e-05 5.2971679183216326e-06
+ 5.5691985567032641e-05 4.8133849648221628e-06
+ 5.5692009931104267e-05 4.3712064413582404e-06
+ 5.5692034295175892e-05 3.9673077642003495e-06
+ 5.5692058659247518e-05 3.5986059186122073e-06
+ 5.5692083023319151e-05 3.2622441148827113e-06
+ 5.5692107387390777e-05 2.955577222710442e-06
+ 5.569213671968357e-05 2.6223173518557521e-06
+ 5.5692166051976363e-05 2.3246430183300364e-06
+ 5.5692195384269163e-05 2.0589938235170389e-06
+ 5.5692224716561956e-05 1.8221375097881734e-06
+ 5.5692254048854749e-05 1.6111428978970881e-06
+ 5.5692283381147542e-05 1.4233547079677823e-06
+ 5.5692312713440342e-05 1.2563701699769522e-06
+ 5.5692342045733135e-05 1.1080173307665688e-06
+ 5.56923778480292e-05 9.4935328593955194e-07
+ 5.5692412335454634e-05 8.1703614317247063e-07
+ 5.5692446822880062e-05 7.0231034037170861e-07
+ 5.5692481310305496e-05 6.0295931014601184e-07
+ 5.5692515797730931e-05 5.1702814794412422e-07
+ 5.5692557828321209e-05 4.2796498791424164e-07
+ 5.5692599858911487e-05 3.5358466304975593e-07
+ 5.5692641889501765e-05 2.9157919961691281e-07
+ 5.5692683920092049e-05 2.3998333476715486e-07
+ 5.5692725950682327e-05 1.9712710629082681e-07
+ 5.5692777518503426e-05 1.5442331314774624e-07
+ 5.5692828186666485e-05 1.2110746118199679e-07
+ 5.5692878854829543e-05 9.4668212428266369e-08
+ 5.5692929522992602e-05 7.3741045625230226e-08
+ 5.5692993215143466e-05 5.3572482382509411e-08
+ 5.569305690729433e-05 3.8650410566722333e-08
+ 5.5693120599445195e-05 2.7655607125139506e-08
+ 5.5693198945610715e-05 1.80624388894615e-08
+ 5.5693278657649693e-05 1.1455385675920075e-08
+ 5.5693358369688671e-05 7.0279116712338033e-09
+ 5.5693461292370767e-05 3.42722610432318e-09
+ 5.5693569508909822e-05 1.2415251844169095e-09
+ 5.5693701914804441e-05 -1.7423168879043324e-10
+ 5.5693847065030183e-05 -9.0046498724308251e-10
+ 5.5694034315235683e-05 -1.2675598336250834e-09
+ 5.5694255865010425e-05 -1.390661486095478e-09
+ 5.5694554034092501e-05 -1.4079464626524889e-09
+ 5.5694998769870891e-05 -1.3781166774969621e-09
+ 5.5695805003988993e-05 -1.313948994893242e-09
+ 5.5696711764368313e-05 -1.2450592154006523e-09
+ 5.5697737475686441e-05 -1.1711746826522686e-09
+ 5.5698801143402345e-05 -1.0985374417948889e-09
+ 5.5699944764949551e-05 -1.0244977902794022e-09
+ 5.570223164627891e-05 -8.876839903243166e-10
+ 5.5704182681216658e-05 -7.8153991862173163e-10
+ 5.5706291228517252e-05 -6.7660226349856925e-10
+ 5.570858146743616e-05 -5.7299433820914436e-10
+ 5.5710926666850025e-05 -4.7698621811411996e-10
+ 5.571327186626389e-05 -3.901690868650475e-10
+ 5.5715590537179633e-05 -3.1248869476676087e-10
+ 5.571847456948428e-05 -2.2600941125466692e-10
+ 5.5721358601788933e-05 -1.4953972152878652e-10
+ 5.572424263409358e-05 -8.1909642546355165e-11
+ 5.5727126666398226e-05 -2.2097231394821104e-11
+ 5.5730010698702879e-05 3.0804763949844941e-11
+ 5.5732894731007526e-05 7.7599184420572088e-11
+ 5.5735778763312173e-05 1.1899177680085989e-10
+ 5.5739342797663596e-05 1.6360497315690482e-10
+ 5.5742906832015013e-05 2.0194460469335925e-10
+ 5.5746470866366437e-05 2.3489304324568193e-10
+ 5.5750034900717854e-05 2.6320792465228799e-10
+ 5.5753598935069271e-05 2.8754418863776942e-10
+ 5.5757899961127365e-05 3.124003450031708e-10
+ 5.5762200987185451e-05 3.3310188136055884e-10
+ 5.5766502013243537e-05 3.5034335018174361e-10
+ 5.577080303930163e-05 3.6470346013268147e-10
+ 5.5775104065359717e-05 3.7666442373221598e-10
+ 5.5780502505986987e-05 3.8888313831481749e-10
+ 5.5785900946614251e-05 3.9859542479219459e-10
+ 5.5791299387241515e-05 4.0629545583254085e-10
+ 5.5796697827868785e-05 4.1242659596079512e-10
+ 5.5803468247657473e-05 4.1836450212166619e-10
+ 5.5810238667446161e-05 4.228142873871682e-10
+ 5.5817009087234848e-05 4.2614500842071573e-10
+ 5.5825385304343961e-05 4.2912633403108892e-10
+ 5.5833761521453073e-05 4.3120345772378355e-10
+ 5.5842137738562186e-05 4.3264838822889765e-10
+ 5.5853043385488658e-05 4.3388610175178318e-10
+ 5.5863949032415131e-05 4.3464666000495187e-10
+ 5.5876156063665129e-05 4.3514763453961883e-10
+ 5.5888363094915135e-05 4.3542384097085643e-10
+ 5.5900570126165133e-05 4.3556624282357159e-10
+ 5.5912777157415132e-05 4.3562884855868211e-10
+ 5.5924984188665137e-05 4.3564390919099658e-10
+ 5.5937191219915136e-05 4.3563071731303817e-10
+ 5.5949398251165135e-05 4.3560072832369711e-10
+ 5.5961605282415133e-05 4.3556071800624522e-10
+ 5.5973812313665132e-05 4.3551473285478916e-10
+ 5.5986019344915137e-05 4.3546520640556509e-10
+ 5.5998226376165136e-05 4.3541358487496968e-10
+ 5.6010433407415135e-05 4.3536071753580087e-10
+ 5.602264043866514e-05 4.353071102954193e-10
+ 5.6034847469915139e-05 4.3525307030070124e-10
+ 5.6047054501165138e-05 4.3519878102624261e-10
+ 5.6059261532415136e-05 4.3514434891989702e-10
+ 5.6071468563665135e-05 4.3508983678706616e-10
+ 5.608367559491514e-05 4.3503528333983576e-10
+ 5.6095882626165139e-05 4.3498071205926307e-10
+ 5.6108089657415138e-05 4.3492613633167183e-10
+ 5.6120296688665143e-05 4.348715638520445e-10
+ 5.6132503719915142e-05 4.3481699946235471e-10
+ 5.614471075116514e-05 4.3476244620745766e-10
+ 5.6156917782415139e-05 4.3470790578886986e-10
+ 5.6169124813665138e-05 4.3465337912630206e-10
+ 5.6181331844915143e-05 4.3459886680952396e-10
+ 5.6193538876165142e-05 4.3454436923774573e-10
+ 5.620574590741514e-05 4.3448988663097442e-10
+ 5.6217952938665146e-05 4.3443541909242035e-10
+ 5.6230159969915144e-05 4.3438096668679938e-10
+ 5.6242367001165143e-05 4.3432652946422885e-10
+ 5.6250000000000005e-05 4.3429323819786375e-10
+ 5.6262207031250004e-05 4.3423882549145797e-10
+ 5.6274414062500003e-05 4.3418442800650571e-10
+ 5.6286621093750008e-05 4.3413004574565444e-10
+ 5.6298828125000007e-05 4.3407567870875607e-10
+ 5.6311035156250005e-05 4.3402132689399754e-10
+ 5.6323242187500004e-05 4.3396699029857563e-10
+ 5.6335449218750003e-05 4.3391266891909689e-10
+ 5.6347656250000008e-05 4.338583627518177e-10
+ 5.6359863281250007e-05 4.338040717927861e-10
+ 5.6372070312500005e-05 4.3374979603792648e-10
+ 5.6384277343750004e-05 4.3369553548309005e-10
+ 5.6396484375000003e-05 4.3364129012408513e-10
+ 5.6408691406250008e-05 4.3358705995669485e-10
+ 5.6420898437500007e-05 4.3353284497668784e-10
+ 5.6433105468750005e-05 4.3347864517982436e-10
+ 5.6445312500000004e-05 4.3342446056186068e-10
+ 5.6457519531250003e-05 4.3337029111855061e-10
+ 5.6469726562500008e-05 4.3331613684564742e-10
+ 5.6481933593750007e-05 4.3326199773890431e-10
+ 5.6494140625000005e-05 4.3320787379407488e-10
+ 5.6506347656250004e-05 4.3315376500691365e-10
+ 5.6518554687500003e-05 4.3309967137317592e-10
+ 5.6530761718750008e-05 4.3304559288861817e-10
+ 5.6542968750000007e-05 4.3299152954899793e-10
+ 5.6555175781250006e-05 4.3293748135007384e-10
+ 5.6567382812500004e-05 4.3288344828760572e-10
+ 5.6579589843750003e-05 4.3282943035735457e-10
+ 5.6591796875000008e-05 4.3277542755508266e-10
+ 5.6604003906250007e-05 4.327214398765532e-10
+ 5.6616210937500006e-05 4.3266746731753079e-10
+ 5.6628417968750004e-05 4.3261350987378112e-10
+ 5.6640625000000003e-05 4.3255956754107106e-10
+ 5.6652832031250008e-05 4.3250564031516869e-10
+ 5.6665039062500007e-05 4.324517281918434e-10
+ 5.6677246093750006e-05 4.3239783116686546e-10
+ 5.6689453125000004e-05 4.3234394923600652e-10
+ 5.6701660156250003e-05 4.3229008239503964e-10
+ 5.6713867187500002e-05 4.322362306397386e-10
+ 5.6726074218750007e-05 4.3218239396587857e-10
+ 5.6738281250000006e-05 4.3212857236923607e-10
+ 5.6750488281250004e-05 4.3207476584558855e-10
+ 5.6762695312500003e-05 4.3202097439071481e-10
+ 5.6774902343750008e-05 4.3196719800039462e-10
+ 5.6787109375000007e-05 4.3191343667040926e-10
+ 5.6799316406250006e-05 4.3185969039654094e-10
+ 5.6811523437500004e-05 4.3180595917457319e-10
+ 5.6823730468750003e-05 4.3175224300029046e-10
+ 5.6835937500000008e-05 4.3169854186947872e-10
+ 5.6848144531250007e-05 4.3164485577792515e-10
+ 5.6860351562500006e-05 4.3159118472141752e-10
+ 5.6872558593750004e-05 4.315375286957455e-10
+ 5.6884765625000003e-05 4.3148388769669956e-10
+ 5.6896972656250009e-05 4.3143026172007142e-10
+ 5.6909179687500007e-05 4.3137665076165393e-10
+ 5.6921386718750006e-05 4.3132305481724119e-10
+ 5.6933593750000004e-05 4.3126947388262849e-10
+ 5.6945800781250003e-05 4.3121590795361226e-10
+ 5.6958007812500009e-05 4.3116235702599014e-10
+ 5.6970214843750007e-05 4.311088210955608e-10
+ 5.6982421875000006e-05 4.3105530015812432e-10
+ 5.6994628906250005e-05 4.3100179420948178e-10
+ 5.7006835937500003e-05 4.3094830324543561e-10
+ 5.7019042968750009e-05 4.3089482726178914e-10
+ 5.7031250000000007e-05 4.3084136625434698e-10
+ 5.7043457031250006e-05 4.3078792021891527e-10
+ 5.7055664062500005e-05 4.3073448915130076e-10
+ 5.7067871093750003e-05 4.3068107304731183e-10
+ 5.7080078125000009e-05 4.3062767190275767e-10
+ 5.7092285156250007e-05 4.3057428571344897e-10
+ 5.7104492187500006e-05 4.305209144751974e-10
+ 5.7116699218750005e-05 4.3046755818381573e-10
+ 5.7128906250000003e-05 4.3041421683511815e-10
+ 5.7141113281250009e-05 4.3036089042491982e-10
+ 5.7153320312500007e-05 4.3030757894903721e-10
+ 5.7165527343750006e-05 4.3025428240328784e-10
+ 5.7177734375000005e-05 4.3020100078349046e-10
+ 5.7189941406250003e-05 4.3014773408546503e-10
+ 5.7202148437500009e-05 4.3009448230503257e-10
+ 5.7214355468750007e-05 4.3004124543801536e-10
+ 5.7226562500000006e-05 4.2998802348023685e-10
+ 5.7238769531250005e-05 4.2993481642752165e-10
+ 5.7250976562500003e-05 4.298816242756955e-10
+ 5.7263183593750009e-05 4.2982844702058526e-10
+ 5.7275390625000008e-05 4.2977528465801911e-10
+ 5.7287597656250006e-05 4.2972213718382639e-10
+ 5.7299804687500005e-05 4.296690045938374e-10
+ 5.7312011718750003e-05 4.2961588688388387e-10
+ 5.7324218750000002e-05 4.2956278404979846e-10
+ 5.7336425781250008e-05 4.2950969608741529e-10
+ 5.7348632812500006e-05 4.2945662299256918e-10
+ 5.7360839843750005e-05 4.2940356476109669e-10
+ 5.7373046875000004e-05 4.2935052138883517e-10
+ 5.7385253906250002e-05 4.2929749287162315e-10
+ 5.7397460937500008e-05 4.2924447920530045e-10
+ 5.7409667968750006e-05 4.2919148038570803e-10
+ 5.7421875000000005e-05 4.2913849640868801e-10
+ 5.7434082031250004e-05 4.2908552727008359e-10
+ 5.7446289062500002e-05 4.2903257296573924e-10
+ 5.7458496093750008e-05 4.2897963349150058e-10
+ 5.7470703125000006e-05 4.2892670884321429e-10
+ 5.7482910156250005e-05 4.288737990167283e-10
+ 5.7495117187500004e-05 4.2882090400789185e-10
+ 5.7507324218750002e-05 4.2876802381255504e-10
+ 5.7519531250000008e-05 4.2871515842656934e-10
+ 5.7531738281250006e-05 4.2866230784578723e-10
+ 5.7543945312500005e-05 4.2860947206606246e-10
+ 5.7556152343750004e-05 4.2855665108325002e-10
+ 5.7568359375000002e-05 4.2850384489320595e-10
+ 5.7580566406250001e-05 4.2845105349178732e-10
+ 5.7592773437500006e-05 4.2839827687485269e-10
+ 5.7604980468750005e-05 4.2834551503826145e-10
+ 5.7617187500000004e-05 4.2829276797787439e-10
+ 5.7629394531250002e-05 4.2824003568955333e-10
+ 5.7641601562500001e-05 4.2818731816916134e-10
+ 5.7653808593750006e-05 4.2813461541256231e-10
+ 5.7666015625000005e-05 4.2808192741562203e-10
+ 5.7678222656250004e-05 4.2802925417420679e-10
+ 5.7690429687500002e-05 4.2797659568418397e-10
+ 5.7702636718750001e-05 4.2792395194142275e-10
+ 5.771484375e-05 4.2787132294179297e-10
+ 5.7727050781250005e-05 4.2781870868116553e-10
+ 5.7739257812500004e-05 4.2776610915541303e-10
+ 5.7751464843750003e-05 4.2771352436040875e-10
+ 5.7763671875000001e-05 4.2766095429202714e-10
+ 5.777587890625e-05 4.2760839894614423e-10
+ 5.7788085937500005e-05 4.2755585831863669e-10
+ 5.7800292968750004e-05 4.2750333240538267e-10
+ 5.7812500000000003e-05 4.2745082120226136e-10
+ 5.7824707031250001e-05 4.2739832470515305e-10
+ 5.78369140625e-05 4.273458429099393e-10
+ 5.7849121093750005e-05 4.2729337581250278e-10
+ 5.7861328125000004e-05 4.2724092340872732e-10
+ 5.7873535156250003e-05 4.2718848569449787e-10
+ 5.7885742187500001e-05 4.2713606266570053e-10
+ 5.789794921875e-05 4.2708365431822263e-10
+ 5.7910156250000005e-05 4.270312606479525e-10
+ 5.7922363281250004e-05 4.2697888165077988e-10
+ 5.7934570312500003e-05 4.2692651732259529e-10
+ 5.7946777343750001e-05 4.2687416765929084e-10
+ 5.7958984375e-05 4.2682183265675928e-10
+ 5.7971191406249999e-05 4.2676951231089505e-10
+ 5.7983398437500004e-05 4.2671720661759342e-10
+ 5.7995605468750003e-05 4.2666491557275079e-10
+ 5.8007812500000001e-05 4.2661263917226478e-10
+ 5.802001953125e-05 4.265603774120343e-10
+ 5.8032226562499999e-05 4.265081302879591e-10
+ 5.8044433593750004e-05 4.2645589779594043e-10
+ 5.8056640625000003e-05 4.2640367993188038e-10
+ 5.8068847656250001e-05 4.2635147669168246e-10
+ 5.80810546875e-05 4.2629928807125108e-10
+ 5.8093261718749999e-05 4.2624711406649186e-10
+ 5.8105468749999997e-05 4.2619495467331169e-10
+ 5.8117675781250003e-05 4.2614280988761856e-10
+ 5.8129882812500001e-05 4.2609067970532156e-10
+ 5.814208984375e-05 4.2603856412233079e-10
+ 5.8154296874999999e-05 4.2598646313455786e-10
+ 5.8166503906249997e-05 4.2593437673791515e-10
+ 5.8178710937500003e-05 4.2588230492831644e-10
+ 5.8190917968750002e-05 4.2583024770167654e-10
+ 5.8203125e-05 4.2577820505391141e-10
+ 5.8215332031249999e-05 4.2572617698093814e-10
+ 5.8227539062499998e-05 4.2567416347867499e-10
+ 5.8239746093750003e-05 4.2562216454304139e-10
+ 5.8251953125000002e-05 4.2557018016995789e-10
+ 5.826416015625e-05 4.2551821035534623e-10
+ 5.8276367187499999e-05 4.2546625509512913e-10
+ 5.8288574218749998e-05 4.254143143852306e-10
+ 5.8300781250000003e-05 4.2536238822157581e-10
+ 5.8312988281250002e-05 4.2531047660009089e-10
+ 5.83251953125e-05 4.2525857951670346e-10
+ 5.8337402343749999e-05 4.252066969673418e-10
+ 5.8349609374999998e-05 4.2515482894793579e-10
+ 5.8361816406249996e-05 4.2510297545441604e-10
+ 5.8374023437500002e-05 4.2505113648271467e-10
+ 5.838623046875e-05 4.2499931202876474e-10
+ 5.8398437499999999e-05 4.2494750208850055e-10
+ 5.8410644531249998e-05 4.248957066578573e-10
+ 5.8422851562499996e-05 4.2482519493572964e-10
+ 5.8435058593750002e-05 4.2475256100502045e-10
+ 5.8447265625e-05 4.2468173951608737e-10
+ 5.8459472656249999e-05 4.2459666096075283e-10
+ 5.8471679687499998e-05 4.2448010616874532e-10
+ 5.8483886718749996e-05 4.242745676347303e-10
+ 5.8489990234374996e-05 4.2406762246865748e-10
+ 5.8496093749999995e-05 4.2364446431160585e-10
+ 5.8499145507812501e-05 4.2320637096990359e-10
+ 5.8502197265625001e-05 4.2237081875579266e-10
+ 5.8505249023437501e-05 4.2039912634768696e-10
+ 5.8506606790774093e-05 4.184858057925494e-10
+ 5.8506998216660865e-05 4.1769354662518729e-10
+ 5.8507389642547638e-05 4.1673967866159501e-10
+ 5.8508368207264581e-05 4.1328644574257995e-10
+ 5.8509409502908191e-05 4.0647792025774505e-10
+ 5.8509970598735327e-05 4.0009399586852752e-10
+ 5.8510339629298372e-05 3.9400830485401903e-10
+ 5.8511110323815848e-05 3.7217296598144555e-10
+ 5.8511741481233851e-05 3.3482378565862255e-10
+ 5.8512113084009013e-05 2.9476725253157392e-10
+ 5.8512434193795797e-05 2.3913652951300332e-10
+ 5.8512647097925413e-05 2.1273235713088472e-10
+ 5.8512860002055035e-05 2.1207408791108858e-10
+ 5.8514989043351249e-05 2.1185023895337551e-10
+ 5.8527196074601248e-05 2.0757980032582087e-10
+ 5.8539403105851246e-05 1.9827504053149293e-10
+ 5.8551610137101252e-05 1.8447156434439206e-10
+ 5.8563817168351251e-05 1.6696410651490149e-10
+ 5.8576024199601249e-05 1.4676018343964647e-10
+ 5.8588231230851248e-05 1.2502212943217047e-10
+ 5.8600438262101246e-05 1.0300022779102304e-10
+ 5.8612645293351252e-05 8.1960799754197404e-11
+ 5.8624852324601251e-05 6.311338755160194e-11
+ 5.8637059355851249e-05 4.7541218733423125e-11
+ 5.8649266387101248e-05 3.6138949326912032e-11
+ 5.8661473418351247e-05 2.9561263935700322e-11
+ 5.8673680449601245e-05 2.8185285811614418e-11
+ 5.8685887480851251e-05 3.2088955187765566e-11
+ 5.8698094512101249e-05 4.1046615499322252e-11
+ 5.8710301543351248e-05 5.4542057385810135e-11
+ 5.8722508574601247e-05 7.1798266491615728e-11
+ 5.8734715605851245e-05 9.1822160785597292e-11
+ 5.8746922637101251e-05 1.1346174161334856e-10
+ 5.8759129668351249e-05 1.3547236949090519e-10
+ 5.8771336699601248e-05 1.5658835172212636e-10
+ 5.8783543730851247e-05 1.7559572435646284e-10
+ 5.8795750762101245e-05 1.9140204326212496e-10
+ 5.8807957793351244e-05 2.030991720132836e-10
+ 5.881100955116375e-05 2.0529687447679853e-10
+ 5.8811314726944996e-05 2.0549982177660819e-10
+ 5.8812077666398126e-05 2.0599366009052315e-10
+ 5.8812459136124687e-05 2.062333046850057e-10
+ 5.8812482977982591e-05 2.0624812098499301e-10
+ 5.8812487746354175e-05 2.0625108196291897e-10
+ 5.8812497283097342e-05 2.0625700163649109e-10
+ 5.8812498046036791e-05 2.0625747507891284e-10
+ 5.8812499571915701e-05 2.0625842190532621e-10
+ 5.881249969398601e-05 2.0625849764807365e-10
+ 5.8812499938126635e-05 2.0625864913207268e-10
+ 5.8812499957657887e-05 2.0625866125070641e-10
+ 5.881249999672039e-05 2.0625868548793557e-10
+ 5.881250007484539e-05 8.3574849775232329e-10
+ 5.8812500152970389e-05 2.8382408459534785e-09
+ 5.8812500934220386e-05 9.7910663945931592e-08
+ 5.881250805184598e-05 6.9281309170090845e-06
+ 5.8812515169471575e-05 2.3496919613390592e-05
+ 5.8812522287097176e-05 4.8515586154137975e-05
+ 5.881252940472277e-05 8.0864107426474553e-05
+ 5.8812536522348364e-05 0.0001195688537478285
+ 5.8812543639973958e-05 0.00016378325676260678
+ 5.881255075759956e-05 0.00021277103077073492
+ 5.8812557875225154e-05 0.00026589161027525284
+ 5.8812564992850748e-05 0.00032258751106878353
+ 5.8812572110476349e-05 0.00038237336083026571
+ 5.8812579228101943e-05 0.00044482637875059637
+ 5.8812587807568575e-05 0.00052313156179263198
+ 5.8812596387035207e-05 0.00060422377214069478
+ 5.8812604966501839e-05 0.00068763160407692863
+ 5.8812613545968472e-05 0.00077295453496090106
+ 5.8812622125435104e-05 0.00085985181282763258
+ 5.8812630704901736e-05 0.00094803308914625053
+ 5.8812639284368368e-05 0.0010372505228311898
+ 5.8812647863835e-05 0.0011272921245865509
+ 5.8812658180770253e-05 0.0012364048498757886
+ 5.8812668497705507e-05 0.0013461799437633384
+ 5.8812678814640768e-05 0.0014563930288477433
+ 5.8812689131576021e-05 0.001566855276772596
+ 5.8812699448511275e-05 0.0016774068636345029
+ 5.8812709765446535e-05 0.001787911643031166
+ 5.8812720082381789e-05 0.0018982528107135616
+ 5.8812730399317043e-05 0.0020083293767566338
+ 5.8812742902012265e-05 0.002141246780886198
+ 5.8812755404707481e-05 0.0022735106700283729
+ 5.8812767907402703e-05 0.0024050029041599369
+ 5.8812780410097919e-05 0.0025356196305195535
+ 5.8812792912793141e-05 0.0026652683340791378
+ 5.8812805415488357e-05 0.002793865545581445
+ 5.881281791818358e-05 0.0029213350620943554
+ 5.8812830420878795e-05 0.0030476065669750823
+ 5.8812845592253877e-05 0.0031991277392290247
+ 5.8812860763628958e-05 0.0033486794005026179
+ 5.881287593500404e-05 0.0034961593179601309
+ 5.8812891106379121e-05 0.0036414711081661105
+ 5.8812906277754196e-05 0.0037845233735065873
+ 5.8812921449129278e-05 0.0039252290818992874
+ 5.8812936620504359e-05 0.0040635051254073566
+ 5.8812954860519563e-05 0.0042264209820281088
+ 5.8812973100534775e-05 0.0043855785109888799
+ 5.8812991340549979e-05 0.004540852807539594
+ 5.881300958056519e-05 0.0046921255232483241
+ 5.8813027820580394e-05 0.004839284756390172
+ 5.8813046060595599e-05 0.0049822250059800644
+ 5.8813068199865847e-05 0.0051499118748984281
+ 5.8813090339136095e-05 0.0053110729761570875
+ 5.881311247840635e-05 0.0054655577982168782
+ 5.8813134617676599e-05 0.0056132299331846198
+ 5.8813161293011324e-05 0.0057819364493443522
+ 5.8813187873095811e-05 0.0059398423573548687
+ 5.8813214453180299e-05 0.0060874136176253622
+ 5.8813248688484344e-05 0.0062620603819550135
+ 5.8813282923788388e-05 0.0064191641307141745
+ 5.881331535612705e-05 0.0065517091134031152
+ 5.8813347788465718e-05 0.0066683776453289999
+ 5.881338022080438e-05 0.0067692021882621509
+ 5.8813412653143041e-05 0.0068542763543729904
+ 5.8813445085481709e-05 0.0069237529436825757
+ 5.8813477517820371e-05 0.0069778416850672731
+ 5.8813509950159032e-05 0.0070168067033145008
+ 5.8813542382497701e-05 0.0070409637367341727
+ 5.8813569584998152e-05 0.0070500711051410814
+ 5.8813596787498604e-05 0.0070492564131712353
+ 5.8813623989999056e-05 0.0070387804986578604
+ 5.8813651192499508e-05 0.0070189238317284377
+ 5.8813678394999966e-05 0.0069899850256677273
+ 5.8813705597500418e-05 0.0069522793135452206
+ 5.881373280000087e-05 0.0069061369988542495
+ 5.8813760002501329e-05 0.0068519018883273245
+ 5.8813787205001781e-05 0.0067899297149596706
+ 5.8813814407502232e-05 0.0067205865590935169
+ 5.8813841610002684e-05 0.0066442472751925379
+ 5.8813868812503136e-05 0.006561293931672073
+ 5.8813896015003595e-05 0.0064721142708494637
+ 5.8813923217504047e-05 0.0063771001957435066
+ 5.8813950420004498e-05 0.0062766462900859356
+ 5.8813977622504957e-05 0.0061711483775146155
+ 5.8814004825005409e-05 0.0060610021255013743
+ 5.8814032027505861e-05 0.0059466016991306979
+ 5.8814059230006313e-05 0.0058283384693926773
+ 5.8814086432506764e-05 0.0057065997804302861
+ 5.8814115300883502e-05 0.0055740309990659331
+ 5.8814144169260239e-05 0.0054384272991202893
+ 5.881417303763697e-05 0.0053002282345430132
+ 5.8814201906013708e-05 0.0051598626838551204
+ 5.8814230774390445e-05 0.0050177476630414884
+ 5.8814259642767176e-05 0.0048742872442221231
+ 5.8814288511143913e-05 0.0047298715812966012
+ 5.8814317379520651e-05 0.0045848760430473451
+ 5.8814346247897381e-05 0.0044396604535071188
+ 5.8814381135166691e-05 0.0042643637747592994
+ 5.8814416022435993e-05 0.0040898203879790361
+ 5.8814449985506054e-05 0.0039211359224094145
+ 5.8814483948576115e-05 0.0037541355090310092
+ 5.8814517911646183e-05 0.0035892460195200843
+ 5.8814551874716244e-05 0.0034268598627977894
+ 5.8814585837786305e-05 0.0032673350066711841
+ 5.8814627381082825e-05 0.0030765664536155394
+ 5.8814668924379338e-05 0.0028910852643209248
+ 5.881471046767585e-05 0.0027113416169293153
+ 5.881475201097237e-05 0.0025377141992044784
+ 5.8814802322523106e-05 0.0023360685105670866
+ 5.8814853125173638e-05 0.0021424443576868821
+ 5.8814903927824176e-05 0.001959156496722657
+ 5.8814971607266251e-05 0.0017313192252947558
+ 5.8815039286708325e-05 0.0015222190408349249
+ 5.8815091919396572e-05 0.001372431253814393
+ 5.8815144552084819e-05 0.0012336381966261724
+ 5.8815197184773059e-05 0.0011055447342070166
+ 5.8815249817461306e-05 0.00098778684645394604
+ 5.8815297809929107e-05 0.00088906516794052203
+ 5.8815345802396909e-05 0.00079823747715313789
+ 5.8815393794864717e-05 0.00071492972227882204
+ 5.8815441787332518e-05 0.00063875107498295779
+ 5.881548977980032e-05 0.00056929990178360005
+ 5.8815537261554871e-05 0.00050680910974394439
+ 5.8815584743309415e-05 0.00045011010916966049
+ 5.8815632225063966e-05 0.00039881145821643485
+ 5.8815679706818517e-05 0.00035252854906615789
+ 5.8815727188573062e-05 0.00031088653907439246
+ 5.8815774670327613e-05 0.0002735227890958723
+ 5.8815824358583368e-05 0.00023862511600889196
+ 5.8815874046839129e-05 0.00020765025205703798
+ 5.8815923735094884e-05 0.00018023763188315632
+ 5.8815973423350638e-05 0.00015604795426756195
+ 5.88160231116064e-05 0.0001347637411803884
+ 5.8816072799862154e-05 0.00011608953467670693
+ 5.881612795138608e-05 9.8086983151495662e-05
+ 5.8816183102910005e-05 8.2620379659707852e-05
+ 5.881623825443393e-05 6.937830638173144e-05
+ 5.8816293405957856e-05 5.8079646203919961e-05
+ 5.8816348557481788e-05 4.8471998343402797e-05
+ 5.8816411640520546e-05 3.9267448447275403e-05
+ 5.8816474723559305e-05 3.1683839518460041e-05
+ 5.8816537806598064e-05 2.5463033689023789e-05
+ 5.8816600889636823e-05 2.0382309617297274e-05
+ 5.881667414014643e-05 1.5662206653736814e-05
+ 5.8816747390656038e-05 1.1971024407425274e-05
+ 5.8816820641165645e-05 9.101093726216712e-06
+ 5.8816905619421591e-05 6.5781195004269459e-06
+ 5.8816990597677529e-05 4.7207090840830405e-06
+ 5.8817093836844791e-05 3.1245246960755978e-06
+ 5.8817198171769416e-05 2.0371887602864823e-06
+ 5.8817302506694047e-05 1.3141391771344707e-06
+ 5.8817426664469166e-05 7.6923430377838728e-07
+ 5.8817550822244292e-05 4.435788450454647e-07
+ 5.8817705800806535e-05 2.1851475951109054e-07
+ 5.8817884937131789e-05 9.3708673373505121e-08
+ 5.8818098556602392e-05 3.2883700516734768e-08
+ 5.881836448572296e-05 8.5309004428172277e-09
+ 5.8818717982712209e-05 1.4552417250701691e-09
+ 5.8819242097564151e-05 3.0578689270965244e-10
+ 5.8820136340120477e-05 2.4569663308855879e-10
+ 5.8822132807185043e-05 2.4259754686171839e-10
+ 5.882398881685802e-05 2.4182034068072913e-10
+ 5.8826421668443085e-05 2.4138174969930913e-10
+ 5.8828854520028149e-05 2.4076582964276258e-10
+ 5.8831287371613213e-05 2.4012576594620444e-10
+ 5.8833720223198278e-05 2.4057963384973803e-10
+ 5.8836153074783335e-05 2.4092919901400983e-10
+ 5.8838585926368399e-05 2.401872610697499e-10
+ 5.8841018777953464e-05 2.3987554496708928e-10
+ 5.8843451629538528e-05 2.4037942571475707e-10
+ 5.8845767705239782e-05 2.4025247901632375e-10
+ 5.8848819440406721e-05 2.4017887589128354e-10
+ 5.8851871175573666e-05 2.4009951114703349e-10
+ 5.8854922910740604e-05 2.4004351142745323e-10
+ 5.8857974645907542e-05 2.4016098617015712e-10
+ 5.8861026381074481e-05 2.4071442426522539e-10
+ 5.8864078116241419e-05 2.3968616681674537e-10
+ 5.8867773618773606e-05 2.4003007462135484e-10
+ 5.8871134288610911e-05 2.4006402385879101e-10
+ 5.8874494958448223e-05 2.4006047129867007e-10
+ 5.8878620731690286e-05 2.4005210497337081e-10
+ 5.8882746504932342e-05 2.4004042399080182e-10
+ 5.8886872278174399e-05 2.4003044384477591e-10
+ 5.8890998051416462e-05 2.4003749578386358e-10
+ 5.8895123824658519e-05 2.4008180521387353e-10
+ 5.8900251138437102e-05 2.4016443526047099e-10
+ 5.8905378452215685e-05 2.3985136550844345e-10
+ 5.8910505765994268e-05 2.3994252727381691e-10
+ 5.8915633079772851e-05 2.4004700010028028e-10
+ 5.8921995979825158e-05 2.4004483697536087e-10
+ 5.8928358879877465e-05 2.3997024527683999e-10
+ 5.8934721779929772e-05 2.3997592655072043e-10
+ 5.8942497256254516e-05 2.4000749931504923e-10
+ 5.8950272732579254e-05 2.4001269631983051e-10
+ 5.8958048208903998e-05 2.3999782508278659e-10
+ 5.8967983441936075e-05 2.3999355892689472e-10
+ 5.8977918674968144e-05 2.4000179472492324e-10
+ 5.8990125706218149e-05 2.4000339716614338e-10
+ 5.9002332737468148e-05 2.3999888202599127e-10
+ 5.9014539768718147e-05 2.3999830525938688e-10
+ 5.9026746799968145e-05 2.4000037974237526e-10
+ 5.9038953831218144e-05 2.4000087414852165e-10
+ 5.9051160862468149e-05 2.3999993966201389e-10
+ 5.9063367893718148e-05 2.3999960494882817e-10
+ 5.9075574924968147e-05 2.4000001432309894e-10
+ 5.9087781956218145e-05 2.4000021737723387e-10
+ 5.9099988987468144e-05 2.4000004462513988e-10
+ 5.9112196018718143e-05 2.3999993006727966e-10
+ 5.9124403049968148e-05 2.3999999917748096e-10
+ 5.9136610081218147e-05 2.4000006049017395e-10
+ 5.9148817112468145e-05 2.4000003421757239e-10
+ 5.9161024143718144e-05 2.4000000237870328e-10
+ 5.9173231174968143e-05 2.4000001256652595e-10
+ 5.9185438206218148e-05 2.4000002745854788e-10
+ 5.9197645237468147e-05 2.4000002475271839e-10
+ 5.9209852268718145e-05 2.4000001795384735e-10
+ 5.9222059299968144e-05 2.400000173879749e-10
+ 5.9234266331218143e-05 2.4000002070407596e-10
+ 5.9246473362468148e-05 2.4000002067419452e-10
+ 5.9258680393718147e-05 2.4000001976473751e-10
+ 5.9270887424968146e-05 2.40000019362722e-10
+ 5.9283094456218144e-05 2.4000002028128461e-10
+ 5.9295301487468143e-05 2.4000002060646208e-10
+ 5.9307508518718148e-05 2.4000002008287723e-10
+ 5.9319715549968147e-05 2.4000001934276911e-10
+ 5.9331922581218146e-05 2.4000001968966948e-10
+ 5.9344129612468144e-05 2.4000002093381111e-10
+ 5.9356336643718143e-05 2.4000001965726013e-10
+ 5.9368543674968142e-05 2.4000001961507071e-10
+ 5.9380750706218147e-05 2.4000002048512451e-10
+ 5.9392957737468146e-05 2.4000001998121006e-10
+ 5.9405164768718144e-05 2.400000199764228e-10
+ 5.9417371799968143e-05 2.4000001998665694e-10
+ 5.9429578831218142e-05 2.4000001988395378e-10
+ 5.9441785862468147e-05 2.4000001969840786e-10
+ 5.9453992893718146e-05 2.4000001962628526e-10
+ 5.9466199924968144e-05 2.4000001985975601e-10
+ 5.9478406956218143e-05 2.4000001994562599e-10
+ 5.9490613987468142e-05 2.4000001873790616e-10
+ 5.950282101871814e-05 2.400000206888198e-10
+ 5.9515028049968146e-05 2.4000002115772409e-10
+ 5.9527235081218144e-05 2.4000001926167516e-10
+ 5.9539442112468143e-05 2.4000001865095655e-10
+ 5.9551649143718142e-05 2.4000002024868279e-10
+ 5.956385617496814e-05 2.4000002062807212e-10
+ 5.9576063206218146e-05 2.4000001971246058e-10
+ 5.9588270237468144e-05 2.4000001913611468e-10
+ 5.9600477268718143e-05 2.4000001939609548e-10
+ 5.9612684299968142e-05 2.4000001928925776e-10
+ 5.962489133121814e-05 2.4000002036211893e-10
+ 5.9637098362468146e-05 2.4000001948566678e-10
+ 5.9649305393718145e-05 2.40000020557049e-10
+ 5.9661512424968143e-05 2.400000203491446e-10
+ 5.9673719456218142e-05 2.4000001961720044e-10
+ 5.968592648746814e-05 2.400000200808237e-10
+ 5.9698133518718146e-05 2.4000002006495584e-10
+ 5.9710340549968145e-05 2.4000001941755901e-10
+ 5.9722547581218143e-05 2.4000001925514504e-10
+ 5.9734754612468142e-05 2.4000001949494439e-10
+ 5.9746961643718141e-05 2.4000001987457185e-10
+ 5.9759168674968139e-05 2.4000001956535886e-10
+ 5.9771375706218145e-05 2.4000001976899341e-10
+ 5.9783582737468143e-05 2.4000001989767335e-10
+ 5.9795789768718142e-05 2.4000002010421042e-10
+ 5.9807996799968141e-05 2.4000002031692612e-10
+ 5.9820203831218139e-05 2.4000001943796074e-10
+ 5.9832410862468145e-05 2.4000001979057998e-10
+ 5.9844617893718143e-05 2.4000001994141042e-10
+ 5.9856824924968142e-05 2.4000001910787902e-10
+ 5.9869031956218141e-05 2.4000002014157438e-10
+ 5.9881238987468139e-05 2.4000002007976212e-10
+ 5.9893446018718138e-05 2.4000001897875313e-10
+ 5.9905653049968143e-05 2.4000002030066949e-10
+ 5.9917860081218142e-05 2.4000002070432142e-10
+ 5.9930067112468141e-05 2.4000001950520541e-10
+ 5.9942274143718139e-05 2.4000001947980057e-10
+ 5.9954481174968138e-05 2.4000002027253361e-10
+ 5.9966688206218143e-05 2.40000020609859e-10
+ 5.9978895237468142e-05 2.4000001911322354e-10
+ 5.9991102268718141e-05 2.4000001969739074e-10
+ 6.0003309299968139e-05 2.4000002073053612e-10
+ 6.0015516331218138e-05 2.4000001994814067e-10
+ 6.0027723362468144e-05 2.4000001923239209e-10
+ 6.0039930393718142e-05 2.4000002015288261e-10
+ 6.0052137424968141e-05 2.4000001930210656e-10
+ 6.0064344456218139e-05 2.4000001837686493e-10
+ 6.0076551487468138e-05 2.4000001946449939e-10
+ 6.0088758518718144e-05 2.4000002038326192e-10
+ 6.0100965549968142e-05 2.400000203109469e-10
+ 6.0113172581218141e-05 2.400000203952259e-10
+ 6.012537961246814e-05 2.4000001970496741e-10
+ 6.0137586643718145e-05 2.4000001924454606e-10
+ 6.0149793674968144e-05 2.4000001905466872e-10
+ 6.0162000706218142e-05 2.400000204518705e-10
+ 6.0174207737468141e-05 2.4000002011557764e-10
+ 6.0186414768718146e-05 2.4000001946831419e-10
+ 6.0198621799968145e-05 2.4000001925940771e-10
+ 6.0210828831218144e-05 2.4000001980987061e-10
+ 6.0223035862468142e-05 2.4000002089319245e-10
+ 6.0235242893718148e-05 2.4000001973823067e-10
+ 6.0247449924968146e-05 2.4000001879346328e-10
+ 6.0259656956218145e-05 2.4000001869932423e-10
+ 6.0271863987468144e-05 2.4000002074828773e-10
+ 6.0284071018718149e-05 2.4000001934026167e-10
+ 6.0296278049968148e-05 2.4000001952115826e-10
+ 6.0308485081218146e-05 2.4000001987859593e-10
+ 6.0320692112468145e-05 2.400000198982881e-10
+ 6.0332899143718151e-05 2.40000018977687e-10
+ 6.0345106174968149e-05 2.4000001970468766e-10
+ 6.0357313206218148e-05 2.4000001969944985e-10
+ 6.0369520237468147e-05 2.4000002027367879e-10
+ 6.0381727268718152e-05 2.4000001840031488e-10
+ 6.0393934299968151e-05 2.4000001957318321e-10
+ 6.0406141331218149e-05 2.400000188108562e-10
+ 6.0418348362468148e-05 2.4000002046679305e-10
+ 6.0430555393718153e-05 2.4000001950571268e-10
+ 6.0442762424968152e-05 2.4000001838116472e-10
+ 6.0454969456218151e-05 2.4000001853089837e-10
+ 6.0467176487468149e-05 2.4000002004811227e-10
+ 6.0479383518718155e-05 2.4000001966057371e-10
+ 6.0491590549968153e-05 2.4000001941089245e-10
+ 6.0503797581218152e-05 2.4000001913185568e-10
+ 6.0516004612468151e-05 2.4000001954838558e-10
+ 6.0528211643718156e-05 2.4000001920964592e-10
+ 6.0540418674968155e-05 2.4000001943469307e-10
+ 6.0552625706218153e-05 2.4000001866641258e-10
+ 6.0564832737468152e-05 2.4000002020897109e-10
+ 6.0577039768718158e-05 2.4000001940179987e-10
+ 6.0589246799968156e-05 2.4000001993507329e-10
+ 6.0601453831218155e-05 2.4000002008198123e-10
+ 6.0613660862468154e-05 2.400000198005213e-10
+ 6.0625867893718159e-05 2.4000001916301211e-10
+ 6.0638074924968158e-05 2.4000001960280073e-10
+ 6.0650281956218156e-05 2.4000001963117276e-10
+ 6.0662488987468155e-05 2.400000196254434e-10
+ 6.067469601871816e-05 2.4000002030623543e-10
+ 6.0686903049968159e-05 2.4000001985486468e-10
+ 6.0699110081218158e-05 2.4000001975560508e-10
+ 6.0711317112468156e-05 2.4000002002563028e-10
+ 6.0723524143718162e-05 2.4000001880683233e-10
+ 6.073573117496816e-05 2.400000186107882e-10
+ 6.0747938206218159e-05 2.4000002026174485e-10
+ 6.0760145237468158e-05 2.4000001964579944e-10
+ 6.0772352268718163e-05 2.4000001869414737e-10
+ 6.0784559299968162e-05 2.4000002024855297e-10
+ 6.079676633121816e-05 2.4000001886895933e-10
+ 6.0808973362468159e-05 2.4000001996539064e-10
+ 6.0821180393718165e-05 2.4000001852201533e-10
+ 6.0833387424968163e-05 2.4000001995376353e-10
+ 6.0845594456218162e-05 2.4000001885033681e-10
+ 6.0857801487468161e-05 2.400000202275795e-10
+ 6.0870008518718166e-05 2.4000001938682899e-10
+ 6.0882215549968165e-05 2.400000185286626e-10
+ 6.0894422581218163e-05 2.4000002021567022e-10
+ 6.0906629612468162e-05 2.4000001929093104e-10
+ 6.0918836643718167e-05 2.4000001945502139e-10
+ 6.0931043674968166e-05 2.4000001849176264e-10
+ 6.0943250706218165e-05 2.4000001899160695e-10
+ 6.0955457737468163e-05 2.4000001908469775e-10
+ 6.0967664768718169e-05 2.4000002021320925e-10
+ 6.0979871799968167e-05 2.4000001986077044e-10
+ 6.0992078831218166e-05 2.4000001985660228e-10
+ 6.1004285862468165e-05 2.4000001982734366e-10
+ 6.101649289371817e-05 2.4000001909394165e-10
+ 6.1028699924968169e-05 2.4000001971428865e-10
+ 6.1040906956218174e-05 2.4000001921042243e-10
+ 6.1053113987468173e-05 2.400000190589926e-10
+ 6.1065321018718172e-05 2.400000192770844e-10
+ 6.107752804996817e-05 2.4000001876027354e-10
+ 6.1089735081218169e-05 2.4000001963225885e-10
+ 6.1101942112468168e-05 2.4000001898595255e-10
+ 6.1114149143718166e-05 2.4000001876650681e-10
+ 6.1126356174968165e-05 2.4000001955479303e-10
+ 6.1138563206218177e-05 2.400000192149284e-10
+ 6.1150770237468176e-05 2.4000001962818762e-10
+ 6.1162977268718174e-05 2.400000192259498e-10
+ 6.1175184299968173e-05 2.4000001958046752e-10
+ 6.1187391331218172e-05 2.4000001876653049e-10
+ 6.119959836246817e-05 2.4000001901679062e-10
+ 6.1211805393718169e-05 2.4000001929188411e-10
+ 6.1224012424968168e-05 2.4000001878460593e-10
+ 6.123621945621818e-05 2.4000001895149019e-10
+ 6.1248426487468178e-05 2.4000001953324466e-10
+ 6.1260633518718177e-05 2.4000001930179932e-10
+ 6.1272840549968176e-05 2.4000001867284628e-10
+ 6.1285047581218174e-05 2.4000001876404646e-10
+ 6.1297254612468173e-05 2.4000001844012502e-10
+ 6.1309461643718172e-05 2.4000001847700822e-10
+ 6.132166867496817e-05 2.4000001848915366e-10
+ 6.1333875706218183e-05 2.4000001847211049e-10
+ 6.1346082737468181e-05 2.4000001842583542e-10
+ 6.135828976871818e-05 2.4000001874485954e-10
+ 6.1370496799968179e-05 2.4000001864470591e-10
+ 6.1382703831218177e-05 2.400000192645186e-10
+ 6.1394910862468176e-05 2.4000001911011029e-10
+ 6.1407117893718175e-05 2.400000189594016e-10
+ 6.1419324924968173e-05 2.4000001834385696e-10
+ 6.1431531956218185e-05 2.4000001923683012e-10
+ 6.1443738987468184e-05 2.4000002008098464e-10
+ 6.1455946018718183e-05 2.400000183211859e-10
+ 6.1468153049968181e-05 2.4000001983070817e-10
+ 6.148036008121818e-05 2.4000001841550595e-10
+ 6.1492567112468179e-05 2.4000001987140726e-10
+ 6.1504774143718177e-05 2.4000001839799459e-10
+ 6.1516981174968176e-05 2.4000001979564812e-10
+ 6.1529188206218188e-05 2.4000001826400317e-10
+ 6.1541395237468187e-05 2.3996544537098469e-10
+ 6.1553602268718186e-05 2.3996256464191007e-10
+ 6.1565809299968184e-05 2.3996062147298765e-10
+ 6.1578016331218183e-05 2.399538992151035e-10
+ 6.1590223362468181e-05 2.3990864356794482e-10
+ 6.160243039371818e-05 2.3980391697569448e-10
+ 6.1614637424968179e-05 2.3960325885649169e-10
+ 6.1620740940593192e-05 2.3930636780140344e-10
+ 6.1626844456218191e-05 2.3825018349924986e-10
+ 6.1629896214030684e-05 2.3664385617022961e-10
+ 6.163294797184319e-05 2.313460144418538e-10
+ 6.1634473850749437e-05 2.2273712950258841e-10
+ 6.1635999729655683e-05 1.9502932447418286e-10
+ 6.163699110688919e-05 1.3263414891107653e-10
+ 6.1637269733896249e-05 9.5672269136980181e-11
+ 6.1637548360903309e-05 4.6113023016783446e-11
+ 6.1638098835627977e-05 4.077304569289076e-11
+ 6.1640875273912443e-05 4.2347131994264368e-11
+ 6.1653082305162442e-05 4.4733371018365243e-11
+ 6.1665289336412441e-05 5.3058719093237963e-11
+ 6.1677496367662439e-05 6.5249849962529414e-11
+ 6.1689703398912438e-05 8.0586557341896391e-11
+ 6.1701910430162437e-05 9.8186059694000248e-11
+ 6.1714117461412435e-05 1.1703587328666208e-10
+ 6.1726324492662448e-05 1.3605185310399104e-10
+ 6.1738531523912446e-05 1.5414054504639482e-10
+ 6.1750738555162445e-05 1.7026206156240515e-10
+ 6.1762945586412444e-05 1.8348986297121229e-10
+ 6.1775152617662442e-05 1.9306400774952091e-10
+ 6.1787359648912441e-05 1.9843481134517081e-10
+ 6.179956668016244e-05 1.9929440536940058e-10
+ 6.1811773711412452e-05 1.9559438520732841e-10
+ 6.182398074266245e-05 1.8754853451668201e-10
+ 6.1836187773912449e-05 1.7562047328816539e-10
+ 6.1848394805162448e-05 1.6049694315998822e-10
+ 6.1860601836412446e-05 1.4304826930135124e-10
+ 6.1872808867662445e-05 1.2427827523140709e-10
+ 6.1885015898912444e-05 1.052665328361379e-10
+ 6.1897222930162442e-05 8.7106269937226752e-11
+ 6.1909429961412441e-05 7.0841506734532094e-11
+ 6.1921636992662453e-05 5.7407035899497847e-11
+ 6.1933844023912452e-05 4.7574696846103914e-11
+ 6.1936895781724945e-05 4.5750674856066197e-11
+ 6.1937048369615577e-05 4.5666462612461995e-11
+ 6.1937429839342139e-05 4.5458870923120094e-11
+ 6.1937467986314794e-05 4.5438342991126504e-11
+ 6.1937475615709319e-05 4.5434242455099145e-11
+ 6.1937490874498384e-05 4.5426046434154427e-11
+ 6.1937496978014013e-05 4.5422769911655126e-11
+ 6.1937499419420261e-05 4.542145960441293e-11
+ 6.1937499604455788e-05 4.5421360302533612e-11
+ 6.1937499974526841e-05 4.5421161701746532e-11
+ 6.1937500714668946e-05 5.7234708751505077e-08
+ 6.1937501454811065e-05 2.3609835104101694e-07
+ 6.1937508856232148e-05 8.3378657603255145e-06
+ 6.1937516257653245e-05 2.6804211983519737e-05
+ 6.1937523659074328e-05 5.4212572160978158e-05
+ 6.1937531060495424e-05 8.9333429400249197e-05
+ 6.1937538461916507e-05 0.00013110387761772142
+ 6.1937547512355698e-05 0.00018988604042548046
+ 6.1937556562794875e-05 0.000255812068272275
+ 6.1937565613234052e-05 0.00032768193023753725
+ 6.1937574663673228e-05 0.00040448949601993325
+ 6.1937583714112419e-05 0.00048539058840956265
+ 6.1937595044533517e-05 0.00059137048504824714
+ 6.1937606374954616e-05 0.00070151686849491022
+ 6.1937617705375714e-05 0.0008149054011463608
+ 6.1937629035796812e-05 0.00093078918228233572
+ 6.1937643214653361e-05 0.0010784080416500865
+ 6.1937657393509922e-05 0.0012280520970111633
+ 6.1937671572366484e-05 0.0013789889014004875
+ 6.1937689032396935e-05 0.0015657925325384681
+ 6.1937706492427399e-05 0.0017528666320927736
+ 6.1937723952457864e-05 0.0019395804048633696
+ 6.1937746268477841e-05 0.0021769293571718938
+ 6.1937768584497803e-05 0.0024120996791847497
+ 6.193779090051778e-05 0.0026444704336099976
+ 6.1937819090217243e-05 0.0029332237971511233
+ 6.1937847279916719e-05 0.0032158629328255771
+ 6.1937875469616181e-05 0.0034916668520790159
+ 6.1937903659315657e-05 0.0037599988278231356
+ 6.193793184901512e-05 0.0040202830355208904
+ 6.1937960038714596e-05 0.0042719918874605982
+ 6.1937988228414072e-05 0.0045146394015623476
+ 6.1938019414106474e-05 0.0047719795450323309
+ 6.1938050599798889e-05 0.0050171295125712645
+ 6.1938081785491305e-05 0.0052495906087394869
+ 6.1938112971183707e-05 0.0054689190353913904
+ 6.1938150418414339e-05 0.0057143885297757718
+ 6.1938187865644972e-05 0.0059397992525804574
+ 6.1938225312875605e-05 0.006144702220679193
+ 6.1938270844195815e-05 0.0063657430322260553
+ 6.1938316375516025e-05 0.0065556175023236875
+ 6.1938361906836234e-05 0.0067142112673811444
+ 6.1938407438156444e-05 0.0068416534980290083
+ 6.1938441084028123e-05 0.0069160175765833089
+ 6.1938474729899775e-05 0.0069737900261410465
+ 6.1938508375771454e-05 0.0070152594941248576
+ 6.1938542021643106e-05 0.0070407746969006688
+ 6.1938575667514785e-05 0.007050740823760393
+ 6.1938609313386437e-05 0.0070456156939712805
+ 6.1938642959258116e-05 0.007025905702338452
+ 6.1938676605129768e-05 0.0069921615895264296
+ 6.1938710251001447e-05 0.0069449740739896257
+ 6.193873687066815e-05 0.006898526876910809
+ 6.1938763490334867e-05 0.0068443802044164921
+ 6.193879011000157e-05 0.0067828688534493494
+ 6.1938816729668287e-05 0.0067143369242957376
+ 6.193884334933499e-05 0.0066391364097472113
+ 6.1938869969001707e-05 0.0065576257964309343
+ 6.193889658866841e-05 0.0064701686843428533
+ 6.1938923208335126e-05 0.0063771324303375145
+ 6.1938949828001843e-05 0.0062788868210215225
+ 6.1938976447668546e-05 0.0061758027801676225
+ 6.1939003067335263e-05 0.0060682511154162089
+ 6.1939029687001966e-05 0.0059566013086644297
+ 6.1939056306668683e-05 0.0058412203541628417
+ 6.1939082926335386e-05 0.0057224716479485063
+ 6.1939109546002102e-05 0.0056007139318451742
+ 6.1939136165668806e-05 0.0054763002948580381
+ 6.1939162785335522e-05 0.0053495772343856614
+ 6.1939189405002239e-05 0.0052208837792675896
+ 6.1939216024668942e-05 0.0050905506764474901
+ 6.1939239404935239e-05 0.0049749804171373225
+ 6.1939262785201522e-05 0.0048586054363550972
+ 6.1939286165467805e-05 0.0047416314482211135
+ 6.1939309545734102e-05 0.0046242577652878883
+ 6.1939332926000385e-05 0.0045066770343838705
+ 6.1939356306266668e-05 0.0043890750025309139
+ 6.1939379686532965e-05 0.0042716303126259531
+ 6.1939403066799248e-05 0.0041545143284691553
+ 6.1939426447065544e-05 0.0040378909886185305
+ 6.1939449827331828e-05 0.0039219166884552218
+ 6.1939473207598111e-05 0.0038067401897542695
+ 6.1939496587864407e-05 0.0036925025569730643
+ 6.193951996813069e-05 0.0035793371193940525
+ 6.1939543348396974e-05 0.0034673694581895016
+ 6.193956672866327e-05 0.0033567174174145066
+ 6.1939590108929553e-05 0.0032474911378798247
+ 6.193961348919585e-05 0.0031397931128086067
+ 6.1939636869462133e-05 0.0030337182641405314
+ 6.1939660249728416e-05 0.0029293540383132049
+ 6.1939683629994713e-05 0.0028267805203238136
+ 6.1939707010260996e-05 0.0027260705648536779
+ 6.1939735591237517e-05 0.0026055855381113117
+ 6.1939764172214051e-05 0.0024880893416989024
+ 6.1939792753190571e-05 0.0023736731389782805
+ 6.1939821334167092e-05 0.0022624136400195647
+ 6.1939849915143612e-05 0.0021543736566158275
+ 6.193988619980621e-05 0.0020219271947776738
+ 6.193992545337339e-05 0.0018846580284455387
+ 6.1939946977215263e-05 0.0018120618774395494
+ 6.1939973696714705e-05 0.0017245821083065652
+ 6.1940000416214135e-05 0.0016400258203643724
+ 6.1940027135713578e-05 0.0015583844444338579
+ 6.1940053855213007e-05 0.0014796423351417674
+ 6.194008057471245e-05 0.0014037772468436488
+ 6.1940107294211879e-05 0.0013307608065583204
+ 6.1940134013711322e-05 0.0012605589819463642
+ 6.1940160733210751e-05 0.0011931325425094006
+ 6.1940187452710194e-05 0.0011284375123336611
+ 6.1940214172209623e-05 0.0010664256128491564
+ 6.1940240891709066e-05 0.0010070446942234952
+ 6.1940262548859613e-05 0.00096080661895637035
+ 6.1940284206010173e-05 0.0009162294538821239
+ 6.194030586316072e-05 0.00087328092606094238
+ 6.1940327520311266e-05 0.00083192771752318962
+ 6.1940349177461827e-05 0.00079213559354230647
+ 6.1940370834612373e-05 0.00075386952625768001
+ 6.1940392491762933e-05 0.00071709381353394315
+ 6.194041414891348e-05 0.00068177219296354193
+ 6.1940435806064027e-05 0.00064786795094112185
+ 6.1940457463214587e-05 0.00061534402675914772
+ 6.1940479120365134e-05 0.00058416311167918647
+ 6.1940496765399601e-05 0.00055972551886932095
+ 6.1940514410434083e-05 0.00053613426244406741
+ 6.1940532055468551e-05 0.00051336904748169171
+ 6.1940549700503032e-05 0.00049140960981622914
+ 6.19405673455375e-05 0.00047023574348777509
+ 6.1940584990571981e-05 0.00044982732676715286
+ 6.1940602635606449e-05 0.00043016434677204047
+ 6.1940620280640917e-05 0.00041122692269401575
+ 6.1940637925675398e-05 0.00039299532765819798
+ 6.1940655570709866e-05 0.00037545000923921415
+ 6.1940673215744348e-05 0.00035857160865911174
+ 6.1940690860778815e-05 0.00034234097869457157
+ 6.1940708505813297e-05 0.00032673920032235228
+ 6.1940726150847765e-05 0.00031174759813332067
+ 6.1940743795882246e-05 0.00029734775454669758
+ 6.1940761440916714e-05 0.00028352152285727745
+ 6.1940779085951182e-05 0.0002702510391493668
+ 6.1940796730985663e-05 0.00025751873311203796
+ 6.1940814376020131e-05 0.00024530733779101174
+ 6.1940832021054612e-05 0.00023359989831307307
+ 6.194084966608908e-05 0.00022237977961939102
+ 6.1940867311123562e-05 0.00021163067324446447
+ 6.1940884956158029e-05 0.00020133660317765155
+ 6.1940902601192511e-05 0.00019148193084437179
+ 6.1940920246226979e-05 0.00018205135924409671
+ 6.1940937891261447e-05 0.00017302993628217709
+ 6.1940955536295928e-05 0.00016440305733239472
+ 6.1940973181330396e-05 0.00015615646706688136
+ 6.1940990826364877e-05 0.00014827626058972067
+ 6.1941008471399345e-05 0.00014074888391014853
+ 6.1941026116433826e-05 0.00013356113379079491
+ 6.1941043761468294e-05 0.00012670015700587552
+ 6.1941061406502762e-05 0.00012015344904364461
+ 6.1941079051537243e-05 0.00011390885228677083
+ 6.1941096696571711e-05 0.00010795455370359766
+ 6.1941114341606193e-05 0.00010227908208250491
+ 6.1941131986640661e-05 9.687130484080241e-05
+ 6.1941149631675142e-05 9.1720424438765868e-05
+ 6.194116727670961e-05 8.6815974428572379e-05
+ 6.1941184921744078e-05 8.2147815167013072e-05
+ 6.1941202566778559e-05 7.7706129219957601e-05
+ 6.1941220211813027e-05 7.3481416485622882e-05
+ 6.1941237856847508e-05 6.9464489062760908e-05
+ 6.1941255501881976e-05 6.5646465888930612e-05
+ 6.1941273146916457e-05 6.2018767173060703e-05
+ 6.1941290791950925e-05 5.8573108645546759e-05
+ 6.1941308436985407e-05 5.5301495648160228e-05
+ 6.1941326082019875e-05 5.2196217085081444e-05
+ 6.1941343727054342e-05 4.9249839255407143e-05
+ 6.1941361372088824e-05 4.6455199586526805e-05
+ 6.1941379017123292e-05 4.3805400286814076e-05
+ 6.1941396662157773e-05 4.1293801935142287e-05
+ 6.1941414307192241e-05 3.8914017023807698e-05
+ 6.1941431952226722e-05 3.6659903470533496e-05
+ 6.194144959726119e-05 3.4525558114332587e-05
+ 6.1941467242295671e-05 3.2505310209129923e-05
+ 6.1941484887330139e-05 3.0593714928186798e-05
+ 6.1941502532364607e-05 2.878554689153125e-05
+ 6.1941520177399088e-05 2.7075793727781893e-05
+ 6.1941537822433556e-05 2.5459649680957857e-05
+ 6.1941555467468038e-05 2.3932509272096093e-05
+ 6.1941573112502506e-05 2.2489961024749567e-05
+ 6.1941590757536987e-05 2.1127781262716843e-05
+ 6.1941608402571455e-05 1.9841927987655173e-05
+ 6.1941626047605923e-05 1.8628534843556469e-05
+ 6.1941643692640404e-05 1.7483905174418017e-05
+ 6.1941661337674872e-05 1.6404506180818473e-05
+ 6.1941682620107584e-05 1.5184596516820046e-05
+ 6.194170274528168e-05 1.4108722156777394e-05
+ 6.1941722870455791e-05 1.3103783271809466e-05
+ 6.1941742995629887e-05 1.2165512099818384e-05
+ 6.1941763120803997e-05 1.1289867233639744e-05
+ 6.1941783245978094e-05 1.0473023791237365e-05
+ 6.1941803371152191e-05 9.711363860421274e-06
+ 6.1941823496326301e-05 9.0014672215583367e-06
+ 6.1941843621500398e-05 8.3401023506671107e-06
+ 6.1941863746674508e-05 7.7242177042852387e-06
+ 6.1941888110746127e-05 7.0353574872189284e-06
+ 6.1941912474817759e-05 6.4041509733236313e-06
+ 6.1941936838889392e-05 5.8261375978047346e-06
+ 6.1941961202961011e-05 5.2971679183216326e-06
+ 6.1941985567032644e-05 4.8133849648221628e-06
+ 6.1942009931104263e-05 4.3712064413582404e-06
+ 6.1942034295175895e-05 3.9673077642003495e-06
+ 6.1942058659247528e-05 3.5986059186122073e-06
+ 6.1942083023319147e-05 3.2622441148827113e-06
+ 6.194210738739078e-05 2.955577222710442e-06
+ 6.1942136719683573e-05 2.6223173518557521e-06
+ 6.1942166051976366e-05 2.3246430183300364e-06
+ 6.1942195384269159e-05 2.0589938235170389e-06
+ 6.1942224716561952e-05 1.8221375097881734e-06
+ 6.1942254048854759e-05 1.6111428978970881e-06
+ 6.1942283381147552e-05 1.4233547079677823e-06
+ 6.1942312713440345e-05 1.2563701699769522e-06
+ 6.1942342045733138e-05 1.1080173307665688e-06
+ 6.1942377848029202e-05 9.4935328593955194e-07
+ 6.1942412335454637e-05 8.1703614317247063e-07
+ 6.1942446822880071e-05 7.0231034037170861e-07
+ 6.1942481310305506e-05 6.0295931014601184e-07
+ 6.194251579773094e-05 5.1702814794412422e-07
+ 6.1942557828321211e-05 4.2796498791424164e-07
+ 6.1942599858911496e-05 3.5358466304975593e-07
+ 6.1942641889501767e-05 2.9157919961691281e-07
+ 6.1942683920092052e-05 2.3998333476715486e-07
+ 6.1942725950682323e-05 1.9712710629082681e-07
+ 6.1942777518503422e-05 1.5442331314774624e-07
+ 6.1942828186666488e-05 1.2110746118199679e-07
+ 6.1942878854829539e-05 9.4668212428266369e-08
+ 6.1942929522992604e-05 7.3741045625230226e-08
+ 6.1942993215143469e-05 5.3572482382509411e-08
+ 6.1943056907294333e-05 3.8650410566722333e-08
+ 6.1943120599445198e-05 2.7655607125139506e-08
+ 6.1943198945610718e-05 1.80624388894615e-08
+ 6.1943278657649703e-05 1.1455385675920075e-08
+ 6.1943358369688674e-05 7.0279116712338033e-09
+ 6.194346129237077e-05 3.42722610432318e-09
+ 6.1943569508909825e-05 1.2415251844169095e-09
+ 6.1943701914804437e-05 -1.7423168879043324e-10
+ 6.1943847065030192e-05 -9.0046498724308251e-10
+ 6.1944034315235686e-05 -1.2675598336250834e-09
+ 6.1944255865010428e-05 -1.390661486095478e-09
+ 6.1944554034092504e-05 -1.4079464626524889e-09
+ 6.1944998769870887e-05 -1.3781166774969621e-09
+ 6.1945805003988996e-05 -1.313948994893242e-09
+ 6.1946711764368316e-05 -1.2450592154006523e-09
+ 6.1947737475686443e-05 -1.1711746826522686e-09
+ 6.1948801143402348e-05 -1.0985374417948889e-09
+ 6.1949944764949554e-05 -1.0244977902794022e-09
+ 6.195223164627892e-05 -8.876839903243166e-10
+ 6.1954182681216667e-05 -7.8153991862173163e-10
+ 6.1956291228517255e-05 -6.7660226349856925e-10
+ 6.1958581467436163e-05 -5.7299433820914436e-10
+ 6.1960926666850035e-05 -4.7698621811411996e-10
+ 6.1963271866263893e-05 -3.901690868650475e-10
+ 6.1965590537179629e-05 -3.1248869476676087e-10
+ 6.1968474569484283e-05 -2.2600941125466692e-10
+ 6.1971358601788936e-05 -1.4953972152878652e-10
+ 6.1974242634093576e-05 -8.1909642546355165e-11
+ 6.1977126666398229e-05 -2.2097231394821104e-11
+ 6.1980010698702882e-05 3.0804763949844941e-11
+ 6.1982894731007536e-05 7.7599184420572088e-11
+ 6.1985778763312175e-05 1.1899177680085989e-10
+ 6.1989342797663592e-05 1.6360497315690482e-10
+ 6.1992906832015023e-05 2.0194460469335925e-10
+ 6.199647086636644e-05 2.3489304324568193e-10
+ 6.2000034900717857e-05 2.6320792465228799e-10
+ 6.2003598935069274e-05 2.8754418863776942e-10
+ 6.2007899961127367e-05 3.124003450031708e-10
+ 6.2012200987185461e-05 3.3310188136055884e-10
+ 6.201650201324354e-05 3.5034335018174361e-10
+ 6.2020803039301633e-05 3.6470346013268147e-10
+ 6.2025104065359726e-05 3.7666442373221598e-10
+ 6.203050250598699e-05 3.8888313831481749e-10
+ 6.2035900946614254e-05 3.9859542479219459e-10
+ 6.2041299387241518e-05 4.0629545583254085e-10
+ 6.2046697827868781e-05 4.1242659596079512e-10
+ 6.2053468247657469e-05 4.1836450212166619e-10
+ 6.2060238667446157e-05 4.228142873871682e-10
+ 6.2067009087234844e-05 4.2614500842071573e-10
+ 6.2075385304343964e-05 4.2912633403108892e-10
+ 6.2083761521453069e-05 4.3120345772378355e-10
+ 6.2092137738562188e-05 4.3264838822889765e-10
+ 6.2103043385488654e-05 4.3388610175178318e-10
+ 6.2113949032415133e-05 4.3464666000495187e-10
+ 6.2126156063665132e-05 4.3514763453961883e-10
+ 6.2138363094915131e-05 4.3542384097085643e-10
+ 6.2150570126165129e-05 4.3556624282357159e-10
+ 6.2162777157415142e-05 4.3562884855868211e-10
+ 6.217498418866514e-05 4.3564390919099658e-10
+ 6.2187191219915139e-05 4.3563071731303817e-10
+ 6.2199398251165138e-05 4.3560072832369711e-10
+ 6.2211605282415136e-05 4.3556071800624522e-10
+ 6.2223812313665135e-05 4.3551473285478916e-10
+ 6.2236019344915134e-05 4.3546520640556509e-10
+ 6.2248226376165146e-05 4.3541358487496968e-10
+ 6.2260433407415144e-05 4.3536071753580087e-10
+ 6.2272640438665143e-05 4.353071102954193e-10
+ 6.2284847469915142e-05 4.3525307030070124e-10
+ 6.229705450116514e-05 4.3519878102624261e-10
+ 6.2309261532415139e-05 4.3514434891989702e-10
+ 6.2321468563665138e-05 4.3508983678706616e-10
+ 6.2333675594915136e-05 4.3503528333983576e-10
+ 6.2345882626165135e-05 4.3498071205926307e-10
+ 6.2358089657415147e-05 4.3492613633167183e-10
+ 6.2370296688665146e-05 4.348715638520445e-10
+ 6.2382503719915144e-05 4.3481699946235471e-10
+ 6.2394710751165143e-05 4.3476244620745766e-10
+ 6.2406917782415142e-05 4.3470790578886986e-10
+ 6.241912481366514e-05 4.3465337912630206e-10
+ 6.2431331844915139e-05 4.3459886680952396e-10
+ 6.2443538876165151e-05 4.3454436923774573e-10
+ 6.245574590741515e-05 4.3448988663097442e-10
+ 6.2467952938665149e-05 4.3443541909242035e-10
+ 6.2480159969915147e-05 4.3438096668679938e-10
+ 6.2492367001165146e-05 4.3432652946422885e-10
+ 6.2500000000000001e-05 4.3429323819786375e-10
+ 6.251220703125e-05 4.3423882549145797e-10
+ 6.2524414062499999e-05 4.3418442800650571e-10
+ 6.2536621093749997e-05 4.3413004574565444e-10
+ 6.2548828124999996e-05 4.3407567870875607e-10
+ 6.2561035156249995e-05 4.3402132689399754e-10
+ 6.2573242187500007e-05 4.3396699029857563e-10
+ 6.2585449218750005e-05 4.3391266891909689e-10
+ 6.2597656250000004e-05 4.338583627518177e-10
+ 6.2609863281250003e-05 4.338040717927861e-10
+ 6.2622070312500001e-05 4.3374979603792648e-10
+ 6.263427734375e-05 4.3369553548309005e-10
+ 6.2646484374999999e-05 4.3364129012408513e-10
+ 6.2658691406249997e-05 4.3358705995669485e-10
+ 6.2670898437499996e-05 4.3353284497668784e-10
+ 6.2683105468749995e-05 4.3347864517982436e-10
+ 6.2695312500000007e-05 4.3342446056186068e-10
+ 6.2707519531250006e-05 4.3337029111855061e-10
+ 6.2719726562500004e-05 4.3331613684564742e-10
+ 6.2731933593750003e-05 4.3326199773890431e-10
+ 6.2744140625000002e-05 4.3320787379407488e-10
+ 6.275634765625e-05 4.3315376500691365e-10
+ 6.2768554687499999e-05 4.3309967137317592e-10
+ 6.2780761718749997e-05 4.3304559288861817e-10
+ 6.2792968749999996e-05 4.3299152954899793e-10
+ 6.2805175781249995e-05 4.3293748135007384e-10
+ 6.2817382812500007e-05 4.3288344828760572e-10
+ 6.2829589843750006e-05 4.3282943035735457e-10
+ 6.2841796875000004e-05 4.3277542755508266e-10
+ 6.2854003906250003e-05 4.327214398765532e-10
+ 6.2866210937500002e-05 4.3266746731753079e-10
+ 6.287841796875e-05 4.3261350987378112e-10
+ 6.2890624999999999e-05 4.3255956754107106e-10
+ 6.2902832031249998e-05 4.3250564031516869e-10
+ 6.2915039062499996e-05 4.324517281918434e-10
+ 6.2927246093749995e-05 4.3239783116686546e-10
+ 6.2939453125000007e-05 4.3234394923600652e-10
+ 6.2951660156250006e-05 4.3229008239503964e-10
+ 6.2963867187500004e-05 4.322362306397386e-10
+ 6.2976074218750003e-05 4.3218239396587857e-10
+ 6.2988281250000002e-05 4.3212857236923607e-10
+ 6.300048828125e-05 4.3207476584558855e-10
+ 6.3012695312499999e-05 4.3202097439071481e-10
+ 6.3024902343749998e-05 4.3196719800039462e-10
+ 6.3037109374999996e-05 4.3191343667040926e-10
+ 6.3049316406249995e-05 4.3185969039654094e-10
+ 6.3061523437500007e-05 4.3180595917457319e-10
+ 6.3073730468750006e-05 4.3175224300029046e-10
+ 6.3085937500000005e-05 4.3169854186947872e-10
+ 6.3098144531250003e-05 4.3164485577792515e-10
+ 6.3110351562500002e-05 4.3159118472141752e-10
+ 6.312255859375e-05 4.315375286957455e-10
+ 6.3134765624999999e-05 4.3148388769669956e-10
+ 6.3146972656249998e-05 4.3143026172007142e-10
+ 6.3159179687499996e-05 4.3137665076165393e-10
+ 6.3171386718749995e-05 4.3132305481724119e-10
+ 6.3183593750000007e-05 4.3126947388262849e-10
+ 6.3195800781250006e-05 4.3121590795361226e-10
+ 6.3208007812500005e-05 4.3116235702599014e-10
+ 6.3220214843750003e-05 4.311088210955608e-10
+ 6.3232421875000002e-05 4.3105530015812432e-10
+ 6.3244628906250001e-05 4.3100179420948178e-10
+ 6.3256835937499999e-05 4.3094830324543561e-10
+ 6.3269042968749998e-05 4.3089482726178914e-10
+ 6.3281249999999997e-05 4.3084136625434698e-10
+ 6.3293457031249995e-05 4.3078792021891527e-10
+ 6.3305664062500007e-05 4.3073448915130076e-10
+ 6.3317871093750006e-05 4.3068107304731183e-10
+ 6.3330078125000005e-05 4.3062767190275767e-10
+ 6.3342285156250003e-05 4.3057428571344897e-10
+ 6.3354492187500002e-05 4.305209144751974e-10
+ 6.3366699218750001e-05 4.3046755818381573e-10
+ 6.3378906249999999e-05 4.3041421683511815e-10
+ 6.3391113281249998e-05 4.3036089042491982e-10
+ 6.3403320312499997e-05 4.3030757894903721e-10
+ 6.3415527343750009e-05 4.3025428240328784e-10
+ 6.3427734375000008e-05 4.3020100078349046e-10
+ 6.3439941406250006e-05 4.3014773408546503e-10
+ 6.3452148437500005e-05 4.3009448230503257e-10
+ 6.3464355468750004e-05 4.3004124543801536e-10
+ 6.3476562500000002e-05 4.2998802348023685e-10
+ 6.3488769531250001e-05 4.2993481642752165e-10
+ 6.3500976562499999e-05 4.298816242756955e-10
+ 6.3513183593749998e-05 4.2982844702058526e-10
+ 6.3525390624999997e-05 4.2977528465801911e-10
+ 6.3537597656249995e-05 4.2972213718382639e-10
+ 6.3549804687500008e-05 4.296690045938374e-10
+ 6.3562011718750006e-05 4.2961588688388387e-10
+ 6.3574218750000005e-05 4.2956278404979846e-10
+ 6.3586425781250004e-05 4.2950969608741529e-10
+ 6.3598632812500002e-05 4.2945662299256918e-10
+ 6.3610839843750001e-05 4.2940356476109669e-10
+ 6.3623046875e-05 4.2935052138883517e-10
+ 6.3635253906249998e-05 4.2929749287162315e-10
+ 6.3647460937499997e-05 4.2924447920530045e-10
+ 6.3659667968749996e-05 4.2919148038570803e-10
+ 6.3671875000000008e-05 4.2913849640868801e-10
+ 6.3684082031250006e-05 4.2908552727008359e-10
+ 6.3696289062500005e-05 4.2903257296573924e-10
+ 6.3708496093750004e-05 4.2897963349150058e-10
+ 6.3720703125000002e-05 4.2892670884321429e-10
+ 6.3732910156250001e-05 4.288737990167283e-10
+ 6.37451171875e-05 4.2882090400789185e-10
+ 6.3757324218749998e-05 4.2876802381255504e-10
+ 6.3769531249999997e-05 4.2871515842656934e-10
+ 6.3781738281249996e-05 4.2866230784578723e-10
+ 6.3793945312499994e-05 4.2860947206606246e-10
+ 6.3806152343750007e-05 4.2855665108325002e-10
+ 6.3818359375000005e-05 4.2850384489320595e-10
+ 6.3830566406250004e-05 4.2845105349178732e-10
+ 6.3842773437500002e-05 4.2839827687485269e-10
+ 6.3854980468750001e-05 4.2834551503826145e-10
+ 6.38671875e-05 4.2829276797787439e-10
+ 6.3879394531249998e-05 4.2824003568955333e-10
+ 6.3891601562499997e-05 4.2818731816916134e-10
+ 6.3903808593749996e-05 4.2813461541256231e-10
+ 6.3916015624999994e-05 4.2808192741562203e-10
+ 6.3928222656249993e-05 4.2802925417420679e-10
+ 6.3940429687500005e-05 4.2797659568418397e-10
+ 6.3952636718750004e-05 4.2792395194142275e-10
+ 6.3964843750000003e-05 4.2787132294179297e-10
+ 6.3977050781250001e-05 4.2781870868116553e-10
+ 6.39892578125e-05 4.2776610915541303e-10
+ 6.4001464843749999e-05 4.2771352436040875e-10
+ 6.4013671874999997e-05 4.2766095429202714e-10
+ 6.4025878906249996e-05 4.2760839894614423e-10
+ 6.4038085937499995e-05 4.2755585831863669e-10
+ 6.4050292968749993e-05 4.2750333240538267e-10
+ 6.4062499999999992e-05 4.2745082120226136e-10
+ 6.4074707031250004e-05 4.2739832470515305e-10
+ 6.4086914062500003e-05 4.273458429099393e-10
+ 6.4099121093750001e-05 4.2729337581250278e-10
+ 6.4111328125e-05 4.2724092340872732e-10
+ 6.4123535156249999e-05 4.2718848569449787e-10
+ 6.4135742187499997e-05 4.2713606266570053e-10
+ 6.4147949218749996e-05 4.2708365431822263e-10
+ 6.4160156249999995e-05 4.270312606479525e-10
+ 6.4172363281249993e-05 4.2697888165077988e-10
+ 6.4184570312499992e-05 4.2692651732259529e-10
+ 6.4196777343750004e-05 4.2687416765929084e-10
+ 6.4208984375000003e-05 4.2682183265675928e-10
+ 6.4221191406250001e-05 4.2676951231089505e-10
+ 6.42333984375e-05 4.2671720661759342e-10
+ 6.4245605468749999e-05 4.2666491557275079e-10
+ 6.4257812499999997e-05 4.2661263917226478e-10
+ 6.4270019531249996e-05 4.265603774120343e-10
+ 6.4282226562499995e-05 4.265081302879591e-10
+ 6.4294433593749993e-05 4.2645589779594043e-10
+ 6.4306640624999992e-05 4.2640367993188038e-10
+ 6.4318847656249991e-05 4.2635147669168246e-10
+ 6.4331054687500003e-05 4.2629928807125108e-10
+ 6.4343261718750002e-05 4.2624711406649186e-10
+ 6.435546875e-05 4.2619495467331169e-10
+ 6.4367675781249999e-05 4.2614280988761856e-10
+ 6.4379882812499998e-05 4.2609067970532156e-10
+ 6.4392089843749996e-05 4.2603856412233079e-10
+ 6.4404296874999995e-05 4.2598646313455786e-10
+ 6.4416503906249994e-05 4.2593437673791515e-10
+ 6.4428710937499992e-05 4.2588230492831644e-10
+ 6.4440917968749991e-05 4.2583024770167654e-10
+ 6.4453125000000003e-05 4.2577820505391141e-10
+ 6.4465332031250002e-05 4.2572617698093814e-10
+ 6.44775390625e-05 4.2567416347867499e-10
+ 6.4489746093749999e-05 4.2562216454304139e-10
+ 6.4501953124999998e-05 4.2557018016995789e-10
+ 6.4514160156249996e-05 4.2551821035534623e-10
+ 6.4526367187499995e-05 4.2546625509512913e-10
+ 6.4538574218749994e-05 4.254143143852306e-10
+ 6.4550781249999992e-05 4.2536238822157581e-10
+ 6.4562988281249991e-05 4.2531047660009089e-10
+ 6.457519531249999e-05 4.2525857951670346e-10
+ 6.4587402343750002e-05 4.252066969673418e-10
+ 6.4599609375e-05 4.2515482894793579e-10
+ 6.4611816406249999e-05 4.2510297545441604e-10
+ 6.4624023437499998e-05 4.2505113648271467e-10
+ 6.4636230468749996e-05 4.2499931202876474e-10
+ 6.4648437499999995e-05 4.2494750208850055e-10
+ 6.4660644531249994e-05 4.248957066578573e-10
+ 6.4672851562499992e-05 4.2482519493572964e-10
+ 6.4685058593749991e-05 4.2475256100502045e-10
+ 6.469726562499999e-05 4.2468173951608737e-10
+ 6.4709472656249988e-05 4.2459666096075283e-10
+ 6.4721679687500001e-05 4.2448010616874532e-10
+ 6.4733886718749999e-05 4.242745676347303e-10
+ 6.4739990234374999e-05 4.2406762246865748e-10
+ 6.4746093749999998e-05 4.2364446431160585e-10
+ 6.4749145507812491e-05 4.2320637096990359e-10
+ 6.4752197265624997e-05 4.2237081875579266e-10
+ 6.475524902343749e-05 4.2039912634768696e-10
+ 6.4756606790774082e-05 4.184858057925494e-10
+ 6.4756998216660862e-05 4.1769354662518729e-10
+ 6.4757389642547641e-05 4.1673967866159501e-10
+ 6.475836820726457e-05 4.1328644574257995e-10
+ 6.4759409502908181e-05 4.0647792025774505e-10
+ 6.4759970598735316e-05 4.0009399586852752e-10
+ 6.4760339629298369e-05 3.9400830485401903e-10
+ 6.4761110323815837e-05 3.7217296598144555e-10
+ 6.4761741481233847e-05 3.3482378565862255e-10
+ 6.4762113084009009e-05 2.9476725253157392e-10
+ 6.4762434193795787e-05 2.3913652951300332e-10
+ 6.4762647097925416e-05 2.1273235713088472e-10
+ 6.4762860002055031e-05 2.1207408791108858e-10
+ 6.4764989043351238e-05 2.1185023895337551e-10
+ 6.4777196074601251e-05 2.0757980032582087e-10
+ 6.4789403105851249e-05 1.9827504053149293e-10
+ 6.4801610137101248e-05 1.8447156434439206e-10
+ 6.4813817168351247e-05 1.6696410651490149e-10
+ 6.4826024199601245e-05 1.4676018343964647e-10
+ 6.4838231230851244e-05 1.2502212943217047e-10
+ 6.4850438262101243e-05 1.0300022779102304e-10
+ 6.4862645293351241e-05 8.1960799754197404e-11
+ 6.487485232460124e-05 6.311338755160194e-11
+ 6.4887059355851239e-05 4.7541218733423125e-11
+ 6.4899266387101251e-05 3.6138949326912032e-11
+ 6.4911473418351249e-05 2.9561263935700322e-11
+ 6.4923680449601248e-05 2.8185285811614418e-11
+ 6.4935887480851247e-05 3.2088955187765566e-11
+ 6.4948094512101245e-05 4.1046615499322252e-11
+ 6.4960301543351244e-05 5.4542057385810135e-11
+ 6.4972508574601243e-05 7.1798266491615728e-11
+ 6.4984715605851241e-05 9.1822160785597292e-11
+ 6.499692263710124e-05 1.1346174161334856e-10
+ 6.5009129668351239e-05 1.3547236949090519e-10
+ 6.5021336699601237e-05 1.5658835172212636e-10
+ 6.5033543730851249e-05 1.7559572435646284e-10
+ 6.5045750762101248e-05 1.9140204326212496e-10
+ 6.5057957793351247e-05 2.030991720132836e-10
+ 6.506100955116374e-05 2.0529687447679853e-10
+ 6.5061314726944992e-05 2.0549982177660819e-10
+ 6.5062077666398115e-05 2.0599366009052315e-10
+ 6.5062459136124677e-05 2.062333046850057e-10
+ 6.5062482977982594e-05 2.0624812098499301e-10
+ 6.5062487746354178e-05 2.0625108196291897e-10
+ 6.5062497283097331e-05 2.0625700163649109e-10
+ 6.5062498046036793e-05 2.0625747507891284e-10
+ 6.506249957191569e-05 2.0625842190532621e-10
+ 6.5062499693986013e-05 2.0625849764807365e-10
+ 6.5062499938126631e-05 2.0625864913207268e-10
+ 6.5062499957657883e-05 2.0625866125070641e-10
+ 6.5062499996720386e-05 2.0625868548793557e-10
+ 6.5062500074845379e-05 8.3574849775232329e-10
+ 6.5062500152970385e-05 2.8382408459534785e-09
+ 6.5062500934220382e-05 9.7910663945931592e-08
+ 6.5062508051845976e-05 6.9281309170090845e-06
+ 6.5062515169471571e-05 2.3496919613390592e-05
+ 6.5062522287097165e-05 4.8515586154137975e-05
+ 6.5062529404722759e-05 8.0864107426474553e-05
+ 6.5062536522348367e-05 0.0001195688537478285
+ 6.5062543639973961e-05 0.00016378325676260678
+ 6.5062550757599556e-05 0.00021277103077073492
+ 6.506255787522515e-05 0.00026589161027525284
+ 6.5062564992850744e-05 0.00032258751106878353
+ 6.5062572110476338e-05 0.00038237336083026571
+ 6.5062579228101933e-05 0.00044482637875059637
+ 6.5062587807568578e-05 0.00052313156179263198
+ 6.5062596387035197e-05 0.00060422377214069478
+ 6.5062604966501842e-05 0.00068763160407692863
+ 6.5062613545968461e-05 0.00077295453496090106
+ 6.5062622125435106e-05 0.00085985181282763258
+ 6.5062630704901725e-05 0.00094803308914625053
+ 6.506263928436837e-05 0.0010372505228311898
+ 6.5062647863834989e-05 0.0011272921245865509
+ 6.5062658180770256e-05 0.0012364048498757886
+ 6.506266849770551e-05 0.0013461799437633384
+ 6.5062678814640764e-05 0.0014563930288477433
+ 6.5062689131576017e-05 0.001566855276772596
+ 6.5062699448511271e-05 0.0016774068636345029
+ 6.5062709765446525e-05 0.001787911643031166
+ 6.5062720082381778e-05 0.0018982528107135616
+ 6.5062730399317046e-05 0.0020083293767566338
+ 6.5062742902012255e-05 0.002141246780886198
+ 6.5062755404707477e-05 0.0022735106700283729
+ 6.5062767907402699e-05 0.0024050029041599369
+ 6.5062780410097922e-05 0.0025356196305195535
+ 6.5062792912793131e-05 0.0026652683340791378
+ 6.5062805415488353e-05 0.002793865545581445
+ 6.5062817918183576e-05 0.0029213350620943554
+ 6.5062830420878798e-05 0.0030476065669750823
+ 6.5062845592253873e-05 0.0031991277392290247
+ 6.5062860763628948e-05 0.0033486794005026179
+ 6.5062875935004036e-05 0.0034961593179601309
+ 6.5062891106379111e-05 0.0036414711081661105
+ 6.5062906277754199e-05 0.0037845233735065873
+ 6.5062921449129274e-05 0.0039252290818992874
+ 6.5062936620504348e-05 0.0040635051254073566
+ 6.5062954860519559e-05 0.0042264209820281088
+ 6.5062973100534771e-05 0.0043855785109888799
+ 6.5062991340549982e-05 0.004540852807539594
+ 6.5063009580565179e-05 0.0046921255232483241
+ 6.506302782058039e-05 0.004839284756390172
+ 6.5063046060595601e-05 0.0049822250059800644
+ 6.506306819986585e-05 0.0051499118748984281
+ 6.5063090339136098e-05 0.0053110729761570875
+ 6.5063112478406347e-05 0.0054655577982168782
+ 6.5063134617676595e-05 0.0056132299331846198
+ 6.506316129301132e-05 0.0057819364493443522
+ 6.5063187873095807e-05 0.0059398423573548687
+ 6.5063214453180295e-05 0.0060874136176253622
+ 6.506324868848434e-05 0.0062620603819550135
+ 6.5063282923788384e-05 0.0064191641307141745
+ 6.5063315356127046e-05 0.0065517091134031152
+ 6.5063347788465707e-05 0.0066683776453289999
+ 6.5063380220804369e-05 0.0067692021882621509
+ 6.5063412653143044e-05 0.0068542763543729904
+ 6.5063445085481705e-05 0.0069237529436825757
+ 6.5063477517820367e-05 0.0069778416850672731
+ 6.5063509950159028e-05 0.0070168067033145008
+ 6.506354238249769e-05 0.0070409637367341727
+ 6.5063569584998142e-05 0.0070500711051410814
+ 6.5063596787498593e-05 0.0070492564131712353
+ 6.5063623989999059e-05 0.0070387804986578604
+ 6.5063651192499511e-05 0.0070189238317284377
+ 6.5063678394999963e-05 0.0069899850256677273
+ 6.5063705597500414e-05 0.0069522793135452206
+ 6.5063732800000866e-05 0.0069061369988542495
+ 6.5063760002501318e-05 0.0068519018883273245
+ 6.506378720500177e-05 0.0067899297149596706
+ 6.5063814407502235e-05 0.0067205865590935169
+ 6.5063841610002687e-05 0.0066442472751925379
+ 6.5063868812503139e-05 0.006561293931672073
+ 6.5063896015003591e-05 0.0064721142708494637
+ 6.5063923217504043e-05 0.0063771001957435066
+ 6.5063950420004494e-05 0.0062766462900859356
+ 6.5063977622504946e-05 0.0061711483775146155
+ 6.5064004825005398e-05 0.0060610021255013743
+ 6.506403202750585e-05 0.0059466016991306979
+ 6.5064059230006315e-05 0.0058283384693926773
+ 6.5064086432506767e-05 0.0057065997804302861
+ 6.5064115300883505e-05 0.0055740309990659331
+ 6.5064144169260229e-05 0.0054384272991202893
+ 6.5064173037636966e-05 0.0053002282345430132
+ 6.5064201906013704e-05 0.0051598626838551204
+ 6.5064230774390441e-05 0.0050177476630414884
+ 6.5064259642767179e-05 0.0048742872442221231
+ 6.5064288511143903e-05 0.0047298715812966012
+ 6.506431737952064e-05 0.0045848760430473451
+ 6.5064346247897378e-05 0.0044396604535071188
+ 6.506438113516668e-05 0.0042643637747592994
+ 6.5064416022435982e-05 0.0040898203879790361
+ 6.506444998550605e-05 0.0039211359224094145
+ 6.5064483948576118e-05 0.0037541355090310092
+ 6.5064517911646172e-05 0.0035892460195200843
+ 6.506455187471624e-05 0.0034268598627977894
+ 6.5064585837786308e-05 0.0032673350066711841
+ 6.5064627381082821e-05 0.0030765664536155394
+ 6.5064668924379334e-05 0.0028910852643209248
+ 6.5064710467675847e-05 0.0027113416169293153
+ 6.5064752010972359e-05 0.0025377141992044784
+ 6.5064802322523102e-05 0.0023360685105670866
+ 6.506485312517364e-05 0.0021424443576868821
+ 6.5064903927824165e-05 0.001959156496722657
+ 6.5064971607266253e-05 0.0017313192252947558
+ 6.5065039286708328e-05 0.0015222190408349249
+ 6.5065091919396561e-05 0.001372431253814393
+ 6.5065144552084808e-05 0.0012336381966261724
+ 6.5065197184773055e-05 0.0011055447342070166
+ 6.5065249817461302e-05 0.00098778684645394604
+ 6.5065297809929103e-05 0.00088906516794052203
+ 6.5065345802396905e-05 0.00079823747715313789
+ 6.5065393794864706e-05 0.00071492972227882204
+ 6.5065441787332508e-05 0.00063875107498295779
+ 6.5065489779800309e-05 0.00056929990178360005
+ 6.5065537261554867e-05 0.00050680910974394439
+ 6.5065584743309411e-05 0.00045011010916966049
+ 6.5065632225063956e-05 0.00039881145821643485
+ 6.5065679706818514e-05 0.00035252854906615789
+ 6.5065727188573058e-05 0.00031088653907439246
+ 6.5065774670327616e-05 0.0002735227890958723
+ 6.5065824358583364e-05 0.00023862511600889196
+ 6.5065874046839125e-05 0.00020765025205703798
+ 6.5065923735094873e-05 0.00018023763188315632
+ 6.5065973423350634e-05 0.00015604795426756195
+ 6.5066023111606396e-05 0.0001347637411803884
+ 6.5066072799862144e-05 0.00011608953467670693
+ 6.5066127951386076e-05 9.8086983151495662e-05
+ 6.5066183102910008e-05 8.2620379659707852e-05
+ 6.5066238254433926e-05 6.937830638173144e-05
+ 6.5066293405957858e-05 5.8079646203919961e-05
+ 6.5066348557481777e-05 4.8471998343402797e-05
+ 6.5066411640520542e-05 3.9267448447275403e-05
+ 6.5066474723559294e-05 3.1683839518460041e-05
+ 6.506653780659806e-05 2.5463033689023789e-05
+ 6.5066600889636812e-05 2.0382309617297274e-05
+ 6.506667414014642e-05 1.5662206653736814e-05
+ 6.5066747390656041e-05 1.1971024407425274e-05
+ 6.5066820641165648e-05 9.101093726216712e-06
+ 6.506690561942158e-05 6.5781195004269459e-06
+ 6.5066990597677525e-05 4.7207090840830405e-06
+ 6.5067093836844781e-05 3.1245246960755978e-06
+ 6.5067198171769419e-05 2.0371887602864823e-06
+ 6.5067302506694044e-05 1.3141391771344707e-06
+ 6.5067426664469169e-05 7.6923430377838728e-07
+ 6.5067550822244281e-05 4.435788450454647e-07
+ 6.5067705800806532e-05 2.1851475951109054e-07
+ 6.5067884937131785e-05 9.3708673373505121e-08
+ 6.5068098556602394e-05 3.2883700516734768e-08
+ 6.5068364485722956e-05 8.5309004428172277e-09
+ 6.5068717982712205e-05 1.4552417250701691e-09
+ 6.5069242097564147e-05 3.0578689270965244e-10
+ 6.507013634012048e-05 2.4569663308855879e-10
+ 6.5072132807185039e-05 2.4259754686171839e-10
+ 6.5073988816858016e-05 2.4182034068072913e-10
+ 6.5076421668443081e-05 2.4138174969930913e-10
+ 6.5078854520028145e-05 2.4076582964276258e-10
+ 6.5081287371613209e-05 2.4012576594620444e-10
+ 6.5083720223198274e-05 2.4057963384973803e-10
+ 6.5086153074783338e-05 2.4092919901400983e-10
+ 6.5088585926368402e-05 2.401872610697499e-10
+ 6.5091018777953467e-05 2.3987554496708928e-10
+ 6.5093451629538531e-05 2.4037942571475707e-10
+ 6.5095767705239778e-05 2.4025247901632375e-10
+ 6.5098819440406717e-05 2.4017887589128354e-10
+ 6.5101871175573655e-05 2.4009951114703349e-10
+ 6.5104922910740593e-05 2.4004351142745323e-10
+ 6.5107974645907532e-05 2.4016098617015712e-10
+ 6.511102638107447e-05 2.4071442426522539e-10
+ 6.5114078116241408e-05 2.3968616681674537e-10
+ 6.5117773618773595e-05 2.4003007462135484e-10
+ 6.5121134288610914e-05 2.4006402385879101e-10
+ 6.5124494958448219e-05 2.4006047129867007e-10
+ 6.5128620731690282e-05 2.4005210497337081e-10
+ 6.5132746504932332e-05 2.4004042399080182e-10
+ 6.5136872278174395e-05 2.4003044384477591e-10
+ 6.5140998051416458e-05 2.4003749578386358e-10
+ 6.5145123824658521e-05 2.4008180521387353e-10
+ 6.5150251138437098e-05 2.4016443526047099e-10
+ 6.5155378452215674e-05 2.3985136550844345e-10
+ 6.5160505765994264e-05 2.3994252727381691e-10
+ 6.516563307977284e-05 2.4004700010028028e-10
+ 6.5171995979825147e-05 2.4004483697536087e-10
+ 6.5178358879877467e-05 2.3997024527683999e-10
+ 6.5184721779929774e-05 2.3997592655072043e-10
+ 6.5192497256254505e-05 2.4000749931504923e-10
+ 6.520027273257925e-05 2.4001269631983051e-10
+ 6.5208048208903994e-05 2.3999782508278659e-10
+ 6.5217983441936064e-05 2.3999355892689472e-10
+ 6.5227918674968147e-05 2.4000179472492324e-10
+ 6.5240125706218145e-05 2.4000339716614338e-10
+ 6.5252332737468144e-05 2.3999888202599127e-10
+ 6.5264539768718143e-05 2.3999830525938688e-10
+ 6.5276746799968141e-05 2.4000037974237526e-10
+ 6.528895383121814e-05 2.4000087414852165e-10
+ 6.5301160862468139e-05 2.3999993966201389e-10
+ 6.5313367893718137e-05 2.3999960494882817e-10
+ 6.5325574924968136e-05 2.4000001432309894e-10
+ 6.5337781956218148e-05 2.4000021737723387e-10
+ 6.5349988987468147e-05 2.4000004462513988e-10
+ 6.5362196018718146e-05 2.3999993006727966e-10
+ 6.5374403049968144e-05 2.3999999917748096e-10
+ 6.5386610081218143e-05 2.4000006049017395e-10
+ 6.5398817112468142e-05 2.4000003421757239e-10
+ 6.541102414371814e-05 2.4000000237870328e-10
+ 6.5423231174968139e-05 2.4000001256652595e-10
+ 6.5435438206218137e-05 2.4000002745854788e-10
+ 6.5447645237468136e-05 2.4000002475271839e-10
+ 6.5459852268718135e-05 2.4000001795384735e-10
+ 6.5472059299968147e-05 2.400000173879749e-10
+ 6.5484266331218146e-05 2.4000002070407596e-10
+ 6.5496473362468144e-05 2.4000002067419452e-10
+ 6.5508680393718143e-05 2.4000001976473751e-10
+ 6.5520887424968142e-05 2.40000019362722e-10
+ 6.553309445621814e-05 2.4000002028128461e-10
+ 6.5545301487468139e-05 2.4000002060646208e-10
+ 6.5557508518718138e-05 2.4000002008287723e-10
+ 6.5569715549968136e-05 2.4000001934276911e-10
+ 6.5581922581218135e-05 2.4000001968966948e-10
+ 6.5594129612468147e-05 2.4000002093381111e-10
+ 6.5606336643718146e-05 2.4000001965726013e-10
+ 6.5618543674968144e-05 2.4000001961507071e-10
+ 6.5630750706218143e-05 2.4000002048512451e-10
+ 6.5642957737468142e-05 2.4000001998121006e-10
+ 6.565516476871814e-05 2.400000199764228e-10
+ 6.5667371799968139e-05 2.4000001998665694e-10
+ 6.5679578831218138e-05 2.4000001988395378e-10
+ 6.5691785862468136e-05 2.4000001969840786e-10
+ 6.5703992893718135e-05 2.4000001962628526e-10
+ 6.5716199924968134e-05 2.4000001985975601e-10
+ 6.5728406956218146e-05 2.4000001994562599e-10
+ 6.5740613987468145e-05 2.4000001873790616e-10
+ 6.5752821018718143e-05 2.400000206888198e-10
+ 6.5765028049968142e-05 2.4000002115772409e-10
+ 6.577723508121814e-05 2.4000001926167516e-10
+ 6.5789442112468139e-05 2.4000001865095655e-10
+ 6.5801649143718138e-05 2.4000002024868279e-10
+ 6.5813856174968136e-05 2.4000002062807212e-10
+ 6.5826063206218135e-05 2.4000001971246058e-10
+ 6.5838270237468134e-05 2.4000001913611468e-10
+ 6.5850477268718146e-05 2.4000001939609548e-10
+ 6.5862684299968145e-05 2.4000001928925776e-10
+ 6.5874891331218143e-05 2.4000002036211893e-10
+ 6.5887098362468142e-05 2.4000001948566678e-10
+ 6.5899305393718141e-05 2.40000020557049e-10
+ 6.5911512424968139e-05 2.400000203491446e-10
+ 6.5923719456218138e-05 2.4000001961720044e-10
+ 6.5935926487468137e-05 2.400000200808237e-10
+ 6.5948133518718135e-05 2.4000002006495584e-10
+ 6.5960340549968134e-05 2.4000001941755901e-10
+ 6.5972547581218133e-05 2.4000001925514504e-10
+ 6.5984754612468145e-05 2.4000001949494439e-10
+ 6.5996961643718143e-05 2.4000001987457185e-10
+ 6.6009168674968142e-05 2.4000001956535886e-10
+ 6.6021375706218141e-05 2.4000001976899341e-10
+ 6.6033582737468139e-05 2.4000001989767335e-10
+ 6.6045789768718138e-05 2.4000002010421042e-10
+ 6.6057996799968137e-05 2.4000002031692612e-10
+ 6.6070203831218135e-05 2.4000001943796074e-10
+ 6.6082410862468134e-05 2.4000001979057998e-10
+ 6.6094617893718133e-05 2.4000001994141042e-10
+ 6.6106824924968131e-05 2.4000001910787902e-10
+ 6.6119031956218143e-05 2.4000002014157438e-10
+ 6.6131238987468142e-05 2.4000002007976212e-10
+ 6.6143446018718141e-05 2.4000001897875313e-10
+ 6.6155653049968139e-05 2.4000002030066949e-10
+ 6.6167860081218138e-05 2.4000002070432142e-10
+ 6.6180067112468137e-05 2.4000001950520541e-10
+ 6.6192274143718135e-05 2.4000001947980057e-10
+ 6.6204481174968134e-05 2.4000002027253361e-10
+ 6.6216688206218133e-05 2.40000020609859e-10
+ 6.6228895237468131e-05 2.4000001911322354e-10
+ 6.624110226871813e-05 2.4000001969739074e-10
+ 6.6253309299968142e-05 2.4000002073053612e-10
+ 6.6265516331218141e-05 2.4000001994814067e-10
+ 6.627772336246814e-05 2.4000001923239209e-10
+ 6.6289930393718138e-05 2.4000002015288261e-10
+ 6.6302137424968137e-05 2.4000001930210656e-10
+ 6.6314344456218136e-05 2.4000001837686493e-10
+ 6.6326551487468134e-05 2.4000001946449939e-10
+ 6.6338758518718133e-05 2.4000002038326192e-10
+ 6.6350965549968132e-05 2.400000203109469e-10
+ 6.6363172581218144e-05 2.400000203952259e-10
+ 6.6375379612468142e-05 2.4000001970496741e-10
+ 6.6387586643718141e-05 2.4000001924454606e-10
+ 6.639979367496814e-05 2.4000001905466872e-10
+ 6.6412000706218138e-05 2.400000204518705e-10
+ 6.6424207737468137e-05 2.4000002011557764e-10
+ 6.6436414768718136e-05 2.4000001946831419e-10
+ 6.6448621799968134e-05 2.4000001925940771e-10
+ 6.6460828831218147e-05 2.4000001980987061e-10
+ 6.6473035862468145e-05 2.4000002089319245e-10
+ 6.6485242893718144e-05 2.4000001973823067e-10
+ 6.6497449924968142e-05 2.4000001879346328e-10
+ 6.6509656956218141e-05 2.4000001869932423e-10
+ 6.652186398746814e-05 2.4000002074828773e-10
+ 6.6534071018718138e-05 2.4000001934026167e-10
+ 6.6546278049968137e-05 2.4000001952115826e-10
+ 6.6558485081218149e-05 2.4000001987859593e-10
+ 6.6570692112468148e-05 2.400000198982881e-10
+ 6.6582899143718147e-05 2.40000018977687e-10
+ 6.6595106174968145e-05 2.4000001970468766e-10
+ 6.6607313206218144e-05 2.4000001969944985e-10
+ 6.6619520237468143e-05 2.4000002027367879e-10
+ 6.6631727268718141e-05 2.4000001840031488e-10
+ 6.664393429996814e-05 2.4000001957318321e-10
+ 6.6656141331218152e-05 2.400000188108562e-10
+ 6.6668348362468151e-05 2.4000002046679305e-10
+ 6.6680555393718149e-05 2.4000001950571268e-10
+ 6.6692762424968148e-05 2.4000001838116472e-10
+ 6.6704969456218147e-05 2.4000001853089837e-10
+ 6.6717176487468145e-05 2.4000002004811227e-10
+ 6.6729383518718144e-05 2.4000001966057371e-10
+ 6.6741590549968143e-05 2.4000001941089245e-10
+ 6.6753797581218155e-05 2.4000001913185568e-10
+ 6.6766004612468154e-05 2.4000001954838558e-10
+ 6.6778211643718152e-05 2.4000001920964592e-10
+ 6.6790418674968151e-05 2.4000001943469307e-10
+ 6.680262570621815e-05 2.4000001866641258e-10
+ 6.6814832737468148e-05 2.4000002020897109e-10
+ 6.6827039768718147e-05 2.4000001940179987e-10
+ 6.6839246799968145e-05 2.4000001993507329e-10
+ 6.6851453831218158e-05 2.4000002008198123e-10
+ 6.6863660862468156e-05 2.400000198005213e-10
+ 6.6875867893718155e-05 2.4000001916301211e-10
+ 6.6888074924968154e-05 2.4000001960280073e-10
+ 6.6900281956218152e-05 2.4000001963117276e-10
+ 6.6912488987468151e-05 2.400000196254434e-10
+ 6.692469601871815e-05 2.4000002030623543e-10
+ 6.6936903049968148e-05 2.4000001985486468e-10
+ 6.694911008121816e-05 2.4000001975560508e-10
+ 6.6961317112468159e-05 2.4000002002563028e-10
+ 6.6973524143718158e-05 2.4000001880683233e-10
+ 6.6985731174968156e-05 2.400000186107882e-10
+ 6.6997938206218155e-05 2.4000002026174485e-10
+ 6.7010145237468154e-05 2.4000001964579944e-10
+ 6.7022352268718152e-05 2.4000001869414737e-10
+ 6.7034559299968151e-05 2.4000002024855297e-10
+ 6.7046766331218163e-05 2.4000001886895933e-10
+ 6.7058973362468162e-05 2.4000001996539064e-10
+ 6.7071180393718161e-05 2.4000001852201533e-10
+ 6.7083387424968159e-05 2.4000001995376353e-10
+ 6.7095594456218158e-05 2.4000001885033681e-10
+ 6.7107801487468157e-05 2.400000202275795e-10
+ 6.7120008518718155e-05 2.4000001938682899e-10
+ 6.7132215549968154e-05 2.400000185286626e-10
+ 6.7144422581218166e-05 2.4000002021567022e-10
+ 6.7156629612468165e-05 2.4000001929093104e-10
+ 6.7168836643718163e-05 2.4000001945502139e-10
+ 6.7181043674968162e-05 2.4000001849176264e-10
+ 6.7193250706218161e-05 2.4000001899160695e-10
+ 6.7205457737468159e-05 2.4000001908469775e-10
+ 6.7217664768718158e-05 2.4000002021320925e-10
+ 6.7229871799968157e-05 2.4000001986077044e-10
+ 6.7242078831218169e-05 2.4000001985660228e-10
+ 6.7254285862468168e-05 2.4000001982734366e-10
+ 6.7266492893718166e-05 2.4000001909394165e-10
+ 6.7278699924968165e-05 2.4000001971428865e-10
+ 6.7290906956218164e-05 2.4000001921042243e-10
+ 6.7303113987468162e-05 2.400000190589926e-10
+ 6.7315321018718161e-05 2.400000192770844e-10
+ 6.7327528049968159e-05 2.4000001876027354e-10
+ 6.7339735081218172e-05 2.4000001963225885e-10
+ 6.735194211246817e-05 2.4000001898595255e-10
+ 6.7364149143718169e-05 2.4000001876650681e-10
+ 6.7376356174968168e-05 2.4000001955479303e-10
+ 6.7388563206218166e-05 2.400000192149284e-10
+ 6.7400770237468165e-05 2.4000001962818762e-10
+ 6.7412977268718164e-05 2.400000192259498e-10
+ 6.7425184299968162e-05 2.4000001958046752e-10
+ 6.7437391331218174e-05 2.4000001876653049e-10
+ 6.7449598362468173e-05 2.4000001901679062e-10
+ 6.7461805393718172e-05 2.4000001929188411e-10
+ 6.747401242496817e-05 2.4000001878460593e-10
+ 6.7486219456218169e-05 2.4000001895149019e-10
+ 6.7498426487468168e-05 2.4000001953324466e-10
+ 6.7510633518718166e-05 2.4000001930179932e-10
+ 6.7522840549968165e-05 2.4000001867284628e-10
+ 6.7535047581218177e-05 2.4000001876404646e-10
+ 6.7547254612468176e-05 2.4000001844012502e-10
+ 6.7559461643718175e-05 2.4000001847700822e-10
+ 6.7571668674968173e-05 2.4000001848915366e-10
+ 6.7583875706218172e-05 2.4000001847211049e-10
+ 6.7596082737468171e-05 2.4000001842583542e-10
+ 6.7608289768718169e-05 2.4000001874485954e-10
+ 6.7620496799968168e-05 2.4000001864470591e-10
+ 6.763270383121818e-05 2.400000192645186e-10
+ 6.7644910862468179e-05 2.4000001911011029e-10
+ 6.7657117893718177e-05 2.400000189594016e-10
+ 6.7669324924968176e-05 2.4000001834385696e-10
+ 6.7681531956218175e-05 2.4000001923683012e-10
+ 6.7693738987468173e-05 2.4000002008098464e-10
+ 6.7705946018718172e-05 2.400000183211859e-10
+ 6.7718153049968171e-05 2.4000001983070817e-10
+ 6.7730360081218183e-05 2.4000001841550595e-10
+ 6.7742567112468182e-05 2.4000001987140726e-10
+ 6.775477414371818e-05 2.4000001839799459e-10
+ 6.7766981174968179e-05 2.4000001979564812e-10
+ 6.7779188206218177e-05 2.4000001826400317e-10
+ 6.7791395237468176e-05 2.3996544537098469e-10
+ 6.7803602268718175e-05 2.3996256464191007e-10
+ 6.7815809299968173e-05 2.3996062147298765e-10
+ 6.7828016331218186e-05 2.399538992151035e-10
+ 6.7840223362468184e-05 2.3990864356794482e-10
+ 6.7852430393718183e-05 2.3980391697569448e-10
+ 6.7864637424968182e-05 2.3960325885649169e-10
+ 6.7870740940593181e-05 2.3930636780140344e-10
+ 6.787684445621818e-05 2.3825018349924986e-10
+ 6.7879896214030687e-05 2.3664385617022961e-10
+ 6.788294797184318e-05 2.313460144418538e-10
+ 6.7884473850749426e-05 2.2273712950258841e-10
+ 6.7885999729655686e-05 1.9502932447418286e-10
+ 6.7886991106889179e-05 1.3263414891107653e-10
+ 6.7887269733896239e-05 9.5672269136980181e-11
+ 6.7887548360903298e-05 4.6113023016783446e-11
+ 6.7888098835627966e-05 4.077304569289076e-11
+ 6.7890875273912433e-05 4.2347131994264368e-11
+ 6.7903082305162431e-05 4.4733371018365243e-11
+ 6.791528933641243e-05 5.3058719093237963e-11
+ 6.7927496367662442e-05 6.5249849962529414e-11
+ 6.7939703398912441e-05 8.0586557341896391e-11
+ 6.795191043016244e-05 9.8186059694000248e-11
+ 6.7964117461412438e-05 1.1703587328666208e-10
+ 6.7976324492662437e-05 1.3605185310399104e-10
+ 6.7988531523912436e-05 1.5414054504639482e-10
+ 6.8000738555162434e-05 1.7026206156240515e-10
+ 6.8012945586412446e-05 1.8348986297121229e-10
+ 6.8025152617662445e-05 1.9306400774952091e-10
+ 6.8037359648912444e-05 1.9843481134517081e-10
+ 6.8049566680162442e-05 1.9929440536940058e-10
+ 6.8061773711412441e-05 1.9559438520732841e-10
+ 6.807398074266244e-05 1.8754853451668201e-10
+ 6.8086187773912438e-05 1.7562047328816539e-10
+ 6.8098394805162437e-05 1.6049694315998822e-10
+ 6.8110601836412436e-05 1.4304826930135124e-10
+ 6.8122808867662448e-05 1.2427827523140709e-10
+ 6.8135015898912446e-05 1.052665328361379e-10
+ 6.8147222930162445e-05 8.7106269937226752e-11
+ 6.8159429961412444e-05 7.0841506734532094e-11
+ 6.8171636992662442e-05 5.7407035899497847e-11
+ 6.8183844023912441e-05 4.7574696846103914e-11
+ 6.8186895781724948e-05 4.5750674856066197e-11
+ 6.8187048369615567e-05 4.5666462612461995e-11
+ 6.8187429839342128e-05 4.5458870923120094e-11
+ 6.8187467986314783e-05 4.5438342991126504e-11
+ 6.8187475615709322e-05 4.5434242455099145e-11
+ 6.8187490874498387e-05 4.5426046434154427e-11
+ 6.8187496978014002e-05 4.5422769911655126e-11
+ 6.8187499419420264e-05 4.542145960441293e-11
+ 6.8187499604455791e-05 4.5421360302533612e-11
+ 6.8187499974526843e-05 4.5421161701746532e-11
+ 6.8187500714668949e-05 5.7234708751505077e-08
+ 6.8187501454811055e-05 2.3609835104101694e-07
+ 6.8187508856232151e-05 8.3378657603255145e-06
+ 6.8187516257653234e-05 2.6804211983519737e-05
+ 6.8187523659074331e-05 5.4212572160978158e-05
+ 6.8187531060495414e-05 8.9333429400249197e-05
+ 6.818753846191651e-05 0.00013110387761772142
+ 6.8187547512355687e-05 0.00018988604042548046
+ 6.8187556562794864e-05 0.000255812068272275
+ 6.8187565613234054e-05 0.00032768193023753725
+ 6.8187574663673231e-05 0.00040448949601993325
+ 6.8187583714112408e-05 0.00048539058840956265
+ 6.8187595044533506e-05 0.00059137048504824714
+ 6.8187606374954605e-05 0.00070151686849491022
+ 6.8187617705375703e-05 0.0008149054011463608
+ 6.8187629035796802e-05 0.00093078918228233572
+ 6.8187643214653363e-05 0.0010784080416500865
+ 6.8187657393509911e-05 0.0012280520970111633
+ 6.8187671572366473e-05 0.0013789889014004875
+ 6.8187689032396938e-05 0.0015657925325384681
+ 6.8187706492427402e-05 0.0017528666320927736
+ 6.8187723952457867e-05 0.0019395804048633696
+ 6.818774626847783e-05 0.0021769293571718938
+ 6.8187768584497806e-05 0.0024120996791847497
+ 6.8187790900517769e-05 0.0026444704336099976
+ 6.8187819090217245e-05 0.0029332237971511233
+ 6.8187847279916708e-05 0.0032158629328255771
+ 6.8187875469616184e-05 0.0034916668520790159
+ 6.8187903659315646e-05 0.0037599988278231356
+ 6.8187931849015123e-05 0.0040202830355208904
+ 6.8187960038714585e-05 0.0042719918874605982
+ 6.8187988228414061e-05 0.0045146394015623476
+ 6.8188019414106477e-05 0.0047719795450323309
+ 6.8188050599798879e-05 0.0050171295125712645
+ 6.8188081785491294e-05 0.0052495906087394869
+ 6.818811297118371e-05 0.0054689190353913904
+ 6.8188150418414342e-05 0.0057143885297757718
+ 6.8188187865644961e-05 0.0059397992525804574
+ 6.8188225312875594e-05 0.006144702220679193
+ 6.8188270844195804e-05 0.0063657430322260553
+ 6.8188316375516027e-05 0.0065556175023236875
+ 6.8188361906836237e-05 0.0067142112673811444
+ 6.8188407438156447e-05 0.0068416534980290083
+ 6.8188441084028113e-05 0.0069160175765833089
+ 6.8188474729899778e-05 0.0069737900261410465
+ 6.8188508375771444e-05 0.0070152594941248576
+ 6.8188542021643109e-05 0.0070407746969006688
+ 6.8188575667514775e-05 0.007050740823760393
+ 6.818860931338644e-05 0.0070456156939712805
+ 6.8188642959258106e-05 0.007025905702338452
+ 6.8188676605129771e-05 0.0069921615895264296
+ 6.8188710251001436e-05 0.0069449740739896257
+ 6.8188736870668153e-05 0.006898526876910809
+ 6.8188763490334856e-05 0.0068443802044164921
+ 6.8188790110001573e-05 0.0067828688534493494
+ 6.8188816729668276e-05 0.0067143369242957376
+ 6.8188843349334993e-05 0.0066391364097472113
+ 6.8188869969001696e-05 0.0065576257964309343
+ 6.8188896588668413e-05 0.0064701686843428533
+ 6.8188923208335116e-05 0.0063771324303375145
+ 6.8188949828001832e-05 0.0062788868210215225
+ 6.8188976447668549e-05 0.0061758027801676225
+ 6.8189003067335252e-05 0.0060682511154162089
+ 6.8189029687001969e-05 0.0059566013086644297
+ 6.8189056306668672e-05 0.0058412203541628417
+ 6.8189082926335389e-05 0.0057224716479485063
+ 6.8189109546002092e-05 0.0056007139318451742
+ 6.8189136165668808e-05 0.0054763002948580381
+ 6.8189162785335525e-05 0.0053495772343856614
+ 6.8189189405002228e-05 0.0052208837792675896
+ 6.8189216024668945e-05 0.0050905506764474901
+ 6.8189239404935228e-05 0.0049749804171373225
+ 6.8189262785201511e-05 0.0048586054363550972
+ 6.8189286165467808e-05 0.0047416314482211135
+ 6.8189309545734091e-05 0.0046242577652878883
+ 6.8189332926000388e-05 0.0045066770343838705
+ 6.8189356306266671e-05 0.0043890750025309139
+ 6.8189379686532954e-05 0.0042716303126259531
+ 6.8189403066799251e-05 0.0041545143284691553
+ 6.8189426447065534e-05 0.0040378909886185305
+ 6.8189449827331817e-05 0.0039219166884552218
+ 6.8189473207598114e-05 0.0038067401897542695
+ 6.8189496587864397e-05 0.0036925025569730643
+ 6.8189519968130693e-05 0.0035793371193940525
+ 6.8189543348396976e-05 0.0034673694581895016
+ 6.818956672866326e-05 0.0033567174174145066
+ 6.8189590108929556e-05 0.0032474911378798247
+ 6.8189613489195839e-05 0.0031397931128086067
+ 6.8189636869462123e-05 0.0030337182641405314
+ 6.8189660249728419e-05 0.0029293540383132049
+ 6.8189683629994702e-05 0.0028267805203238136
+ 6.8189707010260999e-05 0.0027260705648536779
+ 6.8189735591237519e-05 0.0026055855381113117
+ 6.818976417221404e-05 0.0024880893416989024
+ 6.818979275319056e-05 0.0023736731389782805
+ 6.8189821334167094e-05 0.0022624136400195647
+ 6.8189849915143615e-05 0.0021543736566158275
+ 6.8189886199806213e-05 0.0020219271947776738
+ 6.818992545337338e-05 0.0018846580284455387
+ 6.8189946977215265e-05 0.0018120618774395494
+ 6.8189973696714695e-05 0.0017245821083065652
+ 6.8190000416214138e-05 0.0016400258203643724
+ 6.8190027135713567e-05 0.0015583844444338579
+ 6.819005385521301e-05 0.0014796423351417674
+ 6.8190080574712439e-05 0.0014037772468436488
+ 6.8190107294211882e-05 0.0013307608065583204
+ 6.8190134013711311e-05 0.0012605589819463642
+ 6.8190160733210754e-05 0.0011931325425094006
+ 6.8190187452710183e-05 0.0011284375123336611
+ 6.8190214172209626e-05 0.0010664256128491564
+ 6.8190240891709055e-05 0.0010070446942234952
+ 6.8190262548859616e-05 0.00096080661895637035
+ 6.8190284206010162e-05 0.0009162294538821239
+ 6.8190305863160709e-05 0.00087328092606094238
+ 6.8190327520311269e-05 0.00083192771752318962
+ 6.8190349177461816e-05 0.00079213559354230647
+ 6.8190370834612376e-05 0.00075386952625768001
+ 6.8190392491762923e-05 0.00071709381353394315
+ 6.8190414148913469e-05 0.00068177219296354193
+ 6.819043580606403e-05 0.00064786795094112185
+ 6.8190457463214576e-05 0.00061534402675914772
+ 6.8190479120365137e-05 0.00058416311167918647
+ 6.8190496765399604e-05 0.00055972551886932095
+ 6.8190514410434072e-05 0.00053613426244406741
+ 6.8190532055468554e-05 0.00051336904748169171
+ 6.8190549700503021e-05 0.00049140960981622914
+ 6.8190567345537503e-05 0.00047023574348777509
+ 6.8190584990571971e-05 0.00044982732676715286
+ 6.8190602635606452e-05 0.00043016434677204047
+ 6.819062028064092e-05 0.00041122692269401575
+ 6.8190637925675388e-05 0.00039299532765819798
+ 6.8190655570709869e-05 0.00037545000923921415
+ 6.8190673215744337e-05 0.00035857160865911174
+ 6.8190690860778818e-05 0.00034234097869457157
+ 6.8190708505813286e-05 0.00032673920032235228
+ 6.8190726150847768e-05 0.00031174759813332067
+ 6.8190743795882235e-05 0.00029734775454669758
+ 6.8190761440916703e-05 0.00028352152285727745
+ 6.8190779085951185e-05 0.0002702510391493668
+ 6.8190796730985652e-05 0.00025751873311203796
+ 6.8190814376020134e-05 0.00024530733779101174
+ 6.8190832021054602e-05 0.00023359989831307307
+ 6.8190849666089083e-05 0.00022237977961939102
+ 6.8190867311123551e-05 0.00021163067324446447
+ 6.8190884956158032e-05 0.00020133660317765155
+ 6.81909026011925e-05 0.00019148193084437179
+ 6.8190920246226968e-05 0.00018205135924409671
+ 6.8190937891261449e-05 0.00017302993628217709
+ 6.8190955536295917e-05 0.00016440305733239472
+ 6.8190973181330399e-05 0.00015615646706688136
+ 6.8190990826364866e-05 0.00014827626058972067
+ 6.8191008471399348e-05 0.00014074888391014853
+ 6.8191026116433816e-05 0.00013356113379079491
+ 6.8191043761468297e-05 0.00012670015700587552
+ 6.8191061406502765e-05 0.00012015344904364461
+ 6.8191079051537233e-05 0.00011390885228677083
+ 6.8191096696571714e-05 0.00010795455370359766
+ 6.8191114341606182e-05 0.00010227908208250491
+ 6.8191131986640663e-05 9.687130484080241e-05
+ 6.8191149631675131e-05 9.1720424438765868e-05
+ 6.8191167276709613e-05 8.6815974428572379e-05
+ 6.819118492174408e-05 8.2147815167013072e-05
+ 6.8191202566778548e-05 7.7706129219957601e-05
+ 6.819122021181303e-05 7.3481416485622882e-05
+ 6.8191237856847498e-05 6.9464489062760908e-05
+ 6.8191255501881979e-05 6.5646465888930612e-05
+ 6.8191273146916447e-05 6.2018767173060703e-05
+ 6.8191290791950928e-05 5.8573108645546759e-05
+ 6.8191308436985396e-05 5.5301495648160228e-05
+ 6.8191326082019864e-05 5.2196217085081444e-05
+ 6.8191343727054345e-05 4.9249839255407143e-05
+ 6.8191361372088813e-05 4.6455199586526805e-05
+ 6.8191379017123294e-05 4.3805400286814076e-05
+ 6.8191396662157762e-05 4.1293801935142287e-05
+ 6.8191414307192244e-05 3.8914017023807698e-05
+ 6.8191431952226711e-05 3.6659903470533496e-05
+ 6.8191449597261193e-05 3.4525558114332587e-05
+ 6.8191467242295661e-05 3.2505310209129923e-05
+ 6.8191484887330129e-05 3.0593714928186798e-05
+ 6.819150253236461e-05 2.878554689153125e-05
+ 6.8191520177399078e-05 2.7075793727781893e-05
+ 6.8191537822433559e-05 2.5459649680957857e-05
+ 6.8191555467468027e-05 2.3932509272096093e-05
+ 6.8191573112502508e-05 2.2489961024749567e-05
+ 6.8191590757536976e-05 2.1127781262716843e-05
+ 6.8191608402571458e-05 1.9841927987655173e-05
+ 6.8191626047605925e-05 1.8628534843556469e-05
+ 6.8191643692640393e-05 1.7483905174418017e-05
+ 6.8191661337674875e-05 1.6404506180818473e-05
+ 6.8191682620107573e-05 1.5184596516820046e-05
+ 6.8191702745281683e-05 1.4108722156777394e-05
+ 6.819172287045578e-05 1.3103783271809466e-05
+ 6.819174299562989e-05 1.2165512099818384e-05
+ 6.8191763120803987e-05 1.1289867233639744e-05
+ 6.8191783245978083e-05 1.0473023791237365e-05
+ 6.8191803371152194e-05 9.711363860421274e-06
+ 6.819182349632629e-05 9.0014672215583367e-06
+ 6.81918436215004e-05 8.3401023506671107e-06
+ 6.8191863746674497e-05 7.7242177042852387e-06
+ 6.819188811074613e-05 7.0353574872189284e-06
+ 6.8191912474817749e-05 6.4041509733236313e-06
+ 6.8191936838889381e-05 5.8261375978047346e-06
+ 6.8191961202961014e-05 5.2971679183216326e-06
+ 6.8191985567032633e-05 4.8133849648221628e-06
+ 6.8192009931104266e-05 4.3712064413582404e-06
+ 6.8192034295175898e-05 3.9673077642003495e-06
+ 6.8192058659247517e-05 3.5986059186122073e-06
+ 6.819208302331915e-05 3.2622441148827113e-06
+ 6.8192107387390769e-05 2.955577222710442e-06
+ 6.8192136719683576e-05 2.6223173518557521e-06
+ 6.8192166051976369e-05 2.3246430183300364e-06
+ 6.8192195384269162e-05 2.0589938235170389e-06
+ 6.8192224716561955e-05 1.8221375097881734e-06
+ 6.8192254048854748e-05 1.6111428978970881e-06
+ 6.8192283381147541e-05 1.4233547079677823e-06
+ 6.8192312713440334e-05 1.2563701699769522e-06
+ 6.8192342045733127e-05 1.1080173307665688e-06
+ 6.8192377848029192e-05 9.4935328593955194e-07
+ 6.8192412335454626e-05 8.1703614317247063e-07
+ 6.8192446822880061e-05 7.0231034037170861e-07
+ 6.8192481310305495e-05 6.0295931014601184e-07
+ 6.8192515797730929e-05 5.1702814794412422e-07
+ 6.8192557828321214e-05 4.2796498791424164e-07
+ 6.8192599858911485e-05 3.5358466304975593e-07
+ 6.819264188950177e-05 2.9157919961691281e-07
+ 6.8192683920092041e-05 2.3998333476715486e-07
+ 6.8192725950682326e-05 1.9712710629082681e-07
+ 6.8192777518503425e-05 1.5442331314774624e-07
+ 6.8192828186666477e-05 1.2110746118199679e-07
+ 6.8192878854829542e-05 9.4668212428266369e-08
+ 6.8192929522992594e-05 7.3741045625230226e-08
+ 6.8192993215143458e-05 5.3572482382509411e-08
+ 6.8193056907294323e-05 3.8650410566722333e-08
+ 6.8193120599445187e-05 2.7655607125139506e-08
+ 6.819319894561072e-05 1.80624388894615e-08
+ 6.8193278657649692e-05 1.1455385675920075e-08
+ 6.8193358369688663e-05 7.0279116712338033e-09
+ 6.8193461292370759e-05 3.42722610432318e-09
+ 6.8193569508909815e-05 1.2415251844169095e-09
+ 6.819370191480444e-05 -1.7423168879043324e-10
+ 6.8193847065030181e-05 -9.0046498724308251e-10
+ 6.8194034315235689e-05 -1.2675598336250834e-09
+ 6.8194255865010431e-05 -1.390661486095478e-09
+ 6.8194554034092507e-05 -1.4079464626524889e-09
+ 6.819499876987089e-05 -1.3781166774969621e-09
+ 6.8195805003988999e-05 -1.313948994893242e-09
+ 6.8196711764368319e-05 -1.2450592154006523e-09
+ 6.8197737475686446e-05 -1.1711746826522686e-09
+ 6.8198801143402337e-05 -1.0985374417948889e-09
+ 6.8199944764949543e-05 -1.0244977902794022e-09
+ 6.8202231646278909e-05 -8.876839903243166e-10
+ 6.8204182681216657e-05 -7.8153991862173163e-10
+ 6.8206291228517244e-05 -6.7660226349856925e-10
+ 6.8208581467436166e-05 -5.7299433820914436e-10
+ 6.8210926666850024e-05 -4.7698621811411996e-10
+ 6.8213271866263882e-05 -3.901690868650475e-10
+ 6.8215590537179632e-05 -3.1248869476676087e-10
+ 6.8218474569484286e-05 -2.2600941125466692e-10
+ 6.8221358601788925e-05 -1.4953972152878652e-10
+ 6.8224242634093579e-05 -8.1909642546355165e-11
+ 6.8227126666398232e-05 -2.2097231394821104e-11
+ 6.8230010698702872e-05 3.0804763949844941e-11
+ 6.8232894731007525e-05 7.7599184420572088e-11
+ 6.8235778763312178e-05 1.1899177680085989e-10
+ 6.8239342797663595e-05 1.6360497315690482e-10
+ 6.8242906832015012e-05 2.0194460469335925e-10
+ 6.8246470866366429e-05 2.3489304324568193e-10
+ 6.8250034900717846e-05 2.6320792465228799e-10
+ 6.8253598935069277e-05 2.8754418863776942e-10
+ 6.8257899961127357e-05 3.124003450031708e-10
+ 6.826220098718545e-05 3.3310188136055884e-10
+ 6.8266502013243543e-05 3.5034335018174361e-10
+ 6.8270803039301623e-05 3.6470346013268147e-10
+ 6.8275104065359716e-05 3.7666442373221598e-10
+ 6.8280502505986979e-05 3.8888313831481749e-10
+ 6.8285900946614257e-05 3.9859542479219459e-10
+ 6.829129938724152e-05 4.0629545583254085e-10
+ 6.8296697827868784e-05 4.1242659596079512e-10
+ 6.8303468247657472e-05 4.1836450212166619e-10
+ 6.8310238667446159e-05 4.228142873871682e-10
+ 6.8317009087234847e-05 4.2614500842071573e-10
+ 6.8325385304343953e-05 4.2912633403108892e-10
+ 6.8333761521453072e-05 4.3120345772378355e-10
+ 6.8342137738562178e-05 4.3264838822889765e-10
+ 6.8353043385488657e-05 4.3388610175178318e-10
+ 6.8363949032415136e-05 4.3464666000495187e-10
+ 6.8376156063665135e-05 4.3514763453961883e-10
+ 6.8388363094915134e-05 4.3542384097085643e-10
+ 6.8400570126165132e-05 4.3556624282357159e-10
+ 6.8412777157415131e-05 4.3562884855868211e-10
+ 6.842498418866513e-05 4.3564390919099658e-10
+ 6.8437191219915128e-05 4.3563071731303817e-10
+ 6.844939825116514e-05 4.3560072832369711e-10
+ 6.8461605282415139e-05 4.3556071800624522e-10
+ 6.8473812313665138e-05 4.3551473285478916e-10
+ 6.8486019344915136e-05 4.3546520640556509e-10
+ 6.8498226376165135e-05 4.3541358487496968e-10
+ 6.8510433407415134e-05 4.3536071753580087e-10
+ 6.8522640438665132e-05 4.353071102954193e-10
+ 6.8534847469915131e-05 4.3525307030070124e-10
+ 6.854705450116513e-05 4.3519878102624261e-10
+ 6.8559261532415142e-05 4.3514434891989702e-10
+ 6.857146856366514e-05 4.3508983678706616e-10
+ 6.8583675594915139e-05 4.3503528333983576e-10
+ 6.8595882626165138e-05 4.3498071205926307e-10
+ 6.8608089657415136e-05 4.3492613633167183e-10
+ 6.8620296688665135e-05 4.348715638520445e-10
+ 6.8632503719915134e-05 4.3481699946235471e-10
+ 6.8644710751165146e-05 4.3476244620745766e-10
+ 6.8656917782415145e-05 4.3470790578886986e-10
+ 6.8669124813665143e-05 4.3465337912630206e-10
+ 6.8681331844915142e-05 4.3459886680952396e-10
+ 6.8693538876165141e-05 4.3454436923774573e-10
+ 6.8705745907415139e-05 4.3448988663097442e-10
+ 6.8717952938665138e-05 4.3443541909242035e-10
+ 6.8730159969915137e-05 4.3438096668679938e-10
+ 6.8742367001165135e-05 4.3432652946422885e-10
+ 6.8750000000000004e-05 4.3429323819786375e-10
+ 6.8762207031250003e-05 4.3423882549145797e-10
+ 6.8774414062500001e-05 4.3418442800650571e-10
+ 6.878662109375e-05 4.3413004574565444e-10
+ 6.8798828124999999e-05 4.3407567870875607e-10
+ 6.8811035156249997e-05 4.3402132689399754e-10
+ 6.882324218750001e-05 4.3396699029857563e-10
+ 6.8835449218750008e-05 4.3391266891909689e-10
+ 6.8847656250000007e-05 4.338583627518177e-10
+ 6.8859863281250006e-05 4.338040717927861e-10
+ 6.8872070312500004e-05 4.3374979603792648e-10
+ 6.8884277343750003e-05 4.3369553548309005e-10
+ 6.8896484375000002e-05 4.3364129012408513e-10
+ 6.890869140625e-05 4.3358705995669485e-10
+ 6.8920898437499999e-05 4.3353284497668784e-10
+ 6.8933105468749998e-05 4.3347864517982436e-10
+ 6.894531250000001e-05 4.3342446056186068e-10
+ 6.8957519531250008e-05 4.3337029111855061e-10
+ 6.8969726562500007e-05 4.3331613684564742e-10
+ 6.8981933593750006e-05 4.3326199773890431e-10
+ 6.8994140625000004e-05 4.3320787379407488e-10
+ 6.9006347656250003e-05 4.3315376500691365e-10
+ 6.9018554687500002e-05 4.3309967137317592e-10
+ 6.903076171875e-05 4.3304559288861817e-10
+ 6.9042968749999999e-05 4.3299152954899793e-10
+ 6.9055175781249998e-05 4.3293748135007384e-10
+ 6.906738281250001e-05 4.3288344828760572e-10
+ 6.9079589843750009e-05 4.3282943035735457e-10
+ 6.9091796875000007e-05 4.3277542755508266e-10
+ 6.9104003906250006e-05 4.327214398765532e-10
+ 6.9116210937500004e-05 4.3266746731753079e-10
+ 6.9128417968750003e-05 4.3261350987378112e-10
+ 6.9140625000000002e-05 4.3255956754107106e-10
+ 6.915283203125e-05 4.3250564031516869e-10
+ 6.9165039062499999e-05 4.324517281918434e-10
+ 6.9177246093749998e-05 4.3239783116686546e-10
+ 6.918945312500001e-05 4.3234394923600652e-10
+ 6.9201660156250009e-05 4.3229008239503964e-10
+ 6.9213867187500007e-05 4.322362306397386e-10
+ 6.9226074218750006e-05 4.3218239396587857e-10
+ 6.9238281250000005e-05 4.3212857236923607e-10
+ 6.9250488281250003e-05 4.3207476584558855e-10
+ 6.9262695312500002e-05 4.3202097439071481e-10
+ 6.9274902343750001e-05 4.3196719800039462e-10
+ 6.9287109374999999e-05 4.3191343667040926e-10
+ 6.9299316406249998e-05 4.3185969039654094e-10
+ 6.931152343750001e-05 4.3180595917457319e-10
+ 6.9323730468750009e-05 4.3175224300029046e-10
+ 6.9335937500000007e-05 4.3169854186947872e-10
+ 6.9348144531250006e-05 4.3164485577792515e-10
+ 6.9360351562500005e-05 4.3159118472141752e-10
+ 6.9372558593750003e-05 4.315375286957455e-10
+ 6.9384765625000002e-05 4.3148388769669956e-10
+ 6.9396972656250001e-05 4.3143026172007142e-10
+ 6.9409179687499999e-05 4.3137665076165393e-10
+ 6.9421386718749998e-05 4.3132305481724119e-10
+ 6.943359375000001e-05 4.3126947388262849e-10
+ 6.9445800781250009e-05 4.3121590795361226e-10
+ 6.9458007812500007e-05 4.3116235702599014e-10
+ 6.9470214843750006e-05 4.311088210955608e-10
+ 6.9482421875000005e-05 4.3105530015812432e-10
+ 6.9494628906250003e-05 4.3100179420948178e-10
+ 6.9506835937500002e-05 4.3094830324543561e-10
+ 6.9519042968750001e-05 4.3089482726178914e-10
+ 6.9531249999999999e-05 4.3084136625434698e-10
+ 6.9543457031249998e-05 4.3078792021891527e-10
+ 6.955566406250001e-05 4.3073448915130076e-10
+ 6.9567871093750009e-05 4.3068107304731183e-10
+ 6.9580078125000008e-05 4.3062767190275767e-10
+ 6.9592285156250006e-05 4.3057428571344897e-10
+ 6.9604492187500005e-05 4.305209144751974e-10
+ 6.9616699218750004e-05 4.3046755818381573e-10
+ 6.9628906250000002e-05 4.3041421683511815e-10
+ 6.9641113281250001e-05 4.3036089042491982e-10
+ 6.96533203125e-05 4.3030757894903721e-10
+ 6.9665527343749998e-05 4.3025428240328784e-10
+ 6.967773437500001e-05 4.3020100078349046e-10
+ 6.9689941406250009e-05 4.3014773408546503e-10
+ 6.9702148437500008e-05 4.3009448230503257e-10
+ 6.9714355468750006e-05 4.3004124543801536e-10
+ 6.9726562500000005e-05 4.2998802348023685e-10
+ 6.9738769531250004e-05 4.2993481642752165e-10
+ 6.9750976562500002e-05 4.298816242756955e-10
+ 6.9763183593750001e-05 4.2982844702058526e-10
+ 6.9775390625e-05 4.2977528465801911e-10
+ 6.9787597656249998e-05 4.2972213718382639e-10
+ 6.979980468750001e-05 4.296690045938374e-10
+ 6.9812011718750009e-05 4.2961588688388387e-10
+ 6.9824218750000008e-05 4.2956278404979846e-10
+ 6.9836425781250006e-05 4.2950969608741529e-10
+ 6.9848632812500005e-05 4.2945662299256918e-10
+ 6.9860839843750004e-05 4.2940356476109669e-10
+ 6.9873046875000002e-05 4.2935052138883517e-10
+ 6.9885253906250001e-05 4.2929749287162315e-10
+ 6.98974609375e-05 4.2924447920530045e-10
+ 6.9909667968749998e-05 4.2919148038570803e-10
+ 6.9921874999999997e-05 4.2913849640868801e-10
+ 6.9934082031250009e-05 4.2908552727008359e-10
+ 6.9946289062500008e-05 4.2903257296573924e-10
+ 6.9958496093750007e-05 4.2897963349150058e-10
+ 6.9970703125000005e-05 4.2892670884321429e-10
+ 6.9982910156250004e-05 4.288737990167283e-10
+ 6.9995117187500003e-05 4.2882090400789185e-10
+ 7.0007324218750001e-05 4.2876802381255504e-10
+ 7.001953125e-05 4.2871515842656934e-10
+ 7.0031738281249999e-05 4.2866230784578723e-10
+ 7.0043945312499997e-05 4.2860947206606246e-10
+ 7.0056152343750009e-05 4.2855665108325002e-10
+ 7.0068359375000008e-05 4.2850384489320595e-10
+ 7.0080566406250007e-05 4.2845105349178732e-10
+ 7.0092773437500005e-05 4.2839827687485269e-10
+ 7.0104980468750004e-05 4.2834551503826145e-10
+ 7.0117187500000003e-05 4.2829276797787439e-10
+ 7.0129394531250001e-05 4.2824003568955333e-10
+ 7.01416015625e-05 4.2818731816916134e-10
+ 7.0153808593749999e-05 4.2813461541256231e-10
+ 7.0166015624999997e-05 4.2808192741562203e-10
+ 7.0178222656249996e-05 4.2802925417420679e-10
+ 7.0190429687500008e-05 4.2797659568418397e-10
+ 7.0202636718750007e-05 4.2792395194142275e-10
+ 7.0214843750000005e-05 4.2787132294179297e-10
+ 7.0227050781250004e-05 4.2781870868116553e-10
+ 7.0239257812500003e-05 4.2776610915541303e-10
+ 7.0251464843750001e-05 4.2771352436040875e-10
+ 7.0263671875e-05 4.2766095429202714e-10
+ 7.0275878906249999e-05 4.2760839894614423e-10
+ 7.0288085937499997e-05 4.2755585831863669e-10
+ 7.0300292968749996e-05 4.2750333240538267e-10
+ 7.0312500000000008e-05 4.2745082120226136e-10
+ 7.0324707031250007e-05 4.2739832470515305e-10
+ 7.0336914062500006e-05 4.273458429099393e-10
+ 7.0349121093750004e-05 4.2729337581250278e-10
+ 7.0361328125000003e-05 4.2724092340872732e-10
+ 7.0373535156250002e-05 4.2718848569449787e-10
+ 7.03857421875e-05 4.2713606266570053e-10
+ 7.0397949218749999e-05 4.2708365431822263e-10
+ 7.0410156249999997e-05 4.270312606479525e-10
+ 7.0422363281249996e-05 4.2697888165077988e-10
+ 7.0434570312499995e-05 4.2692651732259529e-10
+ 7.0446777343750007e-05 4.2687416765929084e-10
+ 7.0458984375000006e-05 4.2682183265675928e-10
+ 7.0471191406250004e-05 4.2676951231089505e-10
+ 7.0483398437500003e-05 4.2671720661759342e-10
+ 7.0495605468750002e-05 4.2666491557275079e-10
+ 7.05078125e-05 4.2661263917226478e-10
+ 7.0520019531249999e-05 4.265603774120343e-10
+ 7.0532226562499998e-05 4.265081302879591e-10
+ 7.0544433593749996e-05 4.2645589779594043e-10
+ 7.0556640624999995e-05 4.2640367993188038e-10
+ 7.0568847656249994e-05 4.2635147669168246e-10
+ 7.0581054687500006e-05 4.2629928807125108e-10
+ 7.0593261718750004e-05 4.2624711406649186e-10
+ 7.0605468750000003e-05 4.2619495467331169e-10
+ 7.0617675781250002e-05 4.2614280988761856e-10
+ 7.06298828125e-05 4.2609067970532156e-10
+ 7.0642089843749999e-05 4.2603856412233079e-10
+ 7.0654296874999998e-05 4.2598646313455786e-10
+ 7.0666503906249996e-05 4.2593437673791515e-10
+ 7.0678710937499995e-05 4.2588230492831644e-10
+ 7.0690917968749994e-05 4.2583024770167654e-10
+ 7.0703124999999992e-05 4.2577820505391141e-10
+ 7.0715332031250005e-05 4.2572617698093814e-10
+ 7.0727539062500003e-05 4.2567416347867499e-10
+ 7.0739746093750002e-05 4.2562216454304139e-10
+ 7.0751953125e-05 4.2557018016995789e-10
+ 7.0764160156249999e-05 4.2551821035534623e-10
+ 7.0776367187499998e-05 4.2546625509512913e-10
+ 7.0788574218749996e-05 4.254143143852306e-10
+ 7.0800781249999995e-05 4.2536238822157581e-10
+ 7.0812988281249994e-05 4.2531047660009089e-10
+ 7.0825195312499992e-05 4.2525857951670346e-10
+ 7.0837402343750005e-05 4.252066969673418e-10
+ 7.0849609375000003e-05 4.2515482894793579e-10
+ 7.0861816406250002e-05 4.2510297545441604e-10
+ 7.0874023437500001e-05 4.2505113648271467e-10
+ 7.0886230468749999e-05 4.2499931202876474e-10
+ 7.0898437499999998e-05 4.2494750208850055e-10
+ 7.0910644531249997e-05 4.248957066578573e-10
+ 7.0922851562499995e-05 4.2482519493572964e-10
+ 7.0935058593749994e-05 4.2475256100502045e-10
+ 7.0947265624999993e-05 4.2468173951608737e-10
+ 7.0959472656249991e-05 4.2459666096075283e-10
+ 7.0971679687500003e-05 4.2448010616874532e-10
+ 7.0983886718750002e-05 4.242745676347303e-10
+ 7.0989990234375001e-05 4.2406762246865748e-10
+ 7.0996093750000001e-05 4.2364446431160585e-10
+ 7.0999145507812494e-05 4.2320637096990359e-10
+ 7.1002197265625e-05 4.2237081875579266e-10
+ 7.1005249023437493e-05 4.2039912634768696e-10
+ 7.1006606790774085e-05 4.184858057925494e-10
+ 7.1006998216660864e-05 4.1769354662518729e-10
+ 7.1007389642547644e-05 4.1673967866159501e-10
+ 7.1008368207264573e-05 4.1328644574257995e-10
+ 7.1009409502908183e-05 4.0647792025774505e-10
+ 7.1009970598735333e-05 4.0009399586852752e-10
+ 7.1010339629298371e-05 3.9400830485401903e-10
+ 7.101111032381584e-05 3.7217296598144555e-10
+ 7.101174148123385e-05 3.3482378565862255e-10
+ 7.1012113084009012e-05 2.9476725253157392e-10
+ 7.1012434193795789e-05 2.3913652951300332e-10
+ 7.1012647097925418e-05 2.1273235713088472e-10
+ 7.1012860002055034e-05 2.1207408791108858e-10
+ 7.1014989043351255e-05 2.1185023895337551e-10
+ 7.1027196074601253e-05 2.0757980032582087e-10
+ 7.1039403105851252e-05 1.9827504053149293e-10
+ 7.1051610137101251e-05 1.8447156434439206e-10
+ 7.1063817168351249e-05 1.6696410651490149e-10
+ 7.1076024199601248e-05 1.4676018343964647e-10
+ 7.1088231230851247e-05 1.2502212943217047e-10
+ 7.1100438262101245e-05 1.0300022779102304e-10
+ 7.1112645293351244e-05 8.1960799754197404e-11
+ 7.1124852324601243e-05 6.311338755160194e-11
+ 7.1137059355851241e-05 4.7541218733423125e-11
+ 7.1149266387101254e-05 3.6138949326912032e-11
+ 7.1161473418351252e-05 2.9561263935700322e-11
+ 7.1173680449601251e-05 2.8185285811614418e-11
+ 7.118588748085125e-05 3.2088955187765566e-11
+ 7.1198094512101248e-05 4.1046615499322252e-11
+ 7.1210301543351247e-05 5.4542057385810135e-11
+ 7.1222508574601246e-05 7.1798266491615728e-11
+ 7.1234715605851244e-05 9.1822160785597292e-11
+ 7.1246922637101243e-05 1.1346174161334856e-10
+ 7.1259129668351241e-05 1.3547236949090519e-10
+ 7.127133669960124e-05 1.5658835172212636e-10
+ 7.1283543730851252e-05 1.7559572435646284e-10
+ 7.1295750762101251e-05 1.9140204326212496e-10
+ 7.130795779335125e-05 2.030991720132836e-10
+ 7.1311009551163743e-05 2.0529687447679853e-10
+ 7.1311314726944995e-05 2.0549982177660819e-10
+ 7.1312077666398118e-05 2.0599366009052315e-10
+ 7.1312459136124679e-05 2.062333046850057e-10
+ 7.1312482977982597e-05 2.0624812098499301e-10
+ 7.1312487746354181e-05 2.0625108196291897e-10
+ 7.1312497283097334e-05 2.0625700163649109e-10
+ 7.1312498046036796e-05 2.0625747507891284e-10
+ 7.1312499571915693e-05 2.0625842190532621e-10
+ 7.1312499693986016e-05 2.0625849764807365e-10
+ 7.1312499938126634e-05 2.0625864913207268e-10
+ 7.1312499957657886e-05 2.0625866125070641e-10
+ 7.1312499996720389e-05 2.0625868548793557e-10
+ 7.1312500074845382e-05 8.3574849775232329e-10
+ 7.1312500152970388e-05 2.8382408459534785e-09
+ 7.1312500934220385e-05 9.7910663945931592e-08
+ 7.1312508051845979e-05 6.9281309170090845e-06
+ 7.1312515169471574e-05 2.3496919613390592e-05
+ 7.1312522287097168e-05 4.8515586154137975e-05
+ 7.1312529404722762e-05 8.0864107426474553e-05
+ 7.131253652234837e-05 0.0001195688537478285
+ 7.1312543639973964e-05 0.00016378325676260678
+ 7.1312550757599558e-05 0.00021277103077073492
+ 7.1312557875225153e-05 0.00026589161027525284
+ 7.1312564992850747e-05 0.00032258751106878353
+ 7.1312572110476341e-05 0.00038237336083026571
+ 7.1312579228101949e-05 0.00044482637875059637
+ 7.1312587807568568e-05 0.00052313156179263198
+ 7.1312596387035213e-05 0.00060422377214069478
+ 7.1312604966501832e-05 0.00068763160407692863
+ 7.1312613545968477e-05 0.00077295453496090106
+ 7.1312622125435096e-05 0.00085985181282763258
+ 7.1312630704901741e-05 0.00094803308914625053
+ 7.131263928436836e-05 0.0010372505228311898
+ 7.1312647863835005e-05 0.0011272921245865509
+ 7.1312658180770259e-05 0.0012364048498757886
+ 7.1312668497705513e-05 0.0013461799437633384
+ 7.1312678814640766e-05 0.0014563930288477433
+ 7.131268913157602e-05 0.001566855276772596
+ 7.1312699448511274e-05 0.0016774068636345029
+ 7.1312709765446528e-05 0.001787911643031166
+ 7.1312720082381781e-05 0.0018982528107135616
+ 7.1312730399317035e-05 0.0020083293767566338
+ 7.1312742902012257e-05 0.002141246780886198
+ 7.131275540470748e-05 0.0022735106700283729
+ 7.1312767907402702e-05 0.0024050029041599369
+ 7.1312780410097925e-05 0.0025356196305195535
+ 7.1312792912793134e-05 0.0026652683340791378
+ 7.1312805415488356e-05 0.002793865545581445
+ 7.1312817918183578e-05 0.0029213350620943554
+ 7.1312830420878801e-05 0.0030476065669750823
+ 7.1312845592253876e-05 0.0031991277392290247
+ 7.1312860763628964e-05 0.0033486794005026179
+ 7.1312875935004039e-05 0.0034961593179601309
+ 7.1312891106379113e-05 0.0036414711081661105
+ 7.1312906277754202e-05 0.0037845233735065873
+ 7.1312921449129276e-05 0.0039252290818992874
+ 7.1312936620504351e-05 0.0040635051254073566
+ 7.1312954860519562e-05 0.0042264209820281088
+ 7.1312973100534773e-05 0.0043855785109888799
+ 7.1312991340549985e-05 0.004540852807539594
+ 7.1313009580565182e-05 0.0046921255232483241
+ 7.1313027820580393e-05 0.004839284756390172
+ 7.1313046060595604e-05 0.0049822250059800644
+ 7.1313068199865853e-05 0.0051499118748984281
+ 7.1313090339136101e-05 0.0053110729761570875
+ 7.1313112478406349e-05 0.0054655577982168782
+ 7.1313134617676598e-05 0.0056132299331846198
+ 7.1313161293011323e-05 0.0057819364493443522
+ 7.131318787309581e-05 0.0059398423573548687
+ 7.1313214453180298e-05 0.0060874136176253622
+ 7.1313248688484343e-05 0.0062620603819550135
+ 7.1313282923788387e-05 0.0064191641307141745
+ 7.1313315356127049e-05 0.0065517091134031152
+ 7.131334778846571e-05 0.0066683776453289999
+ 7.1313380220804372e-05 0.0067692021882621509
+ 7.1313412653143047e-05 0.0068542763543729904
+ 7.1313445085481708e-05 0.0069237529436825757
+ 7.131347751782037e-05 0.0069778416850672731
+ 7.1313509950159031e-05 0.0070168067033145008
+ 7.1313542382497693e-05 0.0070409637367341727
+ 7.1313569584998144e-05 0.0070500711051410814
+ 7.131359678749861e-05 0.0070492564131712353
+ 7.1313623989999062e-05 0.0070387804986578604
+ 7.1313651192499514e-05 0.0070189238317284377
+ 7.1313678394999965e-05 0.0069899850256677273
+ 7.1313705597500417e-05 0.0069522793135452206
+ 7.1313732800000869e-05 0.0069061369988542495
+ 7.1313760002501321e-05 0.0068519018883273245
+ 7.1313787205001773e-05 0.0067899297149596706
+ 7.1313814407502225e-05 0.0067205865590935169
+ 7.131384161000269e-05 0.0066442472751925379
+ 7.1313868812503142e-05 0.006561293931672073
+ 7.1313896015003594e-05 0.0064721142708494637
+ 7.1313923217504045e-05 0.0063771001957435066
+ 7.1313950420004497e-05 0.0062766462900859356
+ 7.1313977622504949e-05 0.0061711483775146155
+ 7.1314004825005401e-05 0.0060610021255013743
+ 7.1314032027505866e-05 0.0059466016991306979
+ 7.1314059230006318e-05 0.0058283384693926773
+ 7.131408643250677e-05 0.0057065997804302861
+ 7.1314115300883508e-05 0.0055740309990659331
+ 7.1314144169260231e-05 0.0054384272991202893
+ 7.1314173037636969e-05 0.0053002282345430132
+ 7.1314201906013706e-05 0.0051598626838551204
+ 7.1314230774390444e-05 0.0050177476630414884
+ 7.1314259642767181e-05 0.0048742872442221231
+ 7.1314288511143905e-05 0.0047298715812966012
+ 7.1314317379520643e-05 0.0045848760430473451
+ 7.131434624789738e-05 0.0044396604535071188
+ 7.1314381135166683e-05 0.0042643637747592994
+ 7.1314416022435985e-05 0.0040898203879790361
+ 7.1314449985506053e-05 0.0039211359224094145
+ 7.1314483948576121e-05 0.0037541355090310092
+ 7.1314517911646175e-05 0.0035892460195200843
+ 7.1314551874716243e-05 0.0034268598627977894
+ 7.1314585837786311e-05 0.0032673350066711841
+ 7.1314627381082824e-05 0.0030765664536155394
+ 7.1314668924379337e-05 0.0028910852643209248
+ 7.1314710467675849e-05 0.0027113416169293153
+ 7.1314752010972362e-05 0.0025377141992044784
+ 7.1314802322523105e-05 0.0023360685105670866
+ 7.1314853125173643e-05 0.0021424443576868821
+ 7.1314903927824168e-05 0.001959156496722657
+ 7.1314971607266256e-05 0.0017313192252947558
+ 7.1315039286708331e-05 0.0015222190408349249
+ 7.1315091919396564e-05 0.001372431253814393
+ 7.1315144552084811e-05 0.0012336381966261724
+ 7.1315197184773058e-05 0.0011055447342070166
+ 7.1315249817461304e-05 0.00098778684645394604
+ 7.1315297809929106e-05 0.00088906516794052203
+ 7.1315345802396907e-05 0.00079823747715313789
+ 7.1315393794864709e-05 0.00071492972227882204
+ 7.131544178733251e-05 0.00063875107498295779
+ 7.1315489779800312e-05 0.00056929990178360005
+ 7.131553726155487e-05 0.00050680910974394439
+ 7.1315584743309414e-05 0.00045011010916966049
+ 7.1315632225063958e-05 0.00039881145821643485
+ 7.1315679706818516e-05 0.00035252854906615789
+ 7.1315727188573061e-05 0.00031088653907439246
+ 7.1315774670327605e-05 0.0002735227890958723
+ 7.1315824358583366e-05 0.00023862511600889196
+ 7.1315874046839128e-05 0.00020765025205703798
+ 7.1315923735094876e-05 0.00018023763188315632
+ 7.1315973423350637e-05 0.00015604795426756195
+ 7.1316023111606399e-05 0.0001347637411803884
+ 7.1316072799862146e-05 0.00011608953467670693
+ 7.1316127951386079e-05 9.8086983151495662e-05
+ 7.1316183102910011e-05 8.2620379659707852e-05
+ 7.1316238254433929e-05 6.937830638173144e-05
+ 7.1316293405957861e-05 5.8079646203919961e-05
+ 7.131634855748178e-05 4.8471998343402797e-05
+ 7.1316411640520545e-05 3.9267448447275403e-05
+ 7.1316474723559297e-05 3.1683839518460041e-05
+ 7.1316537806598063e-05 2.5463033689023789e-05
+ 7.1316600889636815e-05 2.0382309617297274e-05
+ 7.1316674140146436e-05 1.5662206653736814e-05
+ 7.1316747390656044e-05 1.1971024407425274e-05
+ 7.1316820641165651e-05 9.101093726216712e-06
+ 7.1316905619421583e-05 6.5781195004269459e-06
+ 7.1316990597677528e-05 4.7207090840830405e-06
+ 7.1317093836844784e-05 3.1245246960755978e-06
+ 7.1317198171769422e-05 2.0371887602864823e-06
+ 7.1317302506694046e-05 1.3141391771344707e-06
+ 7.1317426664469172e-05 7.6923430377838728e-07
+ 7.1317550822244284e-05 4.435788450454647e-07
+ 7.1317705800806534e-05 2.1851475951109054e-07
+ 7.1317884937131788e-05 9.3708673373505121e-08
+ 7.1318098556602397e-05 3.2883700516734768e-08
+ 7.1318364485722959e-05 8.5309004428172277e-09
+ 7.1318717982712208e-05 1.4552417250701691e-09
+ 7.131924209756415e-05 3.0578689270965244e-10
+ 7.1320136340120483e-05 2.4569663308855879e-10
+ 7.1322132807185041e-05 2.4259754686171839e-10
+ 7.1323988816858019e-05 2.4182034068072913e-10
+ 7.1326421668443084e-05 2.4138174969930913e-10
+ 7.1328854520028148e-05 2.4076582964276258e-10
+ 7.1331287371613212e-05 2.4012576594620444e-10
+ 7.1333720223198276e-05 2.4057963384973803e-10
+ 7.1336153074783341e-05 2.4092919901400983e-10
+ 7.1338585926368405e-05 2.401872610697499e-10
+ 7.1341018777953469e-05 2.3987554496708928e-10
+ 7.1343451629538534e-05 2.4037942571475707e-10
+ 7.1345767705239781e-05 2.4025247901632375e-10
+ 7.134881944040672e-05 2.4017887589128354e-10
+ 7.1351871175573658e-05 2.4009951114703349e-10
+ 7.1354922910740596e-05 2.4004351142745323e-10
+ 7.1357974645907534e-05 2.4016098617015712e-10
+ 7.1361026381074473e-05 2.4071442426522539e-10
+ 7.1364078116241411e-05 2.3968616681674537e-10
+ 7.1367773618773598e-05 2.4003007462135484e-10
+ 7.1371134288610917e-05 2.4006402385879101e-10
+ 7.1374494958448222e-05 2.4006047129867007e-10
+ 7.1378620731690285e-05 2.4005210497337081e-10
+ 7.1382746504932335e-05 2.4004042399080182e-10
+ 7.1386872278174398e-05 2.4003044384477591e-10
+ 7.1390998051416461e-05 2.4003749578386358e-10
+ 7.1395123824658524e-05 2.4008180521387353e-10
+ 7.1400251138437101e-05 2.4016443526047099e-10
+ 7.1405378452215677e-05 2.3985136550844345e-10
+ 7.1410505765994266e-05 2.3994252727381691e-10
+ 7.1415633079772843e-05 2.4004700010028028e-10
+ 7.142199597982515e-05 2.4004483697536087e-10
+ 7.142835887987747e-05 2.3997024527683999e-10
+ 7.1434721779929777e-05 2.3997592655072043e-10
+ 7.1442497256254508e-05 2.4000749931504923e-10
+ 7.1450272732579253e-05 2.4001269631983051e-10
+ 7.1458048208903997e-05 2.3999782508278659e-10
+ 7.1467983441936067e-05 2.3999355892689472e-10
+ 7.147791867496815e-05 2.4000179472492324e-10
+ 7.1490125706218148e-05 2.4000339716614338e-10
+ 7.1502332737468147e-05 2.3999888202599127e-10
+ 7.1514539768718146e-05 2.3999830525938688e-10
+ 7.1526746799968144e-05 2.4000037974237526e-10
+ 7.1538953831218143e-05 2.4000087414852165e-10
+ 7.1551160862468142e-05 2.3999993966201389e-10
+ 7.156336789371814e-05 2.3999960494882817e-10
+ 7.1575574924968139e-05 2.4000001432309894e-10
+ 7.1587781956218151e-05 2.4000021737723387e-10
+ 7.159998898746815e-05 2.4000004462513988e-10
+ 7.1612196018718148e-05 2.3999993006727966e-10
+ 7.1624403049968147e-05 2.3999999917748096e-10
+ 7.1636610081218146e-05 2.4000006049017395e-10
+ 7.1648817112468144e-05 2.4000003421757239e-10
+ 7.1661024143718143e-05 2.4000000237870328e-10
+ 7.1673231174968142e-05 2.4000001256652595e-10
+ 7.168543820621814e-05 2.4000002745854788e-10
+ 7.1697645237468139e-05 2.4000002475271839e-10
+ 7.1709852268718151e-05 2.4000001795384735e-10
+ 7.172205929996815e-05 2.400000173879749e-10
+ 7.1734266331218148e-05 2.4000002070407596e-10
+ 7.1746473362468147e-05 2.4000002067419452e-10
+ 7.1758680393718146e-05 2.4000001976473751e-10
+ 7.1770887424968144e-05 2.40000019362722e-10
+ 7.1783094456218143e-05 2.4000002028128461e-10
+ 7.1795301487468142e-05 2.4000002060646208e-10
+ 7.180750851871814e-05 2.4000002008287723e-10
+ 7.1819715549968139e-05 2.4000001934276911e-10
+ 7.1831922581218138e-05 2.4000001968966948e-10
+ 7.184412961246815e-05 2.4000002093381111e-10
+ 7.1856336643718149e-05 2.4000001965726013e-10
+ 7.1868543674968147e-05 2.4000001961507071e-10
+ 7.1880750706218146e-05 2.4000002048512451e-10
+ 7.1892957737468145e-05 2.4000001998121006e-10
+ 7.1905164768718143e-05 2.400000199764228e-10
+ 7.1917371799968142e-05 2.4000001998665694e-10
+ 7.1929578831218141e-05 2.4000001988395378e-10
+ 7.1941785862468139e-05 2.4000001969840786e-10
+ 7.1953992893718138e-05 2.4000001962628526e-10
+ 7.1966199924968136e-05 2.4000001985975601e-10
+ 7.1978406956218149e-05 2.4000001994562599e-10
+ 7.1990613987468147e-05 2.4000001873790616e-10
+ 7.2002821018718146e-05 2.400000206888198e-10
+ 7.2015028049968145e-05 2.4000002115772409e-10
+ 7.2027235081218143e-05 2.4000001926167516e-10
+ 7.2039442112468142e-05 2.4000001865095655e-10
+ 7.2051649143718141e-05 2.4000002024868279e-10
+ 7.2063856174968139e-05 2.4000002062807212e-10
+ 7.2076063206218138e-05 2.4000001971246058e-10
+ 7.2088270237468137e-05 2.4000001913611468e-10
+ 7.2100477268718135e-05 2.4000001939609548e-10
+ 7.2112684299968147e-05 2.4000001928925776e-10
+ 7.2124891331218146e-05 2.4000002036211893e-10
+ 7.2137098362468145e-05 2.4000001948566678e-10
+ 7.2149305393718143e-05 2.40000020557049e-10
+ 7.2161512424968142e-05 2.400000203491446e-10
+ 7.2173719456218141e-05 2.4000001961720044e-10
+ 7.2185926487468139e-05 2.400000200808237e-10
+ 7.2198133518718138e-05 2.4000002006495584e-10
+ 7.2210340549968137e-05 2.4000001941755901e-10
+ 7.2222547581218135e-05 2.4000001925514504e-10
+ 7.2234754612468148e-05 2.4000001949494439e-10
+ 7.2246961643718146e-05 2.4000001987457185e-10
+ 7.2259168674968145e-05 2.4000001956535886e-10
+ 7.2271375706218144e-05 2.4000001976899341e-10
+ 7.2283582737468142e-05 2.4000001989767335e-10
+ 7.2295789768718141e-05 2.4000002010421042e-10
+ 7.230799679996814e-05 2.4000002031692612e-10
+ 7.2320203831218138e-05 2.4000001943796074e-10
+ 7.2332410862468137e-05 2.4000001979057998e-10
+ 7.2344617893718135e-05 2.4000001994141042e-10
+ 7.2356824924968134e-05 2.4000001910787902e-10
+ 7.2369031956218146e-05 2.4000002014157438e-10
+ 7.2381238987468145e-05 2.4000002007976212e-10
+ 7.2393446018718144e-05 2.4000001897875313e-10
+ 7.2405653049968142e-05 2.4000002030066949e-10
+ 7.2417860081218141e-05 2.4000002070432142e-10
+ 7.243006711246814e-05 2.4000001950520541e-10
+ 7.2442274143718138e-05 2.4000001947980057e-10
+ 7.2454481174968137e-05 2.4000002027253361e-10
+ 7.2466688206218136e-05 2.40000020609859e-10
+ 7.2478895237468134e-05 2.4000001911322354e-10
+ 7.2491102268718146e-05 2.4000001969739074e-10
+ 7.2503309299968145e-05 2.4000002073053612e-10
+ 7.2515516331218144e-05 2.4000001994814067e-10
+ 7.2527723362468142e-05 2.4000001923239209e-10
+ 7.2539930393718141e-05 2.4000002015288261e-10
+ 7.255213742496814e-05 2.4000001930210656e-10
+ 7.2564344456218138e-05 2.4000001837686493e-10
+ 7.2576551487468137e-05 2.4000001946449939e-10
+ 7.2588758518718136e-05 2.4000002038326192e-10
+ 7.2600965549968134e-05 2.400000203109469e-10
+ 7.2613172581218147e-05 2.400000203952259e-10
+ 7.2625379612468145e-05 2.4000001970496741e-10
+ 7.2637586643718144e-05 2.4000001924454606e-10
+ 7.2649793674968143e-05 2.4000001905466872e-10
+ 7.2662000706218141e-05 2.400000204518705e-10
+ 7.267420773746814e-05 2.4000002011557764e-10
+ 7.2686414768718138e-05 2.4000001946831419e-10
+ 7.2698621799968137e-05 2.4000001925940771e-10
+ 7.2710828831218149e-05 2.4000001980987061e-10
+ 7.2723035862468148e-05 2.4000002089319245e-10
+ 7.2735242893718147e-05 2.4000001973823067e-10
+ 7.2747449924968145e-05 2.4000001879346328e-10
+ 7.2759656956218144e-05 2.4000001869932423e-10
+ 7.2771863987468143e-05 2.4000002074828773e-10
+ 7.2784071018718141e-05 2.4000001934026167e-10
+ 7.279627804996814e-05 2.4000001952115826e-10
+ 7.2808485081218152e-05 2.4000001987859593e-10
+ 7.2820692112468151e-05 2.400000198982881e-10
+ 7.2832899143718149e-05 2.40000018977687e-10
+ 7.2845106174968148e-05 2.4000001970468766e-10
+ 7.2857313206218147e-05 2.4000001969944985e-10
+ 7.2869520237468145e-05 2.4000002027367879e-10
+ 7.2881727268718144e-05 2.4000001840031488e-10
+ 7.2893934299968143e-05 2.4000001957318321e-10
+ 7.2906141331218155e-05 2.400000188108562e-10
+ 7.2918348362468154e-05 2.4000002046679305e-10
+ 7.2930555393718152e-05 2.4000001950571268e-10
+ 7.2942762424968151e-05 2.4000001838116472e-10
+ 7.295496945621815e-05 2.4000001853089837e-10
+ 7.2967176487468148e-05 2.4000002004811227e-10
+ 7.2979383518718147e-05 2.4000001966057371e-10
+ 7.2991590549968146e-05 2.4000001941089245e-10
+ 7.3003797581218158e-05 2.4000001913185568e-10
+ 7.3016004612468156e-05 2.4000001954838558e-10
+ 7.3028211643718155e-05 2.4000001920964592e-10
+ 7.3040418674968154e-05 2.4000001943469307e-10
+ 7.3052625706218152e-05 2.4000001866641258e-10
+ 7.3064832737468151e-05 2.4000002020897109e-10
+ 7.307703976871815e-05 2.4000001940179987e-10
+ 7.3089246799968148e-05 2.4000001993507329e-10
+ 7.3101453831218161e-05 2.4000002008198123e-10
+ 7.3113660862468159e-05 2.400000198005213e-10
+ 7.3125867893718158e-05 2.4000001916301211e-10
+ 7.3138074924968157e-05 2.4000001960280073e-10
+ 7.3150281956218155e-05 2.4000001963117276e-10
+ 7.3162488987468154e-05 2.400000196254434e-10
+ 7.3174696018718152e-05 2.4000002030623543e-10
+ 7.3186903049968151e-05 2.4000001985486468e-10
+ 7.3199110081218163e-05 2.4000001975560508e-10
+ 7.3211317112468162e-05 2.4000002002563028e-10
+ 7.3223524143718161e-05 2.4000001880683233e-10
+ 7.3235731174968159e-05 2.400000186107882e-10
+ 7.3247938206218158e-05 2.4000002026174485e-10
+ 7.3260145237468157e-05 2.4000001964579944e-10
+ 7.3272352268718155e-05 2.4000001869414737e-10
+ 7.3284559299968154e-05 2.4000002024855297e-10
+ 7.3296766331218166e-05 2.4000001886895933e-10
+ 7.3308973362468165e-05 2.4000001996539064e-10
+ 7.3321180393718163e-05 2.4000001852201533e-10
+ 7.3333387424968162e-05 2.4000001995376353e-10
+ 7.3345594456218161e-05 2.4000001885033681e-10
+ 7.3357801487468159e-05 2.400000202275795e-10
+ 7.3370008518718158e-05 2.4000001938682899e-10
+ 7.3382215549968157e-05 2.400000185286626e-10
+ 7.3394422581218169e-05 2.4000002021567022e-10
+ 7.3406629612468168e-05 2.4000001929093104e-10
+ 7.3418836643718166e-05 2.4000001945502139e-10
+ 7.3431043674968165e-05 2.4000001849176264e-10
+ 7.3443250706218164e-05 2.4000001899160695e-10
+ 7.3455457737468162e-05 2.4000001908469775e-10
+ 7.3467664768718161e-05 2.4000002021320925e-10
+ 7.347987179996816e-05 2.4000001986077044e-10
+ 7.3492078831218172e-05 2.4000001985660228e-10
+ 7.350428586246817e-05 2.4000001982734366e-10
+ 7.3516492893718169e-05 2.4000001909394165e-10
+ 7.3528699924968168e-05 2.4000001971428865e-10
+ 7.3540906956218166e-05 2.4000001921042243e-10
+ 7.3553113987468165e-05 2.400000190589926e-10
+ 7.3565321018718164e-05 2.400000192770844e-10
+ 7.3577528049968162e-05 2.4000001876027354e-10
+ 7.3589735081218175e-05 2.4000001963225885e-10
+ 7.3601942112468173e-05 2.4000001898595255e-10
+ 7.3614149143718172e-05 2.4000001876650681e-10
+ 7.362635617496817e-05 2.4000001955479303e-10
+ 7.3638563206218169e-05 2.400000192149284e-10
+ 7.3650770237468168e-05 2.4000001962818762e-10
+ 7.3662977268718166e-05 2.400000192259498e-10
+ 7.3675184299968165e-05 2.4000001958046752e-10
+ 7.3687391331218177e-05 2.4000001876653049e-10
+ 7.3699598362468176e-05 2.4000001901679062e-10
+ 7.3711805393718175e-05 2.4000001929188411e-10
+ 7.3724012424968173e-05 2.4000001878460593e-10
+ 7.3736219456218172e-05 2.4000001895149019e-10
+ 7.3748426487468171e-05 2.4000001953324466e-10
+ 7.3760633518718169e-05 2.4000001930179932e-10
+ 7.3772840549968168e-05 2.4000001867284628e-10
+ 7.378504758121818e-05 2.4000001876404646e-10
+ 7.3797254612468179e-05 2.4000001844012502e-10
+ 7.3809461643718177e-05 2.4000001847700822e-10
+ 7.3821668674968176e-05 2.4000001848915366e-10
+ 7.3833875706218175e-05 2.4000001847211049e-10
+ 7.3846082737468173e-05 2.4000001842583542e-10
+ 7.3858289768718172e-05 2.4000001874485954e-10
+ 7.3870496799968171e-05 2.4000001864470591e-10
+ 7.3882703831218183e-05 2.400000192645186e-10
+ 7.3894910862468182e-05 2.4000001911011029e-10
+ 7.390711789371818e-05 2.400000189594016e-10
+ 7.3919324924968179e-05 2.4000001834385696e-10
+ 7.3931531956218178e-05 2.4000001923683012e-10
+ 7.3943738987468176e-05 2.4000002008098464e-10
+ 7.3955946018718175e-05 2.400000183211859e-10
+ 7.3968153049968174e-05 2.4000001983070817e-10
+ 7.3980360081218186e-05 2.4000001841550595e-10
+ 7.3992567112468184e-05 2.4000001987140726e-10
+ 7.4004774143718183e-05 2.4000001839799459e-10
+ 7.4016981174968182e-05 2.4000001979564812e-10
+ 7.402918820621818e-05 2.4000001826400317e-10
+ 7.4041395237468179e-05 2.3996544537098469e-10
+ 7.4053602268718178e-05 2.3996256464191007e-10
+ 7.4065809299968176e-05 2.3996062147298765e-10
+ 7.4078016331218189e-05 2.399538992151035e-10
+ 7.4090223362468187e-05 2.3990864356794482e-10
+ 7.4102430393718186e-05 2.3980391697569448e-10
+ 7.4114637424968184e-05 2.3960325885649169e-10
+ 7.4120740940593184e-05 2.3930636780140344e-10
+ 7.4126844456218183e-05 2.3825018349924986e-10
+ 7.412989621403069e-05 2.3664385617022961e-10
+ 7.4132947971843182e-05 2.313460144418538e-10
+ 7.4134473850749429e-05 2.2273712950258841e-10
+ 7.4135999729655689e-05 1.9502932447418286e-10
+ 7.4136991106889196e-05 1.3263414891107653e-10
+ 7.4137269733896242e-05 9.5672269136980181e-11
+ 7.4137548360903301e-05 4.6113023016783446e-11
+ 7.4138098835627969e-05 4.077304569289076e-11
+ 7.4140875273912436e-05 4.2347131994264368e-11
+ 7.4153082305162434e-05 4.4733371018365243e-11
+ 7.4165289336412446e-05 5.3058719093237963e-11
+ 7.4177496367662445e-05 6.5249849962529414e-11
+ 7.4189703398912444e-05 8.0586557341896391e-11
+ 7.4201910430162442e-05 9.8186059694000248e-11
+ 7.4214117461412441e-05 1.1703587328666208e-10
+ 7.422632449266244e-05 1.3605185310399104e-10
+ 7.4238531523912438e-05 1.5414054504639482e-10
+ 7.4250738555162437e-05 1.7026206156240515e-10
+ 7.4262945586412436e-05 1.8348986297121229e-10
+ 7.4275152617662448e-05 1.9306400774952091e-10
+ 7.4287359648912447e-05 1.9843481134517081e-10
+ 7.4299566680162445e-05 1.9929440536940058e-10
+ 7.4311773711412444e-05 1.9559438520732841e-10
+ 7.4323980742662442e-05 1.8754853451668201e-10
+ 7.4336187773912441e-05 1.7562047328816539e-10
+ 7.434839480516244e-05 1.6049694315998822e-10
+ 7.4360601836412452e-05 1.4304826930135124e-10
+ 7.4372808867662451e-05 1.2427827523140709e-10
+ 7.4385015898912449e-05 1.052665328361379e-10
+ 7.4397222930162448e-05 8.7106269937226752e-11
+ 7.4409429961412447e-05 7.0841506734532094e-11
+ 7.4421636992662445e-05 5.7407035899497847e-11
+ 7.4433844023912444e-05 4.7574696846103914e-11
+ 7.443689578172495e-05 4.5750674856066197e-11
+ 7.443704836961557e-05 4.5666462612461995e-11
+ 7.4437429839342131e-05 4.5458870923120094e-11
+ 7.4437467986314786e-05 4.5438342991126504e-11
+ 7.4437475615709325e-05 4.5434242455099145e-11
+ 7.443749087449839e-05 4.5426046434154427e-11
+ 7.4437496978014005e-05 4.5422769911655126e-11
+ 7.4437499419420267e-05 4.542145960441293e-11
+ 7.4437499604455793e-05 4.5421360302533612e-11
+ 7.4437499974526846e-05 4.5421161701746532e-11
+ 7.4437500714668952e-05 5.7234708751505077e-08
+ 7.4437501454811057e-05 2.3609835104101694e-07
+ 7.4437508856232154e-05 8.3378657603255145e-06
+ 7.4437516257653237e-05 2.6804211983519737e-05
+ 7.4437523659074334e-05 5.4212572160978158e-05
+ 7.4437531060495417e-05 8.9333429400249197e-05
+ 7.4437538461916513e-05 0.00013110387761772142
+ 7.443754751235569e-05 0.00018988604042548046
+ 7.4437556562794867e-05 0.000255812068272275
+ 7.4437565613234057e-05 0.00032768193023753725
+ 7.4437574663673234e-05 0.00040448949601993325
+ 7.4437583714112411e-05 0.00048539058840956265
+ 7.4437595044533509e-05 0.00059137048504824714
+ 7.4437606374954608e-05 0.00070151686849491022
+ 7.4437617705375706e-05 0.0008149054011463608
+ 7.4437629035796805e-05 0.00093078918228233572
+ 7.4437643214653366e-05 0.0010784080416500865
+ 7.4437657393509914e-05 0.0012280520970111633
+ 7.4437671572366476e-05 0.0013789889014004875
+ 7.4437689032396941e-05 0.0015657925325384681
+ 7.4437706492427405e-05 0.0017528666320927736
+ 7.443772395245787e-05 0.0019395804048633696
+ 7.4437746268477833e-05 0.0021769293571718938
+ 7.4437768584497809e-05 0.0024120996791847497
+ 7.4437790900517772e-05 0.0026444704336099976
+ 7.4437819090217248e-05 0.0029332237971511233
+ 7.4437847279916711e-05 0.0032158629328255771
+ 7.4437875469616187e-05 0.0034916668520790159
+ 7.4437903659315649e-05 0.0037599988278231356
+ 7.4437931849015125e-05 0.0040202830355208904
+ 7.4437960038714601e-05 0.0042719918874605982
+ 7.4437988228414064e-05 0.0045146394015623476
+ 7.4438019414106479e-05 0.0047719795450323309
+ 7.4438050599798881e-05 0.0050171295125712645
+ 7.4438081785491297e-05 0.0052495906087394869
+ 7.4438112971183712e-05 0.0054689190353913904
+ 7.4438150418414345e-05 0.0057143885297757718
+ 7.4438187865644964e-05 0.0059397992525804574
+ 7.4438225312875597e-05 0.006144702220679193
+ 7.4438270844195807e-05 0.0063657430322260553
+ 7.443831637551603e-05 0.0065556175023236875
+ 7.443836190683624e-05 0.0067142112673811444
+ 7.443840743815645e-05 0.0068416534980290083
+ 7.4438441084028115e-05 0.0069160175765833089
+ 7.4438474729899781e-05 0.0069737900261410465
+ 7.4438508375771446e-05 0.0070152594941248576
+ 7.4438542021643112e-05 0.0070407746969006688
+ 7.4438575667514777e-05 0.007050740823760393
+ 7.4438609313386443e-05 0.0070456156939712805
+ 7.4438642959258108e-05 0.007025905702338452
+ 7.4438676605129774e-05 0.0069921615895264296
+ 7.4438710251001439e-05 0.0069449740739896257
+ 7.4438736870668156e-05 0.006898526876910809
+ 7.4438763490334859e-05 0.0068443802044164921
+ 7.4438790110001576e-05 0.0067828688534493494
+ 7.4438816729668279e-05 0.0067143369242957376
+ 7.4438843349334996e-05 0.0066391364097472113
+ 7.4438869969001699e-05 0.0065576257964309343
+ 7.4438896588668415e-05 0.0064701686843428533
+ 7.4438923208335132e-05 0.0063771324303375145
+ 7.4438949828001835e-05 0.0062788868210215225
+ 7.4438976447668552e-05 0.0061758027801676225
+ 7.4439003067335255e-05 0.0060682511154162089
+ 7.4439029687001972e-05 0.0059566013086644297
+ 7.4439056306668675e-05 0.0058412203541628417
+ 7.4439082926335391e-05 0.0057224716479485063
+ 7.4439109546002095e-05 0.0056007139318451742
+ 7.4439136165668811e-05 0.0054763002948580381
+ 7.4439162785335528e-05 0.0053495772343856614
+ 7.4439189405002231e-05 0.0052208837792675896
+ 7.4439216024668948e-05 0.0050905506764474901
+ 7.4439239404935231e-05 0.0049749804171373225
+ 7.4439262785201514e-05 0.0048586054363550972
+ 7.4439286165467811e-05 0.0047416314482211135
+ 7.4439309545734094e-05 0.0046242577652878883
+ 7.443933292600039e-05 0.0045066770343838705
+ 7.4439356306266674e-05 0.0043890750025309139
+ 7.4439379686532957e-05 0.0042716303126259531
+ 7.4439403066799253e-05 0.0041545143284691553
+ 7.4439426447065537e-05 0.0040378909886185305
+ 7.443944982733182e-05 0.0039219166884552218
+ 7.4439473207598116e-05 0.0038067401897542695
+ 7.4439496587864399e-05 0.0036925025569730643
+ 7.4439519968130696e-05 0.0035793371193940525
+ 7.4439543348396979e-05 0.0034673694581895016
+ 7.4439566728663262e-05 0.0033567174174145066
+ 7.4439590108929559e-05 0.0032474911378798247
+ 7.4439613489195842e-05 0.0031397931128086067
+ 7.4439636869462125e-05 0.0030337182641405314
+ 7.4439660249728422e-05 0.0029293540383132049
+ 7.4439683629994705e-05 0.0028267805203238136
+ 7.4439707010261002e-05 0.0027260705648536779
+ 7.4439735591237522e-05 0.0026055855381113117
+ 7.4439764172214043e-05 0.0024880893416989024
+ 7.4439792753190563e-05 0.0023736731389782805
+ 7.4439821334167097e-05 0.0022624136400195647
+ 7.4439849915143618e-05 0.0021543736566158275
+ 7.4439886199806216e-05 0.0020219271947776738
+ 7.4439925453373382e-05 0.0018846580284455387
+ 7.4439946977215268e-05 0.0018120618774395494
+ 7.4439973696714698e-05 0.0017245821083065652
+ 7.444000041621414e-05 0.0016400258203643724
+ 7.444002713571357e-05 0.0015583844444338579
+ 7.4440053855213013e-05 0.0014796423351417674
+ 7.4440080574712442e-05 0.0014037772468436488
+ 7.4440107294211885e-05 0.0013307608065583204
+ 7.4440134013711314e-05 0.0012605589819463642
+ 7.4440160733210757e-05 0.0011931325425094006
+ 7.4440187452710186e-05 0.0011284375123336611
+ 7.4440214172209629e-05 0.0010664256128491564
+ 7.4440240891709058e-05 0.0010070446942234952
+ 7.4440262548859619e-05 0.00096080661895637035
+ 7.4440284206010165e-05 0.0009162294538821239
+ 7.4440305863160725e-05 0.00087328092606094238
+ 7.4440327520311272e-05 0.00083192771752318962
+ 7.4440349177461819e-05 0.00079213559354230647
+ 7.4440370834612379e-05 0.00075386952625768001
+ 7.4440392491762926e-05 0.00071709381353394315
+ 7.4440414148913472e-05 0.00068177219296354193
+ 7.4440435806064032e-05 0.00064786795094112185
+ 7.4440457463214579e-05 0.00061534402675914772
+ 7.4440479120365126e-05 0.00058416311167918647
+ 7.4440496765399607e-05 0.00055972551886932095
+ 7.4440514410434075e-05 0.00053613426244406741
+ 7.4440532055468556e-05 0.00051336904748169171
+ 7.4440549700503024e-05 0.00049140960981622914
+ 7.4440567345537506e-05 0.00047023574348777509
+ 7.4440584990571973e-05 0.00044982732676715286
+ 7.4440602635606455e-05 0.00043016434677204047
+ 7.4440620280640923e-05 0.00041122692269401575
+ 7.4440637925675391e-05 0.00039299532765819798
+ 7.4440655570709872e-05 0.00037545000923921415
+ 7.444067321574434e-05 0.00035857160865911174
+ 7.4440690860778821e-05 0.00034234097869457157
+ 7.4440708505813289e-05 0.00032673920032235228
+ 7.444072615084777e-05 0.00031174759813332067
+ 7.4440743795882238e-05 0.00029734775454669758
+ 7.444076144091672e-05 0.00028352152285727745
+ 7.4440779085951187e-05 0.0002702510391493668
+ 7.4440796730985655e-05 0.00025751873311203796
+ 7.4440814376020137e-05 0.00024530733779101174
+ 7.4440832021054605e-05 0.00023359989831307307
+ 7.4440849666089086e-05 0.00022237977961939102
+ 7.4440867311123554e-05 0.00021163067324446447
+ 7.4440884956158035e-05 0.00020133660317765155
+ 7.4440902601192503e-05 0.00019148193084437179
+ 7.4440920246226971e-05 0.00018205135924409671
+ 7.4440937891261452e-05 0.00017302993628217709
+ 7.444095553629592e-05 0.00016440305733239472
+ 7.4440973181330401e-05 0.00015615646706688136
+ 7.4440990826364869e-05 0.00014827626058972067
+ 7.4441008471399351e-05 0.00014074888391014853
+ 7.4441026116433819e-05 0.00013356113379079491
+ 7.4441043761468286e-05 0.00012670015700587552
+ 7.4441061406502768e-05 0.00012015344904364461
+ 7.4441079051537236e-05 0.00011390885228677083
+ 7.4441096696571717e-05 0.00010795455370359766
+ 7.4441114341606185e-05 0.00010227908208250491
+ 7.4441131986640666e-05 9.687130484080241e-05
+ 7.4441149631675134e-05 9.1720424438765868e-05
+ 7.4441167276709615e-05 8.6815974428572379e-05
+ 7.4441184921744083e-05 8.2147815167013072e-05
+ 7.4441202566778551e-05 7.7706129219957601e-05
+ 7.4441220211813033e-05 7.3481416485622882e-05
+ 7.44412378568475e-05 6.9464489062760908e-05
+ 7.4441255501881982e-05 6.5646465888930612e-05
+ 7.444127314691645e-05 6.2018767173060703e-05
+ 7.4441290791950931e-05 5.8573108645546759e-05
+ 7.4441308436985399e-05 5.5301495648160228e-05
+ 7.444132608201988e-05 5.2196217085081444e-05
+ 7.4441343727054348e-05 4.9249839255407143e-05
+ 7.4441361372088816e-05 4.6455199586526805e-05
+ 7.4441379017123297e-05 4.3805400286814076e-05
+ 7.4441396662157765e-05 4.1293801935142287e-05
+ 7.4441414307192246e-05 3.8914017023807698e-05
+ 7.4441431952226714e-05 3.6659903470533496e-05
+ 7.4441449597261196e-05 3.4525558114332587e-05
+ 7.4441467242295664e-05 3.2505310209129923e-05
+ 7.4441484887330131e-05 3.0593714928186798e-05
+ 7.4441502532364613e-05 2.878554689153125e-05
+ 7.4441520177399081e-05 2.7075793727781893e-05
+ 7.4441537822433562e-05 2.5459649680957857e-05
+ 7.444155546746803e-05 2.3932509272096093e-05
+ 7.4441573112502511e-05 2.2489961024749567e-05
+ 7.4441590757536979e-05 2.1127781262716843e-05
+ 7.4441608402571447e-05 1.9841927987655173e-05
+ 7.4441626047605928e-05 1.8628534843556469e-05
+ 7.4441643692640396e-05 1.7483905174418017e-05
+ 7.4441661337674878e-05 1.6404506180818473e-05
+ 7.4441682620107576e-05 1.5184596516820046e-05
+ 7.4441702745281686e-05 1.4108722156777394e-05
+ 7.4441722870455783e-05 1.3103783271809466e-05
+ 7.4441742995629893e-05 1.2165512099818384e-05
+ 7.444176312080399e-05 1.1289867233639744e-05
+ 7.4441783245978086e-05 1.0473023791237365e-05
+ 7.4441803371152196e-05 9.711363860421274e-06
+ 7.4441823496326293e-05 9.0014672215583367e-06
+ 7.4441843621500403e-05 8.3401023506671107e-06
+ 7.44418637466745e-05 7.7242177042852387e-06
+ 7.4441888110746133e-05 7.0353574872189284e-06
+ 7.4441912474817752e-05 6.4041509733236313e-06
+ 7.4441936838889384e-05 5.8261375978047346e-06
+ 7.4441961202961017e-05 5.2971679183216326e-06
+ 7.4441985567032636e-05 4.8133849648221628e-06
+ 7.4442009931104268e-05 4.3712064413582404e-06
+ 7.4442034295175901e-05 3.9673077642003495e-06
+ 7.444205865924752e-05 3.5986059186122073e-06
+ 7.4442083023319153e-05 3.2622441148827113e-06
+ 7.4442107387390772e-05 2.955577222710442e-06
+ 7.4442136719683578e-05 2.6223173518557521e-06
+ 7.4442166051976371e-05 2.3246430183300364e-06
+ 7.4442195384269165e-05 2.0589938235170389e-06
+ 7.4442224716561958e-05 1.8221375097881734e-06
+ 7.4442254048854751e-05 1.6111428978970881e-06
+ 7.4442283381147544e-05 1.4233547079677823e-06
+ 7.4442312713440337e-05 1.2563701699769522e-06
+ 7.444234204573313e-05 1.1080173307665688e-06
+ 7.4442377848029195e-05 9.4935328593955194e-07
+ 7.4442412335454629e-05 8.1703614317247063e-07
+ 7.4442446822880063e-05 7.0231034037170861e-07
+ 7.4442481310305498e-05 6.0295931014601184e-07
+ 7.4442515797730932e-05 5.1702814794412422e-07
+ 7.4442557828321217e-05 4.2796498791424164e-07
+ 7.4442599858911488e-05 3.5358466304975593e-07
+ 7.4442641889501773e-05 2.9157919961691281e-07
+ 7.4442683920092044e-05 2.3998333476715486e-07
+ 7.4442725950682329e-05 1.9712710629082681e-07
+ 7.4442777518503428e-05 1.5442331314774624e-07
+ 7.444282818666648e-05 1.2110746118199679e-07
+ 7.4442878854829545e-05 9.4668212428266369e-08
+ 7.4442929522992597e-05 7.3741045625230226e-08
+ 7.4442993215143461e-05 5.3572482382509411e-08
+ 7.4443056907294325e-05 3.8650410566722333e-08
+ 7.444312059944519e-05 2.7655607125139506e-08
+ 7.4443198945610723e-05 1.80624388894615e-08
+ 7.4443278657649695e-05 1.1455385675920075e-08
+ 7.4443358369688666e-05 7.0279116712338033e-09
+ 7.4443461292370762e-05 3.42722610432318e-09
+ 7.4443569508909817e-05 1.2415251844169095e-09
+ 7.4443701914804443e-05 -1.7423168879043324e-10
+ 7.4443847065030184e-05 -9.0046498724308251e-10
+ 7.4444034315235692e-05 -1.2675598336250834e-09
+ 7.4444255865010434e-05 -1.390661486095478e-09
+ 7.444455403409251e-05 -1.4079464626524889e-09
+ 7.4444998769870893e-05 -1.3781166774969621e-09
+ 7.4445805003989002e-05 -1.313948994893242e-09
+ 7.4446711764368322e-05 -1.2450592154006523e-09
+ 7.4447737475686449e-05 -1.1711746826522686e-09
+ 7.444880114340234e-05 -1.0985374417948889e-09
+ 7.4449944764949546e-05 -1.0244977902794022e-09
+ 7.4452231646278912e-05 -8.876839903243166e-10
+ 7.445418268121666e-05 -7.8153991862173163e-10
+ 7.4456291228517247e-05 -6.7660226349856925e-10
+ 7.4458581467436169e-05 -5.7299433820914436e-10
+ 7.4460926666850027e-05 -4.7698621811411996e-10
+ 7.4463271866263885e-05 -3.901690868650475e-10
+ 7.4465590537179635e-05 -3.1248869476676087e-10
+ 7.4468474569484288e-05 -2.2600941125466692e-10
+ 7.4471358601788928e-05 -1.4953972152878652e-10
+ 7.4474242634093581e-05 -8.1909642546355165e-11
+ 7.4477126666398235e-05 -2.2097231394821104e-11
+ 7.4480010698702874e-05 3.0804763949844941e-11
+ 7.4482894731007528e-05 7.7599184420572088e-11
+ 7.4485778763312181e-05 1.1899177680085989e-10
+ 7.4489342797663598e-05 1.6360497315690482e-10
+ 7.4492906832015015e-05 2.0194460469335925e-10
+ 7.4496470866366432e-05 2.3489304324568193e-10
+ 7.4500034900717863e-05 2.6320792465228799e-10
+ 7.450359893506928e-05 2.8754418863776942e-10
+ 7.4507899961127359e-05 3.124003450031708e-10
+ 7.4512200987185453e-05 3.3310188136055884e-10
+ 7.4516502013243546e-05 3.5034335018174361e-10
+ 7.4520803039301625e-05 3.6470346013268147e-10
+ 7.4525104065359719e-05 3.7666442373221598e-10
+ 7.4530502505986982e-05 3.8888313831481749e-10
+ 7.4535900946614246e-05 3.9859542479219459e-10
+ 7.4541299387241523e-05 4.0629545583254085e-10
+ 7.4546697827868787e-05 4.1242659596079512e-10
+ 7.4553468247657475e-05 4.1836450212166619e-10
+ 7.4560238667446162e-05 4.228142873871682e-10
+ 7.456700908723485e-05 4.2614500842071573e-10
+ 7.4575385304343956e-05 4.2912633403108892e-10
+ 7.4583761521453075e-05 4.3120345772378355e-10
+ 7.4592137738562181e-05 4.3264838822889765e-10
+ 7.460304338548866e-05 4.3388610175178318e-10
+ 7.4613949032415139e-05 4.3464666000495187e-10
+ 7.4626156063665138e-05 4.3514763453961883e-10
+ 7.4638363094915136e-05 4.3542384097085643e-10
+ 7.4650570126165135e-05 4.3556624282357159e-10
+ 7.4662777157415134e-05 4.3562884855868211e-10
+ 7.4674984188665132e-05 4.3564390919099658e-10
+ 7.4687191219915131e-05 4.3563071731303817e-10
+ 7.469939825116513e-05 4.3560072832369711e-10
+ 7.4711605282415142e-05 4.3556071800624522e-10
+ 7.4723812313665141e-05 4.3551473285478916e-10
+ 7.4736019344915139e-05 4.3546520640556509e-10
+ 7.4748226376165138e-05 4.3541358487496968e-10
+ 7.4760433407415137e-05 4.3536071753580087e-10
+ 7.4772640438665135e-05 4.353071102954193e-10
+ 7.4784847469915134e-05 4.3525307030070124e-10
+ 7.4797054501165146e-05 4.3519878102624261e-10
+ 7.4809261532415145e-05 4.3514434891989702e-10
+ 7.4821468563665143e-05 4.3508983678706616e-10
+ 7.4833675594915142e-05 4.3503528333983576e-10
+ 7.4845882626165141e-05 4.3498071205926307e-10
+ 7.4858089657415139e-05 4.3492613633167183e-10
+ 7.4870296688665138e-05 4.348715638520445e-10
+ 7.4882503719915137e-05 4.3481699946235471e-10
+ 7.4894710751165135e-05 4.3476244620745766e-10
+ 7.4906917782415147e-05 4.3470790578886986e-10
+ 7.4919124813665146e-05 4.3465337912630206e-10
+ 7.4931331844915145e-05 4.3459886680952396e-10
+ 7.4943538876165143e-05 4.3454436923774573e-10
+ 7.4955745907415142e-05 4.3448988663097442e-10
+ 7.4967952938665141e-05 4.3443541909242035e-10
+ 7.4980159969915139e-05 4.3438096668679938e-10
+ 7.4992367001165152e-05 4.3432652946422885e-10
+ 7.5000000000000007e-05 4.3429323819786375e-10
+ 7.5012207031250006e-05 4.3423882549145797e-10
+ 7.5024414062500004e-05 4.3418442800650571e-10
+ 7.5036621093750003e-05 4.3413004574565444e-10
+ 7.5048828125000002e-05 4.3407567870875607e-10
+ 7.506103515625e-05 4.3402132689399754e-10
+ 7.5073242187500012e-05 4.3396699029857563e-10
+ 7.5085449218750011e-05 4.3391266891909689e-10
+ 7.509765625000001e-05 4.338583627518177e-10
+ 7.5109863281250008e-05 4.338040717927861e-10
+ 7.5122070312500007e-05 4.3374979603792648e-10
+ 7.5134277343750006e-05 4.3369553548309005e-10
+ 7.5146484375000004e-05 4.3364129012408513e-10
+ 7.5158691406250003e-05 4.3358705995669485e-10
+ 7.5170898437500002e-05 4.3353284497668784e-10
+ 7.518310546875e-05 4.3347864517982436e-10
+ 7.5195312500000013e-05 4.3342446056186068e-10
+ 7.5207519531250011e-05 4.3337029111855061e-10
+ 7.521972656250001e-05 4.3331613684564742e-10
+ 7.5231933593750009e-05 4.3326199773890431e-10
+ 7.5244140625000007e-05 4.3320787379407488e-10
+ 7.5256347656250006e-05 4.3315376500691365e-10
+ 7.5268554687500005e-05 4.3309967137317592e-10
+ 7.5280761718750003e-05 4.3304559288861817e-10
+ 7.5292968750000002e-05 4.3299152954899793e-10
+ 7.530517578125e-05 4.3293748135007384e-10
+ 7.5317382812500013e-05 4.3288344828760572e-10
+ 7.5329589843750011e-05 4.3282943035735457e-10
+ 7.534179687500001e-05 4.3277542755508266e-10
+ 7.5354003906250009e-05 4.327214398765532e-10
+ 7.5366210937500007e-05 4.3266746731753079e-10
+ 7.5378417968750006e-05 4.3261350987378112e-10
+ 7.5390625000000005e-05 4.3255956754107106e-10
+ 7.5402832031250003e-05 4.3250564031516869e-10
+ 7.5415039062500002e-05 4.324517281918434e-10
+ 7.5427246093750001e-05 4.3239783116686546e-10
+ 7.5439453125000013e-05 4.3234394923600652e-10
+ 7.5451660156250011e-05 4.3229008239503964e-10
+ 7.546386718750001e-05 4.322362306397386e-10
+ 7.5476074218750009e-05 4.3218239396587857e-10
+ 7.5488281250000007e-05 4.3212857236923607e-10
+ 7.5500488281250006e-05 4.3207476584558855e-10
+ 7.5512695312500005e-05 4.3202097439071481e-10
+ 7.5524902343750003e-05 4.3196719800039462e-10
+ 7.5537109375000002e-05 4.3191343667040926e-10
+ 7.5549316406250001e-05 4.3185969039654094e-10
+ 7.5561523437500013e-05 4.3180595917457319e-10
+ 7.5573730468750012e-05 4.3175224300029046e-10
+ 7.558593750000001e-05 4.3169854186947872e-10
+ 7.5598144531250009e-05 4.3164485577792515e-10
+ 7.5610351562500008e-05 4.3159118472141752e-10
+ 7.5622558593750006e-05 4.315375286957455e-10
+ 7.5634765625000005e-05 4.3148388769669956e-10
+ 7.5646972656250003e-05 4.3143026172007142e-10
+ 7.5659179687500002e-05 4.3137665076165393e-10
+ 7.5671386718750001e-05 4.3132305481724119e-10
+ 7.5683593750000013e-05 4.3126947388262849e-10
+ 7.5695800781250012e-05 4.3121590795361226e-10
+ 7.570800781250001e-05 4.3116235702599014e-10
+ 7.5720214843750009e-05 4.311088210955608e-10
+ 7.5732421875000008e-05 4.3105530015812432e-10
+ 7.5744628906250006e-05 4.3100179420948178e-10
+ 7.5756835937500005e-05 4.3094830324543561e-10
+ 7.5769042968750004e-05 4.3089482726178914e-10
+ 7.5781250000000002e-05 4.3084136625434698e-10
+ 7.5793457031250001e-05 4.3078792021891527e-10
+ 7.5805664062500013e-05 4.3073448915130076e-10
+ 7.5817871093750012e-05 4.3068107304731183e-10
+ 7.583007812500001e-05 4.3062767190275767e-10
+ 7.5842285156250009e-05 4.3057428571344897e-10
+ 7.5854492187500008e-05 4.305209144751974e-10
+ 7.5866699218750006e-05 4.3046755818381573e-10
+ 7.5878906250000005e-05 4.3041421683511815e-10
+ 7.5891113281250004e-05 4.3036089042491982e-10
+ 7.5903320312500002e-05 4.3030757894903721e-10
+ 7.5915527343750015e-05 4.3025428240328784e-10
+ 7.5927734375000013e-05 4.3020100078349046e-10
+ 7.5939941406250012e-05 4.3014773408546503e-10
+ 7.5952148437500011e-05 4.3009448230503257e-10
+ 7.5964355468750009e-05 4.3004124543801536e-10
+ 7.5976562500000008e-05 4.2998802348023685e-10
+ 7.5988769531250007e-05 4.2993481642752165e-10
+ 7.6000976562500005e-05 4.298816242756955e-10
+ 7.6013183593750004e-05 4.2982844702058526e-10
+ 7.6025390625000002e-05 4.2977528465801911e-10
+ 7.6037597656250001e-05 4.2972213718382639e-10
+ 7.6049804687500013e-05 4.296690045938374e-10
+ 7.6062011718750012e-05 4.2961588688388387e-10
+ 7.6074218750000011e-05 4.2956278404979846e-10
+ 7.6086425781250009e-05 4.2950969608741529e-10
+ 7.6098632812500008e-05 4.2945662299256918e-10
+ 7.6110839843750007e-05 4.2940356476109669e-10
+ 7.6123046875000005e-05 4.2935052138883517e-10
+ 7.6135253906250004e-05 4.2929749287162315e-10
+ 7.6147460937500003e-05 4.2924447920530045e-10
+ 7.6159667968750001e-05 4.2919148038570803e-10
+ 7.6171875000000013e-05 4.2913849640868801e-10
+ 7.6184082031250012e-05 4.2908552727008359e-10
+ 7.6196289062500011e-05 4.2903257296573924e-10
+ 7.6208496093750009e-05 4.2897963349150058e-10
+ 7.6220703125000008e-05 4.2892670884321429e-10
+ 7.6232910156250007e-05 4.288737990167283e-10
+ 7.6245117187500005e-05 4.2882090400789185e-10
+ 7.6257324218750004e-05 4.2876802381255504e-10
+ 7.6269531250000003e-05 4.2871515842656934e-10
+ 7.6281738281250001e-05 4.2866230784578723e-10
+ 7.62939453125e-05 4.2860947206606246e-10
+ 7.6306152343750012e-05 4.2855665108325002e-10
+ 7.6318359375000011e-05 4.2850384489320595e-10
+ 7.633056640625001e-05 4.2845105349178732e-10
+ 7.6342773437500008e-05 4.2839827687485269e-10
+ 7.6354980468750007e-05 4.2834551503826145e-10
+ 7.6367187500000005e-05 4.2829276797787439e-10
+ 7.6379394531250004e-05 4.2824003568955333e-10
+ 7.6391601562500003e-05 4.2818731816916134e-10
+ 7.6403808593750001e-05 4.2813461541256231e-10
+ 7.6416015625e-05 4.2808192741562203e-10
+ 7.6428222656249999e-05 4.2802925417420679e-10
+ 7.6440429687500011e-05 4.2797659568418397e-10
+ 7.645263671875001e-05 4.2792395194142275e-10
+ 7.6464843750000008e-05 4.2787132294179297e-10
+ 7.6477050781250007e-05 4.2781870868116553e-10
+ 7.6489257812500006e-05 4.2776610915541303e-10
+ 7.6501464843750004e-05 4.2771352436040875e-10
+ 7.6513671875000003e-05 4.2766095429202714e-10
+ 7.6525878906250002e-05 4.2760839894614423e-10
+ 7.65380859375e-05 4.2755585831863669e-10
+ 7.6550292968749999e-05 4.2750333240538267e-10
+ 7.6562499999999998e-05 4.2745082120226136e-10
+ 7.657470703125001e-05 4.2739832470515305e-10
+ 7.6586914062500008e-05 4.273458429099393e-10
+ 7.6599121093750007e-05 4.2729337581250278e-10
+ 7.6611328125000006e-05 4.2724092340872732e-10
+ 7.6623535156250004e-05 4.2718848569449787e-10
+ 7.6635742187500003e-05 4.2713606266570053e-10
+ 7.6647949218750002e-05 4.2708365431822263e-10
+ 7.666015625e-05 4.270312606479525e-10
+ 7.6672363281249999e-05 4.2697888165077988e-10
+ 7.6684570312499998e-05 4.2692651732259529e-10
+ 7.669677734375001e-05 4.2687416765929084e-10
+ 7.6708984375000009e-05 4.2682183265675928e-10
+ 7.6721191406250007e-05 4.2676951231089505e-10
+ 7.6733398437500006e-05 4.2671720661759342e-10
+ 7.6745605468750004e-05 4.2666491557275079e-10
+ 7.6757812500000003e-05 4.2661263917226478e-10
+ 7.6770019531250002e-05 4.265603774120343e-10
+ 7.67822265625e-05 4.265081302879591e-10
+ 7.6794433593749999e-05 4.2645589779594043e-10
+ 7.6806640624999998e-05 4.2640367993188038e-10
+ 7.6818847656249996e-05 4.2635147669168246e-10
+ 7.6831054687500009e-05 4.2629928807125108e-10
+ 7.6843261718750007e-05 4.2624711406649186e-10
+ 7.6855468750000006e-05 4.2619495467331169e-10
+ 7.6867675781250005e-05 4.2614280988761856e-10
+ 7.6879882812500003e-05 4.2609067970532156e-10
+ 7.6892089843750002e-05 4.2603856412233079e-10
+ 7.6904296875000001e-05 4.2598646313455786e-10
+ 7.6916503906249999e-05 4.2593437673791515e-10
+ 7.6928710937499998e-05 4.2588230492831644e-10
+ 7.6940917968749997e-05 4.2583024770167654e-10
+ 7.6953125000000009e-05 4.2577820505391141e-10
+ 7.6965332031250007e-05 4.2572617698093814e-10
+ 7.6977539062500006e-05 4.2567416347867499e-10
+ 7.6989746093750005e-05 4.2562216454304139e-10
+ 7.7001953125000003e-05 4.2557018016995789e-10
+ 7.7014160156250002e-05 4.2551821035534623e-10
+ 7.7026367187500001e-05 4.2546625509512913e-10
+ 7.7038574218749999e-05 4.254143143852306e-10
+ 7.7050781249999998e-05 4.2536238822157581e-10
+ 7.7062988281249997e-05 4.2531047660009089e-10
+ 7.7075195312499995e-05 4.2525857951670346e-10
+ 7.7087402343750007e-05 4.252066969673418e-10
+ 7.7099609375000006e-05 4.2515482894793579e-10
+ 7.7111816406250005e-05 4.2510297545441604e-10
+ 7.7124023437500003e-05 4.2505113648271467e-10
+ 7.7136230468750002e-05 4.2499931202876474e-10
+ 7.7148437500000001e-05 4.2494750208850055e-10
+ 7.7160644531249999e-05 4.248957066578573e-10
+ 7.7172851562499998e-05 4.2482519493572964e-10
+ 7.7185058593749997e-05 4.2475256100502045e-10
+ 7.7197265624999995e-05 4.2468173951608737e-10
+ 7.7209472656249994e-05 4.2459666096075283e-10
+ 7.7221679687500006e-05 4.2448010616874532e-10
+ 7.7233886718750005e-05 4.242745676347303e-10
+ 7.7239990234375004e-05 4.2406762246865748e-10
+ 7.7246093750000004e-05 4.2364446431160585e-10
+ 7.7249145507812496e-05 4.2320637096990359e-10
+ 7.7252197265625003e-05 4.2237081875579266e-10
+ 7.7255249023437496e-05 4.2039912634768696e-10
+ 7.7256606790774088e-05 4.184858057925494e-10
+ 7.7256998216660867e-05 4.1769354662518729e-10
+ 7.7257389642547647e-05 4.1673967866159501e-10
+ 7.7258368207264576e-05 4.1328644574257995e-10
+ 7.7259409502908186e-05 4.0647792025774505e-10
+ 7.7259970598735322e-05 4.0009399586852752e-10
+ 7.7260339629298374e-05 3.9400830485401903e-10
+ 7.7261110323815843e-05 3.7217296598144555e-10
+ 7.7261741481233852e-05 3.3482378565862255e-10
+ 7.7262113084009015e-05 2.9476725253157392e-10
+ 7.7262434193795792e-05 2.3913652951300332e-10
+ 7.7262647097925421e-05 2.1273235713088472e-10
+ 7.7262860002055037e-05 2.1207408791108858e-10
+ 7.7264989043351244e-05 2.1185023895337551e-10
+ 7.7277196074601256e-05 2.0757980032582087e-10
+ 7.7289403105851255e-05 1.9827504053149293e-10
+ 7.7301610137101254e-05 1.8447156434439206e-10
+ 7.7313817168351252e-05 1.6696410651490149e-10
+ 7.7326024199601251e-05 1.4676018343964647e-10
+ 7.733823123085125e-05 1.2502212943217047e-10
+ 7.7350438262101248e-05 1.0300022779102304e-10
+ 7.7362645293351247e-05 8.1960799754197404e-11
+ 7.7374852324601246e-05 6.311338755160194e-11
+ 7.7387059355851244e-05 4.7541218733423125e-11
+ 7.7399266387101256e-05 3.6138949326912032e-11
+ 7.7411473418351255e-05 2.9561263935700322e-11
+ 7.7423680449601254e-05 2.8185285811614418e-11
+ 7.7435887480851252e-05 3.2088955187765566e-11
+ 7.7448094512101251e-05 4.1046615499322252e-11
+ 7.746030154335125e-05 5.4542057385810135e-11
+ 7.7472508574601248e-05 7.1798266491615728e-11
+ 7.7484715605851247e-05 9.1822160785597292e-11
+ 7.7496922637101246e-05 1.1346174161334856e-10
+ 7.7509129668351244e-05 1.3547236949090519e-10
+ 7.7521336699601243e-05 1.5658835172212636e-10
+ 7.7533543730851255e-05 1.7559572435646284e-10
+ 7.7545750762101254e-05 1.9140204326212496e-10
+ 7.7557957793351252e-05 2.030991720132836e-10
+ 7.7561009551163745e-05 2.0529687447679853e-10
+ 7.7561314726944997e-05 2.0549982177660819e-10
+ 7.7562077666398121e-05 2.0599366009052315e-10
+ 7.7562459136124682e-05 2.062333046850057e-10
+ 7.75624829779826e-05 2.0624812098499301e-10
+ 7.7562487746354183e-05 2.0625108196291897e-10
+ 7.7562497283097337e-05 2.0625700163649109e-10
+ 7.7562498046036799e-05 2.0625747507891284e-10
+ 7.7562499571915696e-05 2.0625842190532621e-10
+ 7.7562499693986019e-05 2.0625849764807365e-10
+ 7.7562499938126637e-05 2.0625864913207268e-10
+ 7.7562499957657888e-05 2.0625866125070641e-10
+ 7.7562499996720392e-05 2.0625868548793557e-10
+ 7.7562500074845384e-05 8.3574849775232329e-10
+ 7.7562500152970391e-05 2.8382408459534785e-09
+ 7.7562500934220388e-05 9.7910663945931592e-08
+ 7.7562508051845982e-05 6.9281309170090845e-06
+ 7.7562515169471576e-05 2.3496919613390592e-05
+ 7.7562522287097171e-05 4.8515586154137975e-05
+ 7.7562529404722765e-05 8.0864107426474553e-05
+ 7.7562536522348373e-05 0.0001195688537478285
+ 7.7562543639973967e-05 0.00016378325676260678
+ 7.7562550757599561e-05 0.00021277103077073492
+ 7.7562557875225156e-05 0.00026589161027525284
+ 7.756256499285075e-05 0.00032258751106878353
+ 7.7562572110476344e-05 0.00038237336083026571
+ 7.7562579228101938e-05 0.00044482637875059637
+ 7.7562587807568584e-05 0.00052313156179263198
+ 7.7562596387035202e-05 0.00060422377214069478
+ 7.7562604966501848e-05 0.00068763160407692863
+ 7.7562613545968466e-05 0.00077295453496090106
+ 7.7562622125435112e-05 0.00085985181282763258
+ 7.7562630704901731e-05 0.00094803308914625053
+ 7.7562639284368376e-05 0.0010372505228311898
+ 7.7562647863834995e-05 0.0011272921245865509
+ 7.7562658180770262e-05 0.0012364048498757886
+ 7.7562668497705516e-05 0.0013461799437633384
+ 7.7562678814640769e-05 0.0014563930288477433
+ 7.7562689131576023e-05 0.001566855276772596
+ 7.7562699448511277e-05 0.0016774068636345029
+ 7.756270976544653e-05 0.001787911643031166
+ 7.7562720082381784e-05 0.0018982528107135616
+ 7.7562730399317051e-05 0.0020083293767566338
+ 7.756274290201226e-05 0.002141246780886198
+ 7.7562755404707483e-05 0.0022735106700283729
+ 7.7562767907402705e-05 0.0024050029041599369
+ 7.7562780410097928e-05 0.0025356196305195535
+ 7.7562792912793136e-05 0.0026652683340791378
+ 7.7562805415488359e-05 0.002793865545581445
+ 7.7562817918183581e-05 0.0029213350620943554
+ 7.7562830420878804e-05 0.0030476065669750823
+ 7.7562845592253878e-05 0.0031991277392290247
+ 7.7562860763628953e-05 0.0033486794005026179
+ 7.7562875935004042e-05 0.0034961593179601309
+ 7.7562891106379116e-05 0.0036414711081661105
+ 7.7562906277754205e-05 0.0037845233735065873
+ 7.7562921449129279e-05 0.0039252290818992874
+ 7.7562936620504354e-05 0.0040635051254073566
+ 7.7562954860519565e-05 0.0042264209820281088
+ 7.7562973100534776e-05 0.0043855785109888799
+ 7.7562991340549987e-05 0.004540852807539594
+ 7.7563009580565185e-05 0.0046921255232483241
+ 7.7563027820580396e-05 0.004839284756390172
+ 7.7563046060595607e-05 0.0049822250059800644
+ 7.7563068199865856e-05 0.0051499118748984281
+ 7.7563090339136104e-05 0.0053110729761570875
+ 7.7563112478406352e-05 0.0054655577982168782
+ 7.7563134617676601e-05 0.0056132299331846198
+ 7.7563161293011325e-05 0.0057819364493443522
+ 7.7563187873095813e-05 0.0059398423573548687
+ 7.7563214453180301e-05 0.0060874136176253622
+ 7.7563248688484345e-05 0.0062620603819550135
+ 7.756328292378839e-05 0.0064191641307141745
+ 7.7563315356127052e-05 0.0065517091134031152
+ 7.7563347788465713e-05 0.0066683776453289999
+ 7.7563380220804375e-05 0.0067692021882621509
+ 7.756341265314305e-05 0.0068542763543729904
+ 7.7563445085481711e-05 0.0069237529436825757
+ 7.7563477517820373e-05 0.0069778416850672731
+ 7.7563509950159034e-05 0.0070168067033145008
+ 7.7563542382497695e-05 0.0070409637367341727
+ 7.7563569584998147e-05 0.0070500711051410814
+ 7.7563596787498599e-05 0.0070492564131712353
+ 7.7563623989999065e-05 0.0070387804986578604
+ 7.7563651192499516e-05 0.0070189238317284377
+ 7.7563678394999968e-05 0.0069899850256677273
+ 7.756370559750042e-05 0.0069522793135452206
+ 7.7563732800000872e-05 0.0069061369988542495
+ 7.7563760002501324e-05 0.0068519018883273245
+ 7.7563787205001776e-05 0.0067899297149596706
+ 7.7563814407502241e-05 0.0067205865590935169
+ 7.7563841610002693e-05 0.0066442472751925379
+ 7.7563868812503145e-05 0.006561293931672073
+ 7.7563896015003596e-05 0.0064721142708494637
+ 7.7563923217504048e-05 0.0063771001957435066
+ 7.75639504200045e-05 0.0062766462900859356
+ 7.7563977622504952e-05 0.0061711483775146155
+ 7.7564004825005404e-05 0.0060610021255013743
+ 7.7564032027505856e-05 0.0059466016991306979
+ 7.7564059230006321e-05 0.0058283384693926773
+ 7.7564086432506773e-05 0.0057065997804302861
+ 7.756411530088351e-05 0.0055740309990659331
+ 7.7564144169260234e-05 0.0054384272991202893
+ 7.7564173037636972e-05 0.0053002282345430132
+ 7.7564201906013709e-05 0.0051598626838551204
+ 7.7564230774390447e-05 0.0050177476630414884
+ 7.7564259642767184e-05 0.0048742872442221231
+ 7.7564288511143908e-05 0.0047298715812966012
+ 7.7564317379520646e-05 0.0045848760430473451
+ 7.7564346247897383e-05 0.0044396604535071188
+ 7.7564381135166686e-05 0.0042643637747592994
+ 7.7564416022435988e-05 0.0040898203879790361
+ 7.7564449985506056e-05 0.0039211359224094145
+ 7.7564483948576124e-05 0.0037541355090310092
+ 7.7564517911646178e-05 0.0035892460195200843
+ 7.7564551874716246e-05 0.0034268598627977894
+ 7.7564585837786314e-05 0.0032673350066711841
+ 7.7564627381082827e-05 0.0030765664536155394
+ 7.7564668924379339e-05 0.0028910852643209248
+ 7.7564710467675852e-05 0.0027113416169293153
+ 7.7564752010972365e-05 0.0025377141992044784
+ 7.7564802322523108e-05 0.0023360685105670866
+ 7.7564853125173646e-05 0.0021424443576868821
+ 7.7564903927824171e-05 0.001959156496722657
+ 7.7564971607266259e-05 0.0017313192252947558
+ 7.7565039286708334e-05 0.0015222190408349249
+ 7.7565091919396567e-05 0.001372431253814393
+ 7.7565144552084814e-05 0.0012336381966261724
+ 7.756519718477306e-05 0.0011055447342070166
+ 7.7565249817461307e-05 0.00098778684645394604
+ 7.7565297809929109e-05 0.00088906516794052203
+ 7.756534580239691e-05 0.00079823747715313789
+ 7.7565393794864712e-05 0.00071492972227882204
+ 7.7565441787332513e-05 0.00063875107498295779
+ 7.7565489779800315e-05 0.00056929990178360005
+ 7.7565537261554873e-05 0.00050680910974394439
+ 7.7565584743309417e-05 0.00045011010916966049
+ 7.7565632225063961e-05 0.00039881145821643485
+ 7.7565679706818519e-05 0.00035252854906615789
+ 7.7565727188573064e-05 0.00031088653907439246
+ 7.7565774670327621e-05 0.0002735227890958723
+ 7.7565824358583369e-05 0.00023862511600889196
+ 7.7565874046839131e-05 0.00020765025205703798
+ 7.7565923735094879e-05 0.00018023763188315632
+ 7.756597342335064e-05 0.00015604795426756195
+ 7.7566023111606401e-05 0.0001347637411803884
+ 7.7566072799862149e-05 0.00011608953467670693
+ 7.7566127951386081e-05 9.8086983151495662e-05
+ 7.7566183102910013e-05 8.2620379659707852e-05
+ 7.7566238254433932e-05 6.937830638173144e-05
+ 7.7566293405957864e-05 5.8079646203919961e-05
+ 7.7566348557481783e-05 4.8471998343402797e-05
+ 7.7566411640520548e-05 3.9267448447275403e-05
+ 7.75664747235593e-05 3.1683839518460041e-05
+ 7.7566537806598066e-05 2.5463033689023789e-05
+ 7.7566600889636818e-05 2.0382309617297274e-05
+ 7.7566674140146425e-05 1.5662206653736814e-05
+ 7.7566747390656046e-05 1.1971024407425274e-05
+ 7.7566820641165654e-05 9.101093726216712e-06
+ 7.7566905619421586e-05 6.5781195004269459e-06
+ 7.7566990597677531e-05 4.7207090840830405e-06
+ 7.7567093836844786e-05 3.1245246960755978e-06
+ 7.7567198171769425e-05 2.0371887602864823e-06
+ 7.7567302506694049e-05 1.3141391771344707e-06
+ 7.7567426664469175e-05 7.6923430377838728e-07
+ 7.7567550822244287e-05 4.435788450454647e-07
+ 7.7567705800806537e-05 2.1851475951109054e-07
+ 7.756788493713179e-05 9.3708673373505121e-08
+ 7.75680985566024e-05 3.2883700516734768e-08
+ 7.7568364485722962e-05 8.5309004428172277e-09
+ 7.7568717982712211e-05 1.4552417250701691e-09
+ 7.7569242097564153e-05 3.0578689270965244e-10
+ 7.7570136340120486e-05 2.4569663308855879e-10
+ 7.7572132807185044e-05 2.4259754686171839e-10
+ 7.7573988816858022e-05 2.4182034068072913e-10
+ 7.7576421668443086e-05 2.4138174969930913e-10
+ 7.7578854520028151e-05 2.4076582964276258e-10
+ 7.7581287371613215e-05 2.4012576594620444e-10
+ 7.7583720223198279e-05 2.4057963384973803e-10
+ 7.7586153074783344e-05 2.4092919901400983e-10
+ 7.7588585926368408e-05 2.401872610697499e-10
+ 7.7591018777953472e-05 2.3987554496708928e-10
+ 7.7593451629538537e-05 2.4037942571475707e-10
+ 7.7595767705239784e-05 2.4025247901632375e-10
+ 7.7598819440406722e-05 2.4017887589128354e-10
+ 7.7601871175573661e-05 2.4009951114703349e-10
+ 7.7604922910740599e-05 2.4004351142745323e-10
+ 7.7607974645907537e-05 2.4016098617015712e-10
+ 7.7611026381074476e-05 2.4071442426522539e-10
+ 7.7614078116241414e-05 2.3968616681674537e-10
+ 7.7617773618773601e-05 2.4003007462135484e-10
+ 7.7621134288610919e-05 2.4006402385879101e-10
+ 7.7624494958448224e-05 2.4006047129867007e-10
+ 7.7628620731690288e-05 2.4005210497337081e-10
+ 7.7632746504932337e-05 2.4004042399080182e-10
+ 7.7636872278174401e-05 2.4003044384477591e-10
+ 7.7640998051416464e-05 2.4003749578386358e-10
+ 7.7645123824658527e-05 2.4008180521387353e-10
+ 7.7650251138437103e-05 2.4016443526047099e-10
+ 7.765537845221568e-05 2.3985136550844345e-10
+ 7.7660505765994269e-05 2.3994252727381691e-10
+ 7.7665633079772846e-05 2.4004700010028028e-10
+ 7.7671995979825153e-05 2.4004483697536087e-10
+ 7.7678358879877473e-05 2.3997024527683999e-10
+ 7.768472177992978e-05 2.3997592655072043e-10
+ 7.7692497256254511e-05 2.4000749931504923e-10
+ 7.7700272732579256e-05 2.4001269631983051e-10
+ 7.7708048208904e-05 2.3999782508278659e-10
+ 7.7717983441936069e-05 2.3999355892689472e-10
+ 7.7727918674968152e-05 2.4000179472492324e-10
+ 7.7740125706218151e-05 2.4000339716614338e-10
+ 7.775233273746815e-05 2.3999888202599127e-10
+ 7.7764539768718148e-05 2.3999830525938688e-10
+ 7.7776746799968147e-05 2.4000037974237526e-10
+ 7.7788953831218146e-05 2.4000087414852165e-10
+ 7.7801160862468144e-05 2.3999993966201389e-10
+ 7.7813367893718143e-05 2.3999960494882817e-10
+ 7.7825574924968142e-05 2.4000001432309894e-10
+ 7.7837781956218154e-05 2.4000021737723387e-10
+ 7.7849988987468153e-05 2.4000004462513988e-10
+ 7.7862196018718151e-05 2.3999993006727966e-10
+ 7.787440304996815e-05 2.3999999917748096e-10
+ 7.7886610081218149e-05 2.4000006049017395e-10
+ 7.7898817112468147e-05 2.4000003421757239e-10
+ 7.7911024143718146e-05 2.4000000237870328e-10
+ 7.7923231174968144e-05 2.4000001256652595e-10
+ 7.7935438206218143e-05 2.4000002745854788e-10
+ 7.7947645237468142e-05 2.4000002475271839e-10
+ 7.795985226871814e-05 2.4000001795384735e-10
+ 7.7972059299968153e-05 2.400000173879749e-10
+ 7.7984266331218151e-05 2.4000002070407596e-10
+ 7.799647336246815e-05 2.4000002067419452e-10
+ 7.8008680393718149e-05 2.4000001976473751e-10
+ 7.8020887424968147e-05 2.40000019362722e-10
+ 7.8033094456218146e-05 2.4000002028128461e-10
+ 7.8045301487468145e-05 2.4000002060646208e-10
+ 7.8057508518718143e-05 2.4000002008287723e-10
+ 7.8069715549968142e-05 2.4000001934276911e-10
+ 7.8081922581218141e-05 2.4000001968966948e-10
+ 7.8094129612468153e-05 2.4000002093381111e-10
+ 7.8106336643718151e-05 2.4000001965726013e-10
+ 7.811854367496815e-05 2.4000001961507071e-10
+ 7.8130750706218149e-05 2.4000002048512451e-10
+ 7.8142957737468147e-05 2.4000001998121006e-10
+ 7.8155164768718146e-05 2.400000199764228e-10
+ 7.8167371799968145e-05 2.4000001998665694e-10
+ 7.8179578831218143e-05 2.4000001988395378e-10
+ 7.8191785862468142e-05 2.4000001969840786e-10
+ 7.8203992893718141e-05 2.4000001962628526e-10
+ 7.8216199924968139e-05 2.4000001985975601e-10
+ 7.8228406956218152e-05 2.4000001994562599e-10
+ 7.824061398746815e-05 2.4000001873790616e-10
+ 7.8252821018718149e-05 2.400000206888198e-10
+ 7.8265028049968148e-05 2.4000002115772409e-10
+ 7.8277235081218146e-05 2.4000001926167516e-10
+ 7.8289442112468145e-05 2.4000001865095655e-10
+ 7.8301649143718143e-05 2.4000002024868279e-10
+ 7.8313856174968142e-05 2.4000002062807212e-10
+ 7.8326063206218141e-05 2.4000001971246058e-10
+ 7.8338270237468139e-05 2.4000001913611468e-10
+ 7.8350477268718152e-05 2.4000001939609548e-10
+ 7.836268429996815e-05 2.4000001928925776e-10
+ 7.8374891331218149e-05 2.4000002036211893e-10
+ 7.8387098362468148e-05 2.4000001948566678e-10
+ 7.8399305393718146e-05 2.40000020557049e-10
+ 7.8411512424968145e-05 2.400000203491446e-10
+ 7.8423719456218144e-05 2.4000001961720044e-10
+ 7.8435926487468142e-05 2.400000200808237e-10
+ 7.8448133518718141e-05 2.4000002006495584e-10
+ 7.846034054996814e-05 2.4000001941755901e-10
+ 7.8472547581218138e-05 2.4000001925514504e-10
+ 7.848475461246815e-05 2.4000001949494439e-10
+ 7.8496961643718149e-05 2.4000001987457185e-10
+ 7.8509168674968148e-05 2.4000001956535886e-10
+ 7.8521375706218146e-05 2.4000001976899341e-10
+ 7.8533582737468145e-05 2.4000001989767335e-10
+ 7.8545789768718144e-05 2.4000002010421042e-10
+ 7.8557996799968142e-05 2.4000002031692612e-10
+ 7.8570203831218141e-05 2.4000001943796074e-10
+ 7.858241086246814e-05 2.4000001979057998e-10
+ 7.8594617893718138e-05 2.4000001994141042e-10
+ 7.8606824924968137e-05 2.4000001910787902e-10
+ 7.8619031956218149e-05 2.4000002014157438e-10
+ 7.8631238987468148e-05 2.4000002007976212e-10
+ 7.8643446018718146e-05 2.4000001897875313e-10
+ 7.8655653049968145e-05 2.4000002030066949e-10
+ 7.8667860081218144e-05 2.4000002070432142e-10
+ 7.8680067112468142e-05 2.4000001950520541e-10
+ 7.8692274143718141e-05 2.4000001947980057e-10
+ 7.870448117496814e-05 2.4000002027253361e-10
+ 7.8716688206218138e-05 2.40000020609859e-10
+ 7.8728895237468137e-05 2.4000001911322354e-10
+ 7.8741102268718136e-05 2.4000001969739074e-10
+ 7.8753309299968148e-05 2.4000002073053612e-10
+ 7.8765516331218147e-05 2.4000001994814067e-10
+ 7.8777723362468145e-05 2.4000001923239209e-10
+ 7.8789930393718144e-05 2.4000002015288261e-10
+ 7.8802137424968143e-05 2.4000001930210656e-10
+ 7.8814344456218141e-05 2.4000001837686493e-10
+ 7.882655148746814e-05 2.4000001946449939e-10
+ 7.8838758518718139e-05 2.4000002038326192e-10
+ 7.8850965549968137e-05 2.400000203109469e-10
+ 7.8863172581218149e-05 2.400000203952259e-10
+ 7.8875379612468148e-05 2.4000001970496741e-10
+ 7.8887586643718147e-05 2.4000001924454606e-10
+ 7.8899793674968145e-05 2.4000001905466872e-10
+ 7.8912000706218144e-05 2.400000204518705e-10
+ 7.8924207737468143e-05 2.4000002011557764e-10
+ 7.8936414768718141e-05 2.4000001946831419e-10
+ 7.894862179996814e-05 2.4000001925940771e-10
+ 7.8960828831218152e-05 2.4000001980987061e-10
+ 7.8973035862468151e-05 2.4000002089319245e-10
+ 7.898524289371815e-05 2.4000001973823067e-10
+ 7.8997449924968148e-05 2.4000001879346328e-10
+ 7.9009656956218147e-05 2.4000001869932423e-10
+ 7.9021863987468145e-05 2.4000002074828773e-10
+ 7.9034071018718144e-05 2.4000001934026167e-10
+ 7.9046278049968143e-05 2.4000001952115826e-10
+ 7.9058485081218155e-05 2.4000001987859593e-10
+ 7.9070692112468154e-05 2.400000198982881e-10
+ 7.9082899143718152e-05 2.40000018977687e-10
+ 7.9095106174968151e-05 2.4000001970468766e-10
+ 7.910731320621815e-05 2.4000001969944985e-10
+ 7.9119520237468148e-05 2.4000002027367879e-10
+ 7.9131727268718147e-05 2.4000001840031488e-10
+ 7.9143934299968146e-05 2.4000001957318321e-10
+ 7.9156141331218158e-05 2.400000188108562e-10
+ 7.9168348362468156e-05 2.4000002046679305e-10
+ 7.9180555393718155e-05 2.4000001950571268e-10
+ 7.9192762424968154e-05 2.4000001838116472e-10
+ 7.9204969456218152e-05 2.4000001853089837e-10
+ 7.9217176487468151e-05 2.4000002004811227e-10
+ 7.922938351871815e-05 2.4000001966057371e-10
+ 7.9241590549968148e-05 2.4000001941089245e-10
+ 7.9253797581218161e-05 2.4000001913185568e-10
+ 7.9266004612468159e-05 2.4000001954838558e-10
+ 7.9278211643718158e-05 2.4000001920964592e-10
+ 7.9290418674968157e-05 2.4000001943469307e-10
+ 7.9302625706218155e-05 2.4000001866641258e-10
+ 7.9314832737468154e-05 2.4000002020897109e-10
+ 7.9327039768718153e-05 2.4000001940179987e-10
+ 7.9339246799968151e-05 2.4000001993507329e-10
+ 7.9351453831218163e-05 2.4000002008198123e-10
+ 7.9363660862468162e-05 2.400000198005213e-10
+ 7.9375867893718161e-05 2.4000001916301211e-10
+ 7.9388074924968159e-05 2.4000001960280073e-10
+ 7.9400281956218158e-05 2.4000001963117276e-10
+ 7.9412488987468157e-05 2.400000196254434e-10
+ 7.9424696018718155e-05 2.4000002030623543e-10
+ 7.9436903049968154e-05 2.4000001985486468e-10
+ 7.9449110081218166e-05 2.4000001975560508e-10
+ 7.9461317112468165e-05 2.4000002002563028e-10
+ 7.9473524143718163e-05 2.4000001880683233e-10
+ 7.9485731174968162e-05 2.400000186107882e-10
+ 7.9497938206218161e-05 2.4000002026174485e-10
+ 7.9510145237468159e-05 2.4000001964579944e-10
+ 7.9522352268718158e-05 2.4000001869414737e-10
+ 7.9534559299968157e-05 2.4000002024855297e-10
+ 7.9546766331218169e-05 2.4000001886895933e-10
+ 7.9558973362468168e-05 2.4000001996539064e-10
+ 7.9571180393718166e-05 2.4000001852201533e-10
+ 7.9583387424968165e-05 2.4000001995376353e-10
+ 7.9595594456218164e-05 2.4000001885033681e-10
+ 7.9607801487468162e-05 2.400000202275795e-10
+ 7.9620008518718161e-05 2.4000001938682899e-10
+ 7.963221554996816e-05 2.400000185286626e-10
+ 7.9644422581218172e-05 2.4000002021567022e-10
+ 7.965662961246817e-05 2.4000001929093104e-10
+ 7.9668836643718169e-05 2.4000001945502139e-10
+ 7.9681043674968168e-05 2.4000001849176264e-10
+ 7.9693250706218166e-05 2.4000001899160695e-10
+ 7.9705457737468165e-05 2.4000001908469775e-10
+ 7.9717664768718164e-05 2.4000002021320925e-10
+ 7.9729871799968162e-05 2.4000001986077044e-10
+ 7.9742078831218175e-05 2.4000001985660228e-10
+ 7.9754285862468173e-05 2.4000001982734366e-10
+ 7.9766492893718172e-05 2.4000001909394165e-10
+ 7.9778699924968171e-05 2.4000001971428865e-10
+ 7.9790906956218169e-05 2.4000001921042243e-10
+ 7.9803113987468168e-05 2.400000190589926e-10
+ 7.9815321018718167e-05 2.400000192770844e-10
+ 7.9827528049968165e-05 2.4000001876027354e-10
+ 7.9839735081218177e-05 2.4000001963225885e-10
+ 7.9851942112468176e-05 2.4000001898595255e-10
+ 7.9864149143718175e-05 2.4000001876650681e-10
+ 7.9876356174968173e-05 2.4000001955479303e-10
+ 7.9888563206218172e-05 2.400000192149284e-10
+ 7.9900770237468171e-05 2.4000001962818762e-10
+ 7.9912977268718169e-05 2.400000192259498e-10
+ 7.9925184299968168e-05 2.4000001958046752e-10
+ 7.993739133121818e-05 2.4000001876653049e-10
+ 7.9949598362468179e-05 2.4000001901679062e-10
+ 7.9961805393718177e-05 2.4000001929188411e-10
+ 7.9974012424968176e-05 2.4000001878460593e-10
+ 7.9986219456218175e-05 2.4000001895149019e-10
+ 7.9998426487468173e-05 2.4000001953324466e-10
+ 8.0010633518718172e-05 2.4000001930179932e-10
+ 8.0022840549968171e-05 2.4000001867284628e-10
+ 8.0035047581218183e-05 2.4000001876404646e-10
+ 8.0047254612468182e-05 2.4000001844012502e-10
+ 8.005946164371818e-05 2.4000001847700822e-10
+ 8.0071668674968179e-05 2.4000001848915366e-10
+ 8.0083875706218178e-05 2.4000001847211049e-10
+ 8.0096082737468176e-05 2.4000001842583542e-10
+ 8.0108289768718175e-05 2.4000001874485954e-10
+ 8.0120496799968174e-05 2.4000001864470591e-10
+ 8.0132703831218186e-05 2.400000192645186e-10
+ 8.0144910862468184e-05 2.4000001911011029e-10
+ 8.0157117893718183e-05 2.400000189594016e-10
+ 8.0169324924968182e-05 2.4000001834385696e-10
+ 8.018153195621818e-05 2.4000001923683012e-10
+ 8.0193738987468179e-05 2.4000002008098464e-10
+ 8.0205946018718178e-05 2.400000183211859e-10
+ 8.0218153049968176e-05 2.4000001983070817e-10
+ 8.0230360081218189e-05 2.4000001841550595e-10
+ 8.0242567112468187e-05 2.4000001987140726e-10
+ 8.0254774143718186e-05 2.4000001839799459e-10
+ 8.0266981174968185e-05 2.4000001979564812e-10
+ 8.0279188206218183e-05 2.4000001826400317e-10
+ 8.0291395237468182e-05 2.3996544537098469e-10
+ 8.030360226871818e-05 2.3996256464191007e-10
+ 8.0315809299968179e-05 2.3996062147298765e-10
+ 8.0328016331218191e-05 2.399538992151035e-10
+ 8.034022336246819e-05 2.3990864356794482e-10
+ 8.0352430393718189e-05 2.3980391697569448e-10
+ 8.0364637424968187e-05 2.3960325885649169e-10
+ 8.0370740940593187e-05 2.3930636780140344e-10
+ 8.0376844456218186e-05 2.3825018349924986e-10
+ 8.0379896214030692e-05 2.3664385617022961e-10
+ 8.0382947971843185e-05 2.313460144418538e-10
+ 8.0384473850749432e-05 2.2273712950258841e-10
+ 8.0385999729655692e-05 1.9502932447418286e-10
+ 8.0386991106889185e-05 1.3263414891107653e-10
+ 8.0387269733896244e-05 9.5672269136980181e-11
+ 8.0387548360903304e-05 4.6113023016783446e-11
+ 8.0388098835627972e-05 4.077304569289076e-11
+ 8.0390875273912438e-05 4.2347131994264368e-11
+ 8.0403082305162437e-05 4.4733371018365243e-11
+ 8.0415289336412436e-05 5.3058719093237963e-11
+ 8.0427496367662448e-05 6.5249849962529414e-11
+ 8.0439703398912447e-05 8.0586557341896391e-11
+ 8.0451910430162445e-05 9.8186059694000248e-11
+ 8.0464117461412444e-05 1.1703587328666208e-10
+ 8.0476324492662443e-05 1.3605185310399104e-10
+ 8.0488531523912441e-05 1.5414054504639482e-10
+ 8.050073855516244e-05 1.7026206156240515e-10
+ 8.0512945586412452e-05 1.8348986297121229e-10
+ 8.0525152617662451e-05 1.9306400774952091e-10
+ 8.0537359648912449e-05 1.9843481134517081e-10
+ 8.0549566680162448e-05 1.9929440536940058e-10
+ 8.0561773711412447e-05 1.9559438520732841e-10
+ 8.0573980742662445e-05 1.8754853451668201e-10
+ 8.0586187773912444e-05 1.7562047328816539e-10
+ 8.0598394805162443e-05 1.6049694315998822e-10
+ 8.0610601836412441e-05 1.4304826930135124e-10
+ 8.0622808867662454e-05 1.2427827523140709e-10
+ 8.0635015898912452e-05 1.052665328361379e-10
+ 8.0647222930162451e-05 8.7106269937226752e-11
+ 8.0659429961412449e-05 7.0841506734532094e-11
+ 8.0671636992662448e-05 5.7407035899497847e-11
+ 8.0683844023912447e-05 4.7574696846103914e-11
+ 8.0686895781724953e-05 4.5750674856066197e-11
+ 8.0687048369615572e-05 4.5666462612461995e-11
+ 8.0687429839342134e-05 4.5458870923120094e-11
+ 8.0687467986314789e-05 4.5438342991126504e-11
+ 8.0687475615709328e-05 4.5434242455099145e-11
+ 8.0687490874498393e-05 4.5426046434154427e-11
+ 8.0687496978014008e-05 4.5422769911655126e-11
+ 8.068749941942027e-05 4.542145960441293e-11
+ 8.0687499604455796e-05 4.5421360302533612e-11
+ 8.0687499974526849e-05 4.5421161701746532e-11
+ 8.0687500714668955e-05 5.7234708751505077e-08
+ 8.068750145481106e-05 2.3609835104101694e-07
+ 8.0687508856232157e-05 8.3378657603255145e-06
+ 8.068751625765324e-05 2.6804211983519737e-05
+ 8.0687523659074336e-05 5.4212572160978158e-05
+ 8.0687531060495419e-05 8.9333429400249197e-05
+ 8.0687538461916516e-05 0.00013110387761772142
+ 8.0687547512355693e-05 0.00018988604042548046
+ 8.068755656279487e-05 0.000255812068272275
+ 8.068756561323406e-05 0.00032768193023753725
+ 8.0687574663673237e-05 0.00040448949601993325
+ 8.0687583714112414e-05 0.00048539058840956265
+ 8.0687595044533512e-05 0.00059137048504824714
+ 8.0687606374954611e-05 0.00070151686849491022
+ 8.0687617705375709e-05 0.0008149054011463608
+ 8.0687629035796807e-05 0.00093078918228233572
+ 8.0687643214653369e-05 0.0010784080416500865
+ 8.0687657393509917e-05 0.0012280520970111633
+ 8.0687671572366479e-05 0.0013789889014004875
+ 8.0687689032396943e-05 0.0015657925325384681
+ 8.0687706492427408e-05 0.0017528666320927736
+ 8.0687723952457873e-05 0.0019395804048633696
+ 8.0687746268477836e-05 0.0021769293571718938
+ 8.0687768584497812e-05 0.0024120996791847497
+ 8.0687790900517775e-05 0.0026444704336099976
+ 8.0687819090217251e-05 0.0029332237971511233
+ 8.0687847279916714e-05 0.0032158629328255771
+ 8.068787546961619e-05 0.0034916668520790159
+ 8.0687903659315652e-05 0.0037599988278231356
+ 8.0687931849015128e-05 0.0040202830355208904
+ 8.0687960038714591e-05 0.0042719918874605982
+ 8.0687988228414067e-05 0.0045146394015623476
+ 8.0688019414106482e-05 0.0047719795450323309
+ 8.0688050599798884e-05 0.0050171295125712645
+ 8.06880817854913e-05 0.0052495906087394869
+ 8.0688112971183715e-05 0.0054689190353913904
+ 8.0688150418414348e-05 0.0057143885297757718
+ 8.0688187865644967e-05 0.0059397992525804574
+ 8.06882253128756e-05 0.006144702220679193
+ 8.068827084419581e-05 0.0063657430322260553
+ 8.0688316375516033e-05 0.0065556175023236875
+ 8.0688361906836243e-05 0.0067142112673811444
+ 8.0688407438156453e-05 0.0068416534980290083
+ 8.0688441084028118e-05 0.0069160175765833089
+ 8.0688474729899784e-05 0.0069737900261410465
+ 8.0688508375771449e-05 0.0070152594941248576
+ 8.0688542021643115e-05 0.0070407746969006688
+ 8.068857566751478e-05 0.007050740823760393
+ 8.0688609313386446e-05 0.0070456156939712805
+ 8.0688642959258111e-05 0.007025905702338452
+ 8.0688676605129777e-05 0.0069921615895264296
+ 8.0688710251001442e-05 0.0069449740739896257
+ 8.0688736870668159e-05 0.006898526876910809
+ 8.0688763490334862e-05 0.0068443802044164921
+ 8.0688790110001579e-05 0.0067828688534493494
+ 8.0688816729668282e-05 0.0067143369242957376
+ 8.0688843349334998e-05 0.0066391364097472113
+ 8.0688869969001702e-05 0.0065576257964309343
+ 8.0688896588668418e-05 0.0064701686843428533
+ 8.0688923208335121e-05 0.0063771324303375145
+ 8.0688949828001838e-05 0.0062788868210215225
+ 8.0688976447668555e-05 0.0061758027801676225
+ 8.0689003067335258e-05 0.0060682511154162089
+ 8.0689029687001975e-05 0.0059566013086644297
+ 8.0689056306668678e-05 0.0058412203541628417
+ 8.0689082926335394e-05 0.0057224716479485063
+ 8.0689109546002097e-05 0.0056007139318451742
+ 8.0689136165668814e-05 0.0054763002948580381
+ 8.0689162785335531e-05 0.0053495772343856614
+ 8.0689189405002234e-05 0.0052208837792675896
+ 8.0689216024668951e-05 0.0050905506764474901
+ 8.0689239404935234e-05 0.0049749804171373225
+ 8.0689262785201517e-05 0.0048586054363550972
+ 8.0689286165467814e-05 0.0047416314482211135
+ 8.0689309545734097e-05 0.0046242577652878883
+ 8.0689332926000393e-05 0.0045066770343838705
+ 8.0689356306266676e-05 0.0043890750025309139
+ 8.068937968653296e-05 0.0042716303126259531
+ 8.0689403066799256e-05 0.0041545143284691553
+ 8.0689426447065539e-05 0.0040378909886185305
+ 8.0689449827331823e-05 0.0039219166884552218
+ 8.0689473207598119e-05 0.0038067401897542695
+ 8.0689496587864402e-05 0.0036925025569730643
+ 8.0689519968130699e-05 0.0035793371193940525
+ 8.0689543348396982e-05 0.0034673694581895016
+ 8.0689566728663265e-05 0.0033567174174145066
+ 8.0689590108929562e-05 0.0032474911378798247
+ 8.0689613489195845e-05 0.0031397931128086067
+ 8.0689636869462128e-05 0.0030337182641405314
+ 8.0689660249728425e-05 0.0029293540383132049
+ 8.0689683629994708e-05 0.0028267805203238136
+ 8.0689707010261005e-05 0.0027260705648536779
+ 8.0689735591237525e-05 0.0026055855381113117
+ 8.0689764172214046e-05 0.0024880893416989024
+ 8.0689792753190566e-05 0.0023736731389782805
+ 8.06898213341671e-05 0.0022624136400195647
+ 8.0689849915143621e-05 0.0021543736566158275
+ 8.0689886199806219e-05 0.0020219271947776738
+ 8.0689925453373385e-05 0.0018846580284455387
+ 8.0689946977215271e-05 0.0018120618774395494
+ 8.06899736967147e-05 0.0017245821083065652
+ 8.0690000416214143e-05 0.0016400258203643724
+ 8.0690027135713573e-05 0.0015583844444338579
+ 8.0690053855213015e-05 0.0014796423351417674
+ 8.0690080574712445e-05 0.0014037772468436488
+ 8.0690107294211888e-05 0.0013307608065583204
+ 8.0690134013711317e-05 0.0012605589819463642
+ 8.069016073321076e-05 0.0011931325425094006
+ 8.0690187452710189e-05 0.0011284375123336611
+ 8.0690214172209632e-05 0.0010664256128491564
+ 8.0690240891709061e-05 0.0010070446942234952
+ 8.0690262548859621e-05 0.00096080661895637035
+ 8.0690284206010168e-05 0.0009162294538821239
+ 8.0690305863160715e-05 0.00087328092606094238
+ 8.0690327520311275e-05 0.00083192771752318962
+ 8.0690349177461822e-05 0.00079213559354230647
+ 8.0690370834612382e-05 0.00075386952625768001
+ 8.0690392491762928e-05 0.00071709381353394315
+ 8.0690414148913475e-05 0.00068177219296354193
+ 8.0690435806064035e-05 0.00064786795094112185
+ 8.0690457463214582e-05 0.00061534402675914772
+ 8.0690479120365142e-05 0.00058416311167918647
+ 8.069049676539961e-05 0.00055972551886932095
+ 8.0690514410434078e-05 0.00053613426244406741
+ 8.0690532055468559e-05 0.00051336904748169171
+ 8.0690549700503027e-05 0.00049140960981622914
+ 8.0690567345537508e-05 0.00047023574348777509
+ 8.0690584990571976e-05 0.00044982732676715286
+ 8.0690602635606458e-05 0.00043016434677204047
+ 8.0690620280640926e-05 0.00041122692269401575
+ 8.0690637925675393e-05 0.00039299532765819798
+ 8.0690655570709875e-05 0.00037545000923921415
+ 8.0690673215744343e-05 0.00035857160865911174
+ 8.0690690860778824e-05 0.00034234097869457157
+ 8.0690708505813292e-05 0.00032673920032235228
+ 8.0690726150847773e-05 0.00031174759813332067
+ 8.0690743795882241e-05 0.00029734775454669758
+ 8.0690761440916709e-05 0.00028352152285727745
+ 8.069077908595119e-05 0.0002702510391493668
+ 8.0690796730985658e-05 0.00025751873311203796
+ 8.069081437602014e-05 0.00024530733779101174
+ 8.0690832021054607e-05 0.00023359989831307307
+ 8.0690849666089089e-05 0.00022237977961939102
+ 8.0690867311123557e-05 0.00021163067324446447
+ 8.0690884956158038e-05 0.00020133660317765155
+ 8.0690902601192506e-05 0.00019148193084437179
+ 8.0690920246226974e-05 0.00018205135924409671
+ 8.0690937891261455e-05 0.00017302993628217709
+ 8.0690955536295923e-05 0.00016440305733239472
+ 8.0690973181330404e-05 0.00015615646706688136
+ 8.0690990826364872e-05 0.00014827626058972067
+ 8.0691008471399354e-05 0.00014074888391014853
+ 8.0691026116433821e-05 0.00013356113379079491
+ 8.0691043761468303e-05 0.00012670015700587552
+ 8.0691061406502771e-05 0.00012015344904364461
+ 8.0691079051537238e-05 0.00011390885228677083
+ 8.069109669657172e-05 0.00010795455370359766
+ 8.0691114341606188e-05 0.00010227908208250491
+ 8.0691131986640669e-05 9.687130484080241e-05
+ 8.0691149631675137e-05 9.1720424438765868e-05
+ 8.0691167276709618e-05 8.6815974428572379e-05
+ 8.0691184921744086e-05 8.2147815167013072e-05
+ 8.0691202566778554e-05 7.7706129219957601e-05
+ 8.0691220211813035e-05 7.3481416485622882e-05
+ 8.0691237856847503e-05 6.9464489062760908e-05
+ 8.0691255501881985e-05 6.5646465888930612e-05
+ 8.0691273146916452e-05 6.2018767173060703e-05
+ 8.0691290791950934e-05 5.8573108645546759e-05
+ 8.0691308436985402e-05 5.5301495648160228e-05
+ 8.0691326082019869e-05 5.2196217085081444e-05
+ 8.0691343727054351e-05 4.9249839255407143e-05
+ 8.0691361372088819e-05 4.6455199586526805e-05
+ 8.06913790171233e-05 4.3805400286814076e-05
+ 8.0691396662157768e-05 4.1293801935142287e-05
+ 8.0691414307192249e-05 3.8914017023807698e-05
+ 8.0691431952226717e-05 3.6659903470533496e-05
+ 8.0691449597261199e-05 3.4525558114332587e-05
+ 8.0691467242295666e-05 3.2505310209129923e-05
+ 8.0691484887330134e-05 3.0593714928186798e-05
+ 8.0691502532364616e-05 2.878554689153125e-05
+ 8.0691520177399083e-05 2.7075793727781893e-05
+ 8.0691537822433565e-05 2.5459649680957857e-05
+ 8.0691555467468033e-05 2.3932509272096093e-05
+ 8.0691573112502514e-05 2.2489961024749567e-05
+ 8.0691590757536982e-05 2.1127781262716843e-05
+ 8.0691608402571463e-05 1.9841927987655173e-05
+ 8.0691626047605931e-05 1.8628534843556469e-05
+ 8.0691643692640399e-05 1.7483905174418017e-05
+ 8.069166133767488e-05 1.6404506180818473e-05
+ 8.0691682620107579e-05 1.5184596516820046e-05
+ 8.0691702745281689e-05 1.4108722156777394e-05
+ 8.0691722870455785e-05 1.3103783271809466e-05
+ 8.0691742995629896e-05 1.2165512099818384e-05
+ 8.0691763120803992e-05 1.1289867233639744e-05
+ 8.0691783245978089e-05 1.0473023791237365e-05
+ 8.0691803371152199e-05 9.711363860421274e-06
+ 8.0691823496326296e-05 9.0014672215583367e-06
+ 8.0691843621500406e-05 8.3401023506671107e-06
+ 8.0691863746674503e-05 7.7242177042852387e-06
+ 8.0691888110746135e-05 7.0353574872189284e-06
+ 8.0691912474817754e-05 6.4041509733236313e-06
+ 8.0691936838889387e-05 5.8261375978047346e-06
+ 8.069196120296102e-05 5.2971679183216326e-06
+ 8.0691985567032639e-05 4.8133849648221628e-06
+ 8.0692009931104271e-05 4.3712064413582404e-06
+ 8.0692034295175904e-05 3.9673077642003495e-06
+ 8.0692058659247523e-05 3.5986059186122073e-06
+ 8.0692083023319155e-05 3.2622441148827113e-06
+ 8.0692107387390775e-05 2.955577222710442e-06
+ 8.0692136719683581e-05 2.6223173518557521e-06
+ 8.0692166051976374e-05 2.3246430183300364e-06
+ 8.0692195384269167e-05 2.0589938235170389e-06
+ 8.0692224716561961e-05 1.8221375097881734e-06
+ 8.0692254048854754e-05 1.6111428978970881e-06
+ 8.0692283381147547e-05 1.4233547079677823e-06
+ 8.069231271344034e-05 1.2563701699769522e-06
+ 8.0692342045733133e-05 1.1080173307665688e-06
+ 8.0692377848029197e-05 9.4935328593955194e-07
+ 8.0692412335454632e-05 8.1703614317247063e-07
+ 8.0692446822880066e-05 7.0231034037170861e-07
+ 8.0692481310305501e-05 6.0295931014601184e-07
+ 8.0692515797730935e-05 5.1702814794412422e-07
+ 8.069255782832122e-05 4.2796498791424164e-07
+ 8.0692599858911491e-05 3.5358466304975593e-07
+ 8.0692641889501776e-05 2.9157919961691281e-07
+ 8.0692683920092047e-05 2.3998333476715486e-07
+ 8.0692725950682332e-05 1.9712710629082681e-07
+ 8.0692777518503431e-05 1.5442331314774624e-07
+ 8.0692828186666482e-05 1.2110746118199679e-07
+ 8.0692878854829548e-05 9.4668212428266369e-08
+ 8.0692929522992599e-05 7.3741045625230226e-08
+ 8.0692993215143464e-05 5.3572482382509411e-08
+ 8.0693056907294328e-05 3.8650410566722333e-08
+ 8.0693120599445193e-05 2.7655607125139506e-08
+ 8.0693198945610726e-05 1.80624388894615e-08
+ 8.0693278657649698e-05 1.1455385675920075e-08
+ 8.0693358369688669e-05 7.0279116712338033e-09
+ 8.0693461292370765e-05 3.42722610432318e-09
+ 8.069356950890982e-05 1.2415251844169095e-09
+ 8.0693701914804445e-05 -1.7423168879043324e-10
+ 8.0693847065030187e-05 -9.0046498724308251e-10
+ 8.0694034315235695e-05 -1.2675598336250834e-09
+ 8.0694255865010437e-05 -1.390661486095478e-09
+ 8.0694554034092513e-05 -1.4079464626524889e-09
+ 8.0694998769870896e-05 -1.3781166774969621e-09
+ 8.0695805003989005e-05 -1.313948994893242e-09
+ 8.0696711764368325e-05 -1.2450592154006523e-09
+ 8.0697737475686452e-05 -1.1711746826522686e-09
+ 8.0698801143402343e-05 -1.0985374417948889e-09
+ 8.0699944764949549e-05 -1.0244977902794022e-09
+ 8.0702231646278915e-05 -8.876839903243166e-10
+ 8.0704182681216662e-05 -7.8153991862173163e-10
+ 8.070629122851725e-05 -6.7660226349856925e-10
+ 8.0708581467436172e-05 -5.7299433820914436e-10
+ 8.071092666685003e-05 -4.7698621811411996e-10
+ 8.0713271866263888e-05 -3.901690868650475e-10
+ 8.0715590537179638e-05 -3.1248869476676087e-10
+ 8.0718474569484291e-05 -2.2600941125466692e-10
+ 8.0721358601788931e-05 -1.4953972152878652e-10
+ 8.0724242634093584e-05 -8.1909642546355165e-11
+ 8.0727126666398238e-05 -2.2097231394821104e-11
+ 8.0730010698702877e-05 3.0804763949844941e-11
+ 8.0732894731007531e-05 7.7599184420572088e-11
+ 8.0735778763312184e-05 1.1899177680085989e-10
+ 8.0739342797663601e-05 1.6360497315690482e-10
+ 8.0742906832015018e-05 2.0194460469335925e-10
+ 8.0746470866366435e-05 2.3489304324568193e-10
+ 8.0750034900717852e-05 2.6320792465228799e-10
+ 8.0753598935069283e-05 2.8754418863776942e-10
+ 8.0757899961127362e-05 3.124003450031708e-10
+ 8.0762200987185455e-05 3.3310188136055884e-10
+ 8.0766502013243549e-05 3.5034335018174361e-10
+ 8.0770803039301628e-05 3.6470346013268147e-10
+ 8.0775104065359721e-05 3.7666442373221598e-10
+ 8.0780502505986985e-05 3.8888313831481749e-10
+ 8.0785900946614262e-05 3.9859542479219459e-10
+ 8.0791299387241526e-05 4.0629545583254085e-10
+ 8.079669782786879e-05 4.1242659596079512e-10
+ 8.0803468247657477e-05 4.1836450212166619e-10
+ 8.0810238667446165e-05 4.228142873871682e-10
+ 8.0817009087234853e-05 4.2614500842071573e-10
+ 8.0825385304343958e-05 4.2912633403108892e-10
+ 8.0833761521453078e-05 4.3120345772378355e-10
+ 8.0842137738562183e-05 4.3264838822889765e-10
+ 8.0853043385488663e-05 4.3388610175178318e-10
+ 8.0863949032415142e-05 4.3464666000495187e-10
+ 8.0876156063665141e-05 4.3514763453961883e-10
+ 8.0888363094915139e-05 4.3542384097085643e-10
+ 8.0900570126165138e-05 4.3556624282357159e-10
+ 8.0912777157415137e-05 4.3562884855868211e-10
+ 8.0924984188665135e-05 4.3564390919099658e-10
+ 8.0937191219915134e-05 4.3563071731303817e-10
+ 8.0949398251165146e-05 4.3560072832369711e-10
+ 8.0961605282415145e-05 4.3556071800624522e-10
+ 8.0973812313665143e-05 4.3551473285478916e-10
+ 8.0986019344915142e-05 4.3546520640556509e-10
+ 8.0998226376165141e-05 4.3541358487496968e-10
+ 8.1010433407415139e-05 4.3536071753580087e-10
+ 8.1022640438665138e-05 4.353071102954193e-10
+ 8.1034847469915137e-05 4.3525307030070124e-10
+ 8.1047054501165135e-05 4.3519878102624261e-10
+ 8.1059261532415148e-05 4.3514434891989702e-10
+ 8.1071468563665146e-05 4.3508983678706616e-10
+ 8.1083675594915145e-05 4.3503528333983576e-10
+ 8.1095882626165143e-05 4.3498071205926307e-10
+ 8.1108089657415142e-05 4.3492613633167183e-10
+ 8.1120296688665141e-05 4.348715638520445e-10
+ 8.1132503719915139e-05 4.3481699946235471e-10
+ 8.1144710751165152e-05 4.3476244620745766e-10
+ 8.115691778241515e-05 4.3470790578886986e-10
+ 8.1169124813665149e-05 4.3465337912630206e-10
+ 8.1181331844915148e-05 4.3459886680952396e-10
+ 8.1193538876165146e-05 4.3454436923774573e-10
+ 8.1205745907415145e-05 4.3448988663097442e-10
+ 8.1217952938665144e-05 4.3443541909242035e-10
+ 8.1230159969915142e-05 4.3438096668679938e-10
+ 8.1242367001165141e-05 4.3432652946422885e-10
+ 8.125000000000001e-05 4.3429323819786375e-10
+ 8.1262207031250008e-05 4.3423882549145797e-10
+ 8.1274414062500007e-05 4.3418442800650571e-10
+ 8.1286621093750006e-05 4.3413004574565444e-10
+ 8.1298828125000004e-05 4.3407567870875607e-10
+ 8.1311035156250003e-05 4.3402132689399754e-10
+ 8.1323242187500015e-05 4.3396699029857563e-10
+ 8.1335449218750014e-05 4.3391266891909689e-10
+ 8.1347656250000013e-05 4.338583627518177e-10
+ 8.1359863281250011e-05 4.338040717927861e-10
+ 8.137207031250001e-05 4.3374979603792648e-10
+ 8.1384277343750009e-05 4.3369553548309005e-10
+ 8.1396484375000007e-05 4.3364129012408513e-10
+ 8.1408691406250006e-05 4.3358705995669485e-10
+ 8.1420898437500005e-05 4.3353284497668784e-10
+ 8.1433105468750003e-05 4.3347864517982436e-10
+ 8.1445312500000015e-05 4.3342446056186068e-10
+ 8.1457519531250014e-05 4.3337029111855061e-10
+ 8.1469726562500013e-05 4.3331613684564742e-10
+ 8.1481933593750011e-05 4.3326199773890431e-10
+ 8.149414062500001e-05 4.3320787379407488e-10
+ 8.1506347656250009e-05 4.3315376500691365e-10
+ 8.1518554687500007e-05 4.3309967137317592e-10
+ 8.1530761718750006e-05 4.3304559288861817e-10
+ 8.1542968750000005e-05 4.3299152954899793e-10
+ 8.1555175781250003e-05 4.3293748135007384e-10
+ 8.1567382812500016e-05 4.3288344828760572e-10
+ 8.1579589843750014e-05 4.3282943035735457e-10
+ 8.1591796875000013e-05 4.3277542755508266e-10
+ 8.1604003906250011e-05 4.327214398765532e-10
+ 8.161621093750001e-05 4.3266746731753079e-10
+ 8.1628417968750009e-05 4.3261350987378112e-10
+ 8.1640625000000007e-05 4.3255956754107106e-10
+ 8.1652832031250006e-05 4.3250564031516869e-10
+ 8.1665039062500005e-05 4.324517281918434e-10
+ 8.1677246093750003e-05 4.3239783116686546e-10
+ 8.1689453125000016e-05 4.3234394923600652e-10
+ 8.1701660156250014e-05 4.3229008239503964e-10
+ 8.1713867187500013e-05 4.322362306397386e-10
+ 8.1726074218750012e-05 4.3218239396587857e-10
+ 8.173828125000001e-05 4.3212857236923607e-10
+ 8.1750488281250009e-05 4.3207476584558855e-10
+ 8.1762695312500008e-05 4.3202097439071481e-10
+ 8.1774902343750006e-05 4.3196719800039462e-10
+ 8.1787109375000005e-05 4.3191343667040926e-10
+ 8.1799316406250004e-05 4.3185969039654094e-10
+ 8.1811523437500016e-05 4.3180595917457319e-10
+ 8.1823730468750014e-05 4.3175224300029046e-10
+ 8.1835937500000013e-05 4.3169854186947872e-10
+ 8.1848144531250012e-05 4.3164485577792515e-10
+ 8.186035156250001e-05 4.3159118472141752e-10
+ 8.1872558593750009e-05 4.315375286957455e-10
+ 8.1884765625000008e-05 4.3148388769669956e-10
+ 8.1896972656250006e-05 4.3143026172007142e-10
+ 8.1909179687500005e-05 4.3137665076165393e-10
+ 8.1921386718750004e-05 4.3132305481724119e-10
+ 8.1933593750000016e-05 4.3126947388262849e-10
+ 8.1945800781250015e-05 4.3121590795361226e-10
+ 8.1958007812500013e-05 4.3116235702599014e-10
+ 8.1970214843750012e-05 4.311088210955608e-10
+ 8.198242187500001e-05 4.3105530015812432e-10
+ 8.1994628906250009e-05 4.3100179420948178e-10
+ 8.2006835937500008e-05 4.3094830324543561e-10
+ 8.2019042968750006e-05 4.3089482726178914e-10
+ 8.2031250000000005e-05 4.3084136625434698e-10
+ 8.2043457031250004e-05 4.3078792021891527e-10
+ 8.2055664062500016e-05 4.3073448915130076e-10
+ 8.2067871093750015e-05 4.3068107304731183e-10
+ 8.2080078125000013e-05 4.3062767190275767e-10
+ 8.2092285156250012e-05 4.3057428571344897e-10
+ 8.2104492187500011e-05 4.305209144751974e-10
+ 8.2116699218750009e-05 4.3046755818381573e-10
+ 8.2128906250000008e-05 4.3041421683511815e-10
+ 8.2141113281250007e-05 4.3036089042491982e-10
+ 8.2153320312500005e-05 4.3030757894903721e-10
+ 8.2165527343750004e-05 4.3025428240328784e-10
+ 8.2177734375000016e-05 4.3020100078349046e-10
+ 8.2189941406250015e-05 4.3014773408546503e-10
+ 8.2202148437500013e-05 4.3009448230503257e-10
+ 8.2214355468750012e-05 4.3004124543801536e-10
+ 8.2226562500000011e-05 4.2998802348023685e-10
+ 8.2238769531250009e-05 4.2993481642752165e-10
+ 8.2250976562500008e-05 4.298816242756955e-10
+ 8.2263183593750007e-05 4.2982844702058526e-10
+ 8.2275390625000005e-05 4.2977528465801911e-10
+ 8.2287597656250004e-05 4.2972213718382639e-10
+ 8.2299804687500016e-05 4.296690045938374e-10
+ 8.2312011718750015e-05 4.2961588688388387e-10
+ 8.2324218750000013e-05 4.2956278404979846e-10
+ 8.2336425781250012e-05 4.2950969608741529e-10
+ 8.2348632812500011e-05 4.2945662299256918e-10
+ 8.2360839843750009e-05 4.2940356476109669e-10
+ 8.2373046875000008e-05 4.2935052138883517e-10
+ 8.2385253906250007e-05 4.2929749287162315e-10
+ 8.2397460937500005e-05 4.2924447920530045e-10
+ 8.2409667968750004e-05 4.2919148038570803e-10
+ 8.2421875000000003e-05 4.2913849640868801e-10
+ 8.2434082031250015e-05 4.2908552727008359e-10
+ 8.2446289062500014e-05 4.2903257296573924e-10
+ 8.2458496093750012e-05 4.2897963349150058e-10
+ 8.2470703125000011e-05 4.2892670884321429e-10
+ 8.248291015625001e-05 4.288737990167283e-10
+ 8.2495117187500008e-05 4.2882090400789185e-10
+ 8.2507324218750007e-05 4.2876802381255504e-10
+ 8.2519531250000006e-05 4.2871515842656934e-10
+ 8.2531738281250004e-05 4.2866230784578723e-10
+ 8.2543945312500003e-05 4.2860947206606246e-10
+ 8.2556152343750015e-05 4.2855665108325002e-10
+ 8.2568359375000014e-05 4.2850384489320595e-10
+ 8.2580566406250012e-05 4.2845105349178732e-10
+ 8.2592773437500011e-05 4.2839827687485269e-10
+ 8.260498046875001e-05 4.2834551503826145e-10
+ 8.2617187500000008e-05 4.2829276797787439e-10
+ 8.2629394531250007e-05 4.2824003568955333e-10
+ 8.2641601562500006e-05 4.2818731816916134e-10
+ 8.2653808593750004e-05 4.2813461541256231e-10
+ 8.2666015625000003e-05 4.2808192741562203e-10
+ 8.2678222656250002e-05 4.2802925417420679e-10
+ 8.2690429687500014e-05 4.2797659568418397e-10
+ 8.2702636718750012e-05 4.2792395194142275e-10
+ 8.2714843750000011e-05 4.2787132294179297e-10
+ 8.272705078125001e-05 4.2781870868116553e-10
+ 8.2739257812500008e-05 4.2776610915541303e-10
+ 8.2751464843750007e-05 4.2771352436040875e-10
+ 8.2763671875000006e-05 4.2766095429202714e-10
+ 8.2775878906250004e-05 4.2760839894614423e-10
+ 8.2788085937500003e-05 4.2755585831863669e-10
+ 8.2800292968750002e-05 4.2750333240538267e-10
+ 8.2812500000000014e-05 4.2745082120226136e-10
+ 8.2824707031250013e-05 4.2739832470515305e-10
+ 8.2836914062500011e-05 4.273458429099393e-10
+ 8.284912109375001e-05 4.2729337581250278e-10
+ 8.2861328125000009e-05 4.2724092340872732e-10
+ 8.2873535156250007e-05 4.2718848569449787e-10
+ 8.2885742187500006e-05 4.2713606266570053e-10
+ 8.2897949218750005e-05 4.2708365431822263e-10
+ 8.2910156250000003e-05 4.270312606479525e-10
+ 8.2922363281250002e-05 4.2697888165077988e-10
+ 8.29345703125e-05 4.2692651732259529e-10
+ 8.2946777343750013e-05 4.2687416765929084e-10
+ 8.2958984375000011e-05 4.2682183265675928e-10
+ 8.297119140625001e-05 4.2676951231089505e-10
+ 8.2983398437500009e-05 4.2671720661759342e-10
+ 8.2995605468750007e-05 4.2666491557275079e-10
+ 8.3007812500000006e-05 4.2661263917226478e-10
+ 8.3020019531250005e-05 4.265603774120343e-10
+ 8.3032226562500003e-05 4.265081302879591e-10
+ 8.3044433593750002e-05 4.2645589779594043e-10
+ 8.3056640625000001e-05 4.2640367993188038e-10
+ 8.3068847656249999e-05 4.2635147669168246e-10
+ 8.3081054687500011e-05 4.2629928807125108e-10
+ 8.309326171875001e-05 4.2624711406649186e-10
+ 8.3105468750000009e-05 4.2619495467331169e-10
+ 8.3117675781250007e-05 4.2614280988761856e-10
+ 8.3129882812500006e-05 4.2609067970532156e-10
+ 8.3142089843750005e-05 4.2603856412233079e-10
+ 8.3154296875000003e-05 4.2598646313455786e-10
+ 8.3166503906250002e-05 4.2593437673791515e-10
+ 8.3178710937500001e-05 4.2588230492831644e-10
+ 8.3190917968749999e-05 4.2583024770167654e-10
+ 8.3203124999999998e-05 4.2577820505391141e-10
+ 8.321533203125001e-05 4.2572617698093814e-10
+ 8.3227539062500009e-05 4.2567416347867499e-10
+ 8.3239746093750008e-05 4.2562216454304139e-10
+ 8.3251953125000006e-05 4.2557018016995789e-10
+ 8.3264160156250005e-05 4.2551821035534623e-10
+ 8.3276367187500003e-05 4.2546625509512913e-10
+ 8.3288574218750002e-05 4.254143143852306e-10
+ 8.3300781250000001e-05 4.2536238822157581e-10
+ 8.3312988281249999e-05 4.2531047660009089e-10
+ 8.3325195312499998e-05 4.2525857951670346e-10
+ 8.333740234375001e-05 4.252066969673418e-10
+ 8.3349609375000009e-05 4.2515482894793579e-10
+ 8.3361816406250008e-05 4.2510297545441604e-10
+ 8.3374023437500006e-05 4.2505113648271467e-10
+ 8.3386230468750005e-05 4.2499931202876474e-10
+ 8.3398437500000004e-05 4.2494750208850055e-10
+ 8.3410644531250002e-05 4.248957066578573e-10
+ 8.3422851562500001e-05 4.2482519493572964e-10
+ 8.343505859375e-05 4.2475256100502045e-10
+ 8.3447265624999998e-05 4.2468173951608737e-10
+ 8.3459472656249997e-05 4.2459666096075283e-10
+ 8.3471679687500009e-05 4.2448010616874532e-10
+ 8.3483886718750008e-05 4.242745676347303e-10
+ 8.3489990234375007e-05 4.2406762246865748e-10
+ 8.3496093750000006e-05 4.2364446431160585e-10
+ 8.3499145507812499e-05 4.2320637096990359e-10
+ 8.3502197265625006e-05 4.2237081875579266e-10
+ 8.3505249023437499e-05 4.2039912634768696e-10
+ 8.350660679077409e-05 4.184858057925494e-10
+ 8.350699821666087e-05 4.1769354662518729e-10
+ 8.350738964254765e-05 4.1673967866159501e-10
+ 8.3508368207264579e-05 4.1328644574257995e-10
+ 8.3509409502908189e-05 4.0647792025774505e-10
+ 8.3509970598735338e-05 4.0009399586852752e-10
+ 8.3510339629298377e-05 3.9400830485401903e-10
+ 8.3511110323815845e-05 3.7217296598144555e-10
+ 8.3511741481233855e-05 3.3482378565862255e-10
+ 8.3512113084009018e-05 2.9476725253157392e-10
+ 8.3512434193795795e-05 2.3913652951300332e-10
+ 8.3512647097925424e-05 2.1273235713088472e-10
+ 8.3512860002055039e-05 2.1207408791108858e-10
+ 8.351498904335126e-05 2.1185023895337551e-10
+ 8.3527196074601259e-05 2.0757980032582087e-10
+ 8.3539403105851258e-05 1.9827504053149293e-10
+ 8.3551610137101256e-05 1.8447156434439206e-10
+ 8.3563817168351255e-05 1.6696410651490149e-10
+ 8.3576024199601254e-05 1.4676018343964647e-10
+ 8.3588231230851252e-05 1.2502212943217047e-10
+ 8.3600438262101251e-05 1.0300022779102304e-10
+ 8.361264529335125e-05 8.1960799754197404e-11
+ 8.3624852324601248e-05 6.311338755160194e-11
+ 8.3637059355851247e-05 4.7541218733423125e-11
+ 8.3649266387101259e-05 3.6138949326912032e-11
+ 8.3661473418351258e-05 2.9561263935700322e-11
+ 8.3673680449601257e-05 2.8185285811614418e-11
+ 8.3685887480851255e-05 3.2088955187765566e-11
+ 8.3698094512101254e-05 4.1046615499322252e-11
+ 8.3710301543351253e-05 5.4542057385810135e-11
+ 8.3722508574601251e-05 7.1798266491615728e-11
+ 8.373471560585125e-05 9.1822160785597292e-11
+ 8.3746922637101249e-05 1.1346174161334856e-10
+ 8.3759129668351247e-05 1.3547236949090519e-10
+ 8.3771336699601246e-05 1.5658835172212636e-10
+ 8.3783543730851258e-05 1.7559572435646284e-10
+ 8.3795750762101257e-05 1.9140204326212496e-10
+ 8.3807957793351255e-05 2.030991720132836e-10
+ 8.3811009551163748e-05 2.0529687447679853e-10
+ 8.3811314726945e-05 2.0549982177660819e-10
+ 8.3812077666398123e-05 2.0599366009052315e-10
+ 8.3812459136124685e-05 2.062333046850057e-10
+ 8.3812482977982603e-05 2.0624812098499301e-10
+ 8.3812487746354186e-05 2.0625108196291897e-10
+ 8.381249728309734e-05 2.0625700163649109e-10
+ 8.3812498046036802e-05 2.0625747507891284e-10
+ 8.3812499571915699e-05 2.0625842190532621e-10
+ 8.3812499693986021e-05 2.0625849764807365e-10
+ 8.381249993812664e-05 2.0625864913207268e-10
+ 8.3812499957657891e-05 2.0625866125070641e-10
+ 8.3812499996720394e-05 2.0625868548793557e-10
+ 8.3812500074845387e-05 8.3574849775232329e-10
+ 8.3812500152970394e-05 2.8382408459534785e-09
+ 8.3812500934220391e-05 9.7910663945931592e-08
+ 8.3812508051845985e-05 6.9281309170090845e-06
+ 8.3812515169471579e-05 2.3496919613390592e-05
+ 8.3812522287097173e-05 4.8515586154137975e-05
+ 8.3812529404722768e-05 8.0864107426474553e-05
+ 8.3812536522348376e-05 0.0001195688537478285
+ 8.381254363997397e-05 0.00016378325676260678
+ 8.3812550757599564e-05 0.00021277103077073492
+ 8.3812557875225158e-05 0.00026589161027525284
+ 8.3812564992850753e-05 0.00032258751106878353
+ 8.3812572110476347e-05 0.00038237336083026571
+ 8.3812579228101955e-05 0.00044482637875059637
+ 8.3812587807568573e-05 0.00052313156179263198
+ 8.3812596387035219e-05 0.00060422377214069478
+ 8.3812604966501837e-05 0.00068763160407692863
+ 8.3812613545968483e-05 0.00077295453496090106
+ 8.3812622125435101e-05 0.00085985181282763258
+ 8.3812630704901747e-05 0.00094803308914625053
+ 8.3812639284368365e-05 0.0010372505228311898
+ 8.3812647863835011e-05 0.0011272921245865509
+ 8.3812658180770265e-05 0.0012364048498757886
+ 8.3812668497705518e-05 0.0013461799437633384
+ 8.3812678814640772e-05 0.0014563930288477433
+ 8.3812689131576026e-05 0.001566855276772596
+ 8.3812699448511279e-05 0.0016774068636345029
+ 8.3812709765446533e-05 0.001787911643031166
+ 8.3812720082381787e-05 0.0018982528107135616
+ 8.3812730399317041e-05 0.0020083293767566338
+ 8.3812742902012263e-05 0.002141246780886198
+ 8.3812755404707485e-05 0.0022735106700283729
+ 8.3812767907402708e-05 0.0024050029041599369
+ 8.381278041009793e-05 0.0025356196305195535
+ 8.3812792912793139e-05 0.0026652683340791378
+ 8.3812805415488362e-05 0.002793865545581445
+ 8.3812817918183584e-05 0.0029213350620943554
+ 8.3812830420878807e-05 0.0030476065669750823
+ 8.3812845592253881e-05 0.0031991277392290247
+ 8.381286076362897e-05 0.0033486794005026179
+ 8.3812875935004044e-05 0.0034961593179601309
+ 8.3812891106379119e-05 0.0036414711081661105
+ 8.3812906277754207e-05 0.0037845233735065873
+ 8.3812921449129282e-05 0.0039252290818992874
+ 8.3812936620504357e-05 0.0040635051254073566
+ 8.3812954860519568e-05 0.0042264209820281088
+ 8.3812973100534779e-05 0.0043855785109888799
+ 8.381299134054999e-05 0.004540852807539594
+ 8.3813009580565188e-05 0.0046921255232483241
+ 8.3813027820580399e-05 0.004839284756390172
+ 8.381304606059561e-05 0.0049822250059800644
+ 8.3813068199865858e-05 0.0051499118748984281
+ 8.3813090339136107e-05 0.0053110729761570875
+ 8.3813112478406355e-05 0.0054655577982168782
+ 8.3813134617676603e-05 0.0056132299331846198
+ 8.3813161293011328e-05 0.0057819364493443522
+ 8.3813187873095816e-05 0.0059398423573548687
+ 8.3813214453180303e-05 0.0060874136176253622
+ 8.3813248688484348e-05 0.0062620603819550135
+ 8.3813282923788393e-05 0.0064191641307141745
+ 8.3813315356127054e-05 0.0065517091134031152
+ 8.3813347788465716e-05 0.0066683776453289999
+ 8.3813380220804377e-05 0.0067692021882621509
+ 8.3813412653143052e-05 0.0068542763543729904
+ 8.3813445085481714e-05 0.0069237529436825757
+ 8.3813477517820375e-05 0.0069778416850672731
+ 8.3813509950159037e-05 0.0070168067033145008
+ 8.3813542382497698e-05 0.0070409637367341727
+ 8.381356958499815e-05 0.0070500711051410814
+ 8.3813596787498616e-05 0.0070492564131712353
+ 8.3813623989999067e-05 0.0070387804986578604
+ 8.3813651192499519e-05 0.0070189238317284377
+ 8.3813678394999971e-05 0.0069899850256677273
+ 8.3813705597500423e-05 0.0069522793135452206
+ 8.3813732800000875e-05 0.0069061369988542495
+ 8.3813760002501327e-05 0.0068519018883273245
+ 8.3813787205001778e-05 0.0067899297149596706
+ 8.381381440750223e-05 0.0067205865590935169
+ 8.3813841610002696e-05 0.0066442472751925379
+ 8.3813868812503147e-05 0.006561293931672073
+ 8.3813896015003599e-05 0.0064721142708494637
+ 8.3813923217504051e-05 0.0063771001957435066
+ 8.3813950420004503e-05 0.0062766462900859356
+ 8.3813977622504955e-05 0.0061711483775146155
+ 8.3814004825005407e-05 0.0060610021255013743
+ 8.3814032027505872e-05 0.0059466016991306979
+ 8.3814059230006324e-05 0.0058283384693926773
+ 8.3814086432506776e-05 0.0057065997804302861
+ 8.3814115300883513e-05 0.0055740309990659331
+ 8.3814144169260237e-05 0.0054384272991202893
+ 8.3814173037636975e-05 0.0053002282345430132
+ 8.3814201906013712e-05 0.0051598626838551204
+ 8.381423077439045e-05 0.0050177476630414884
+ 8.3814259642767187e-05 0.0048742872442221231
+ 8.3814288511143911e-05 0.0047298715812966012
+ 8.3814317379520649e-05 0.0045848760430473451
+ 8.3814346247897386e-05 0.0044396604535071188
+ 8.3814381135166688e-05 0.0042643637747592994
+ 8.3814416022435991e-05 0.0040898203879790361
+ 8.3814449985506059e-05 0.0039211359224094145
+ 8.3814483948576126e-05 0.0037541355090310092
+ 8.3814517911646181e-05 0.0035892460195200843
+ 8.3814551874716249e-05 0.0034268598627977894
+ 8.3814585837786317e-05 0.0032673350066711841
+ 8.3814627381082829e-05 0.0030765664536155394
+ 8.3814668924379342e-05 0.0028910852643209248
+ 8.3814710467675855e-05 0.0027113416169293153
+ 8.3814752010972368e-05 0.0025377141992044784
+ 8.381480232252311e-05 0.0023360685105670866
+ 8.3814853125173649e-05 0.0021424443576868821
+ 8.3814903927824174e-05 0.001959156496722657
+ 8.3814971607266262e-05 0.0017313192252947558
+ 8.3815039286708336e-05 0.0015222190408349249
+ 8.381509191939657e-05 0.001372431253814393
+ 8.3815144552084817e-05 0.0012336381966261724
+ 8.3815197184773063e-05 0.0011055447342070166
+ 8.381524981746131e-05 0.00098778684645394604
+ 8.3815297809929112e-05 0.00088906516794052203
+ 8.3815345802396913e-05 0.00079823747715313789
+ 8.3815393794864715e-05 0.00071492972227882204
+ 8.3815441787332516e-05 0.00063875107498295779
+ 8.3815489779800318e-05 0.00056929990178360005
+ 8.3815537261554875e-05 0.00050680910974394439
+ 8.381558474330942e-05 0.00045011010916966049
+ 8.3815632225063964e-05 0.00039881145821643485
+ 8.3815679706818522e-05 0.00035252854906615789
+ 8.3815727188573066e-05 0.00031088653907439246
+ 8.3815774670327611e-05 0.0002735227890958723
+ 8.3815824358583372e-05 0.00023862511600889196
+ 8.3815874046839134e-05 0.00020765025205703798
+ 8.3815923735094881e-05 0.00018023763188315632
+ 8.3815973423350643e-05 0.00015604795426756195
+ 8.3816023111606404e-05 0.0001347637411803884
+ 8.3816072799862152e-05 0.00011608953467670693
+ 8.3816127951386084e-05 9.8086983151495662e-05
+ 8.3816183102910016e-05 8.2620379659707852e-05
+ 8.3816238254433935e-05 6.937830638173144e-05
+ 8.3816293405957867e-05 5.8079646203919961e-05
+ 8.3816348557481785e-05 4.8471998343402797e-05
+ 8.3816411640520551e-05 3.9267448447275403e-05
+ 8.3816474723559303e-05 3.1683839518460041e-05
+ 8.3816537806598068e-05 2.5463033689023789e-05
+ 8.381660088963682e-05 2.0382309617297274e-05
+ 8.3816674140146442e-05 1.5662206653736814e-05
+ 8.3816747390656049e-05 1.1971024407425274e-05
+ 8.3816820641165657e-05 9.101093726216712e-06
+ 8.3816905619421588e-05 6.5781195004269459e-06
+ 8.3816990597677534e-05 4.7207090840830405e-06
+ 8.3817093836844789e-05 3.1245246960755978e-06
+ 8.3817198171769427e-05 2.0371887602864823e-06
+ 8.3817302506694052e-05 1.3141391771344707e-06
+ 8.3817426664469177e-05 7.6923430377838728e-07
+ 8.3817550822244289e-05 4.435788450454647e-07
+ 8.381770580080654e-05 2.1851475951109054e-07
+ 8.3817884937131793e-05 9.3708673373505121e-08
+ 8.3818098556602403e-05 3.2883700516734768e-08
+ 8.3818364485722965e-05 8.5309004428172277e-09
+ 8.3818717982712214e-05 1.4552417250701691e-09
+ 8.3819242097564155e-05 3.0578689270965244e-10
+ 8.3820136340120489e-05 2.4569663308855879e-10
+ 8.3822132807185047e-05 2.4259754686171839e-10
+ 8.3823988816858025e-05 2.4182034068072913e-10
+ 8.3826421668443089e-05 2.4138174969930913e-10
+ 8.3828854520028154e-05 2.4076582964276258e-10
+ 8.3831287371613218e-05 2.4012576594620444e-10
+ 8.3833720223198282e-05 2.4057963384973803e-10
+ 8.3836153074783346e-05 2.4092919901400983e-10
+ 8.3838585926368411e-05 2.401872610697499e-10
+ 8.3841018777953475e-05 2.3987554496708928e-10
+ 8.3843451629538539e-05 2.4037942571475707e-10
+ 8.3845767705239787e-05 2.4025247901632375e-10
+ 8.3848819440406725e-05 2.4017887589128354e-10
+ 8.3851871175573663e-05 2.4009951114703349e-10
+ 8.3854922910740602e-05 2.4004351142745323e-10
+ 8.385797464590754e-05 2.4016098617015712e-10
+ 8.3861026381074478e-05 2.4071442426522539e-10
+ 8.3864078116241417e-05 2.3968616681674537e-10
+ 8.3867773618773604e-05 2.4003007462135484e-10
+ 8.3871134288610922e-05 2.4006402385879101e-10
+ 8.3874494958448227e-05 2.4006047129867007e-10
+ 8.387862073169029e-05 2.4005210497337081e-10
+ 8.388274650493234e-05 2.4004042399080182e-10
+ 8.3886872278174403e-05 2.4003044384477591e-10
+ 8.3890998051416467e-05 2.4003749578386358e-10
+ 8.389512382465853e-05 2.4008180521387353e-10
+ 8.3900251138437106e-05 2.4016443526047099e-10
+ 8.3905378452215682e-05 2.3985136550844345e-10
+ 8.3910505765994272e-05 2.3994252727381691e-10
+ 8.3915633079772848e-05 2.4004700010028028e-10
+ 8.3921995979825155e-05 2.4004483697536087e-10
+ 8.3928358879877476e-05 2.3997024527683999e-10
+ 8.3934721779929783e-05 2.3997592655072043e-10
+ 8.3942497256254514e-05 2.4000749931504923e-10
+ 8.3950272732579258e-05 2.4001269631983051e-10
+ 8.3958048208904003e-05 2.3999782508278659e-10
+ 8.3967983441936072e-05 2.3999355892689472e-10
+ 8.3977918674968155e-05 2.4000179472492324e-10
+ 8.3990125706218154e-05 2.4000339716614338e-10
+ 8.4002332737468153e-05 2.3999888202599127e-10
+ 8.4014539768718151e-05 2.3999830525938688e-10
+ 8.402674679996815e-05 2.4000037974237526e-10
+ 8.4038953831218149e-05 2.4000087414852165e-10
+ 8.4051160862468147e-05 2.3999993966201389e-10
+ 8.4063367893718146e-05 2.3999960494882817e-10
+ 8.4075574924968145e-05 2.4000001432309894e-10
+ 8.4087781956218157e-05 2.4000021737723387e-10
+ 8.4099988987468155e-05 2.4000004462513988e-10
+ 8.4112196018718154e-05 2.3999993006727966e-10
+ 8.4124403049968153e-05 2.3999999917748096e-10
+ 8.4136610081218151e-05 2.4000006049017395e-10
+ 8.414881711246815e-05 2.4000003421757239e-10
+ 8.4161024143718149e-05 2.4000000237870328e-10
+ 8.4173231174968147e-05 2.4000001256652595e-10
+ 8.4185438206218146e-05 2.4000002745854788e-10
+ 8.4197645237468145e-05 2.4000002475271839e-10
+ 8.4209852268718157e-05 2.4000001795384735e-10
+ 8.4222059299968156e-05 2.400000173879749e-10
+ 8.4234266331218154e-05 2.4000002070407596e-10
+ 8.4246473362468153e-05 2.4000002067419452e-10
+ 8.4258680393718151e-05 2.4000001976473751e-10
+ 8.427088742496815e-05 2.40000019362722e-10
+ 8.4283094456218149e-05 2.4000002028128461e-10
+ 8.4295301487468147e-05 2.4000002060646208e-10
+ 8.4307508518718146e-05 2.4000002008287723e-10
+ 8.4319715549968145e-05 2.4000001934276911e-10
+ 8.4331922581218143e-05 2.4000001968966948e-10
+ 8.4344129612468156e-05 2.4000002093381111e-10
+ 8.4356336643718154e-05 2.4000001965726013e-10
+ 8.4368543674968153e-05 2.4000001961507071e-10
+ 8.4380750706218152e-05 2.4000002048512451e-10
+ 8.439295773746815e-05 2.4000001998121006e-10
+ 8.4405164768718149e-05 2.400000199764228e-10
+ 8.4417371799968148e-05 2.4000001998665694e-10
+ 8.4429578831218146e-05 2.4000001988395378e-10
+ 8.4441785862468145e-05 2.4000001969840786e-10
+ 8.4453992893718144e-05 2.4000001962628526e-10
+ 8.4466199924968142e-05 2.4000001985975601e-10
+ 8.4478406956218154e-05 2.4000001994562599e-10
+ 8.4490613987468153e-05 2.4000001873790616e-10
+ 8.4502821018718152e-05 2.400000206888198e-10
+ 8.451502804996815e-05 2.4000002115772409e-10
+ 8.4527235081218149e-05 2.4000001926167516e-10
+ 8.4539442112468148e-05 2.4000001865095655e-10
+ 8.4551649143718146e-05 2.4000002024868279e-10
+ 8.4563856174968145e-05 2.4000002062807212e-10
+ 8.4576063206218144e-05 2.4000001971246058e-10
+ 8.4588270237468142e-05 2.4000001913611468e-10
+ 8.4600477268718141e-05 2.4000001939609548e-10
+ 8.4612684299968153e-05 2.4000001928925776e-10
+ 8.4624891331218152e-05 2.4000002036211893e-10
+ 8.463709836246815e-05 2.4000001948566678e-10
+ 8.4649305393718149e-05 2.40000020557049e-10
+ 8.4661512424968148e-05 2.400000203491446e-10
+ 8.4673719456218146e-05 2.4000001961720044e-10
+ 8.4685926487468145e-05 2.400000200808237e-10
+ 8.4698133518718144e-05 2.4000002006495584e-10
+ 8.4710340549968142e-05 2.4000001941755901e-10
+ 8.4722547581218141e-05 2.4000001925514504e-10
+ 8.4734754612468153e-05 2.4000001949494439e-10
+ 8.4746961643718152e-05 2.4000001987457185e-10
+ 8.4759168674968151e-05 2.4000001956535886e-10
+ 8.4771375706218149e-05 2.4000001976899341e-10
+ 8.4783582737468148e-05 2.4000001989767335e-10
+ 8.4795789768718147e-05 2.4000002010421042e-10
+ 8.4807996799968145e-05 2.4000002031692612e-10
+ 8.4820203831218144e-05 2.4000001943796074e-10
+ 8.4832410862468142e-05 2.4000001979057998e-10
+ 8.4844617893718141e-05 2.4000001994141042e-10
+ 8.485682492496814e-05 2.4000001910787902e-10
+ 8.4869031956218152e-05 2.4000002014157438e-10
+ 8.4881238987468151e-05 2.4000002007976212e-10
+ 8.4893446018718149e-05 2.4000001897875313e-10
+ 8.4905653049968148e-05 2.4000002030066949e-10
+ 8.4917860081218147e-05 2.4000002070432142e-10
+ 8.4930067112468145e-05 2.4000001950520541e-10
+ 8.4942274143718144e-05 2.4000001947980057e-10
+ 8.4954481174968143e-05 2.4000002027253361e-10
+ 8.4966688206218141e-05 2.40000020609859e-10
+ 8.497889523746814e-05 2.4000001911322354e-10
+ 8.4991102268718152e-05 2.4000001969739074e-10
+ 8.5003309299968151e-05 2.4000002073053612e-10
+ 8.5015516331218149e-05 2.4000001994814067e-10
+ 8.5027723362468148e-05 2.4000001923239209e-10
+ 8.5039930393718147e-05 2.4000002015288261e-10
+ 8.5052137424968145e-05 2.4000001930210656e-10
+ 8.5064344456218144e-05 2.4000001837686493e-10
+ 8.5076551487468143e-05 2.4000001946449939e-10
+ 8.5088758518718141e-05 2.4000002038326192e-10
+ 8.510096554996814e-05 2.400000203109469e-10
+ 8.5113172581218152e-05 2.400000203952259e-10
+ 8.5125379612468151e-05 2.4000001970496741e-10
+ 8.513758664371815e-05 2.4000001924454606e-10
+ 8.5149793674968148e-05 2.4000001905466872e-10
+ 8.5162000706218147e-05 2.400000204518705e-10
+ 8.5174207737468146e-05 2.4000002011557764e-10
+ 8.5186414768718144e-05 2.4000001946831419e-10
+ 8.5198621799968143e-05 2.4000001925940771e-10
+ 8.5210828831218155e-05 2.4000001980987061e-10
+ 8.5223035862468154e-05 2.4000002089319245e-10
+ 8.5235242893718152e-05 2.4000001973823067e-10
+ 8.5247449924968151e-05 2.4000001879346328e-10
+ 8.525965695621815e-05 2.4000001869932423e-10
+ 8.5271863987468148e-05 2.4000002074828773e-10
+ 8.5284071018718147e-05 2.4000001934026167e-10
+ 8.5296278049968146e-05 2.4000001952115826e-10
+ 8.5308485081218158e-05 2.4000001987859593e-10
+ 8.5320692112468156e-05 2.400000198982881e-10
+ 8.5332899143718155e-05 2.40000018977687e-10
+ 8.5345106174968154e-05 2.4000001970468766e-10
+ 8.5357313206218152e-05 2.4000001969944985e-10
+ 8.5369520237468151e-05 2.4000002027367879e-10
+ 8.538172726871815e-05 2.4000001840031488e-10
+ 8.5393934299968148e-05 2.4000001957318321e-10
+ 8.5406141331218161e-05 2.400000188108562e-10
+ 8.5418348362468159e-05 2.4000002046679305e-10
+ 8.5430555393718158e-05 2.4000001950571268e-10
+ 8.5442762424968157e-05 2.4000001838116472e-10
+ 8.5454969456218155e-05 2.4000001853089837e-10
+ 8.5467176487468154e-05 2.4000002004811227e-10
+ 8.5479383518718153e-05 2.4000001966057371e-10
+ 8.5491590549968151e-05 2.4000001941089245e-10
+ 8.5503797581218163e-05 2.4000001913185568e-10
+ 8.5516004612468162e-05 2.4000001954838558e-10
+ 8.5528211643718161e-05 2.4000001920964592e-10
+ 8.5540418674968159e-05 2.4000001943469307e-10
+ 8.5552625706218158e-05 2.4000001866641258e-10
+ 8.5564832737468157e-05 2.4000002020897109e-10
+ 8.5577039768718155e-05 2.4000001940179987e-10
+ 8.5589246799968154e-05 2.4000001993507329e-10
+ 8.5601453831218166e-05 2.4000002008198123e-10
+ 8.5613660862468165e-05 2.400000198005213e-10
+ 8.5625867893718164e-05 2.4000001916301211e-10
+ 8.5638074924968162e-05 2.4000001960280073e-10
+ 8.5650281956218161e-05 2.4000001963117276e-10
+ 8.5662488987468159e-05 2.400000196254434e-10
+ 8.5674696018718158e-05 2.4000002030623543e-10
+ 8.5686903049968157e-05 2.4000001985486468e-10
+ 8.5699110081218169e-05 2.4000001975560508e-10
+ 8.5711317112468168e-05 2.4000002002563028e-10
+ 8.5723524143718166e-05 2.4000001880683233e-10
+ 8.5735731174968165e-05 2.400000186107882e-10
+ 8.5747938206218164e-05 2.4000002026174485e-10
+ 8.5760145237468162e-05 2.4000001964579944e-10
+ 8.5772352268718161e-05 2.4000001869414737e-10
+ 8.578455929996816e-05 2.4000002024855297e-10
+ 8.5796766331218172e-05 2.4000001886895933e-10
+ 8.580897336246817e-05 2.4000001996539064e-10
+ 8.5821180393718169e-05 2.4000001852201533e-10
+ 8.5833387424968168e-05 2.4000001995376353e-10
+ 8.5845594456218166e-05 2.4000001885033681e-10
+ 8.5857801487468165e-05 2.400000202275795e-10
+ 8.5870008518718164e-05 2.4000001938682899e-10
+ 8.5882215549968162e-05 2.400000185286626e-10
+ 8.5894422581218175e-05 2.4000002021567022e-10
+ 8.5906629612468173e-05 2.4000001929093104e-10
+ 8.5918836643718172e-05 2.4000001945502139e-10
+ 8.5931043674968171e-05 2.4000001849176264e-10
+ 8.5943250706218169e-05 2.4000001899160695e-10
+ 8.5955457737468168e-05 2.4000001908469775e-10
+ 8.5967664768718167e-05 2.4000002021320925e-10
+ 8.5979871799968165e-05 2.4000001986077044e-10
+ 8.5992078831218177e-05 2.4000001985660228e-10
+ 8.6004285862468176e-05 2.4000001982734366e-10
+ 8.6016492893718175e-05 2.4000001909394165e-10
+ 8.6028699924968173e-05 2.4000001971428865e-10
+ 8.6040906956218172e-05 2.4000001921042243e-10
+ 8.6053113987468171e-05 2.400000190589926e-10
+ 8.6065321018718169e-05 2.400000192770844e-10
+ 8.6077528049968168e-05 2.4000001876027354e-10
+ 8.608973508121818e-05 2.4000001963225885e-10
+ 8.6101942112468179e-05 2.4000001898595255e-10
+ 8.6114149143718178e-05 2.4000001876650681e-10
+ 8.6126356174968176e-05 2.4000001955479303e-10
+ 8.6138563206218175e-05 2.400000192149284e-10
+ 8.6150770237468173e-05 2.4000001962818762e-10
+ 8.6162977268718172e-05 2.400000192259498e-10
+ 8.6175184299968171e-05 2.4000001958046752e-10
+ 8.6187391331218183e-05 2.4000001876653049e-10
+ 8.6199598362468182e-05 2.4000001901679062e-10
+ 8.621180539371818e-05 2.4000001929188411e-10
+ 8.6224012424968179e-05 2.4000001878460593e-10
+ 8.6236219456218178e-05 2.4000001895149019e-10
+ 8.6248426487468176e-05 2.4000001953324466e-10
+ 8.6260633518718175e-05 2.4000001930179932e-10
+ 8.6272840549968174e-05 2.4000001867284628e-10
+ 8.6285047581218186e-05 2.4000001876404646e-10
+ 8.6297254612468184e-05 2.4000001844012502e-10
+ 8.6309461643718183e-05 2.4000001847700822e-10
+ 8.6321668674968182e-05 2.4000001848915366e-10
+ 8.633387570621818e-05 2.4000001847211049e-10
+ 8.6346082737468179e-05 2.4000001842583542e-10
+ 8.6358289768718178e-05 2.4000001874485954e-10
+ 8.6370496799968176e-05 2.4000001864470591e-10
+ 8.6382703831218189e-05 2.400000192645186e-10
+ 8.6394910862468187e-05 2.4000001911011029e-10
+ 8.6407117893718186e-05 2.400000189594016e-10
+ 8.6419324924968185e-05 2.4000001834385696e-10
+ 8.6431531956218183e-05 2.4000001923683012e-10
+ 8.6443738987468182e-05 2.4000002008098464e-10
+ 8.6455946018718181e-05 2.400000183211859e-10
+ 8.6468153049968179e-05 2.4000001983070817e-10
+ 8.6480360081218191e-05 2.4000001841550595e-10
+ 8.649256711246819e-05 2.4000001987140726e-10
+ 8.6504774143718189e-05 2.4000001839799459e-10
+ 8.6516981174968187e-05 2.4000001979564812e-10
+ 8.6529188206218186e-05 2.4000001826400317e-10
+ 8.6541395237468185e-05 2.3996544537098469e-10
+ 8.6553602268718183e-05 2.3996256464191007e-10
+ 8.6565809299968182e-05 2.3996062147298765e-10
+ 8.6578016331218194e-05 2.399538992151035e-10
+ 8.6590223362468193e-05 2.3990864356794482e-10
+ 8.6602430393718192e-05 2.3980391697569448e-10
+ 8.661463742496819e-05 2.3960325885649169e-10
+ 8.6620740940593189e-05 2.3930636780140344e-10
+ 8.6626844456218189e-05 2.3825018349924986e-10
+ 8.6629896214030695e-05 2.3664385617022961e-10
+ 8.6632947971843188e-05 2.313460144418538e-10
+ 8.6634473850749435e-05 2.2273712950258841e-10
+ 8.6635999729655695e-05 1.9502932447418286e-10
+ 8.6636991106889201e-05 1.3263414891107653e-10
+ 8.6637269733896247e-05 9.5672269136980181e-11
+ 8.6637548360903307e-05 4.6113023016783446e-11
+ 8.6638098835627975e-05 4.077304569289076e-11
+ 8.6640875273912441e-05 4.2347131994264368e-11
+ 8.665308230516244e-05 4.4733371018365243e-11
+ 8.6665289336412452e-05 5.3058719093237963e-11
+ 8.6677496367662451e-05 6.5249849962529414e-11
+ 8.6689703398912449e-05 8.0586557341896391e-11
+ 8.6701910430162448e-05 9.8186059694000248e-11
+ 8.6714117461412447e-05 1.1703587328666208e-10
+ 8.6726324492662445e-05 1.3605185310399104e-10
+ 8.6738531523912444e-05 1.5414054504639482e-10
+ 8.6750738555162443e-05 1.7026206156240515e-10
+ 8.6762945586412441e-05 1.8348986297121229e-10
+ 8.6775152617662454e-05 1.9306400774952091e-10
+ 8.6787359648912452e-05 1.9843481134517081e-10
+ 8.6799566680162451e-05 1.9929440536940058e-10
+ 8.681177371141245e-05 1.9559438520732841e-10
+ 8.6823980742662448e-05 1.8754853451668201e-10
+ 8.6836187773912447e-05 1.7562047328816539e-10
+ 8.6848394805162445e-05 1.6049694315998822e-10
+ 8.6860601836412458e-05 1.4304826930135124e-10
+ 8.6872808867662456e-05 1.2427827523140709e-10
+ 8.6885015898912455e-05 1.052665328361379e-10
+ 8.6897222930162454e-05 8.7106269937226752e-11
+ 8.6909429961412452e-05 7.0841506734532094e-11
+ 8.6921636992662451e-05 5.7407035899497847e-11
+ 8.693384402391245e-05 4.7574696846103914e-11
+ 8.6936895781724956e-05 4.5750674856066197e-11
+ 8.6937048369615575e-05 4.5666462612461995e-11
+ 8.6937429839342137e-05 4.5458870923120094e-11
+ 8.6937467986314792e-05 4.5438342991126504e-11
+ 8.6937475615709331e-05 4.5434242455099145e-11
+ 8.6937490874498395e-05 4.5426046434154427e-11
+ 8.693749697801401e-05 4.5422769911655126e-11
+ 8.6937499419420273e-05 4.542145960441293e-11
+ 8.6937499604455799e-05 4.5421360302533612e-11
+ 8.6937499974526852e-05 4.5421161701746532e-11
+ 8.6937500714668957e-05 5.7234708751505077e-08
+ 8.6937501454811063e-05 2.3609835104101694e-07
+ 8.693750885623216e-05 8.3378657603255145e-06
+ 8.6937516257653243e-05 2.6804211983519737e-05
+ 8.6937523659074339e-05 5.4212572160978158e-05
+ 8.6937531060495422e-05 8.9333429400249197e-05
+ 8.6937538461916519e-05 0.00013110387761772142
+ 8.6937547512355696e-05 0.00018988604042548046
+ 8.6937556562794872e-05 0.000255812068272275
+ 8.6937565613234063e-05 0.00032768193023753725
+ 8.693757466367324e-05 0.00040448949601993325
+ 8.6937583714112417e-05 0.00048539058840956265
+ 8.6937595044533515e-05 0.00059137048504824714
+ 8.6937606374954613e-05 0.00070151686849491022
+ 8.6937617705375712e-05 0.0008149054011463608
+ 8.693762903579681e-05 0.00093078918228233572
+ 8.6937643214653372e-05 0.0010784080416500865
+ 8.693765739350992e-05 0.0012280520970111633
+ 8.6937671572366482e-05 0.0013789889014004875
+ 8.6937689032396946e-05 0.0015657925325384681
+ 8.6937706492427411e-05 0.0017528666320927736
+ 8.6937723952457875e-05 0.0019395804048633696
+ 8.6937746268477838e-05 0.0021769293571718938
+ 8.6937768584497815e-05 0.0024120996791847497
+ 8.6937790900517778e-05 0.0026444704336099976
+ 8.6937819090217254e-05 0.0029332237971511233
+ 8.6937847279916716e-05 0.0032158629328255771
+ 8.6937875469616192e-05 0.0034916668520790159
+ 8.6937903659315655e-05 0.0037599988278231356
+ 8.6937931849015131e-05 0.0040202830355208904
+ 8.6937960038714607e-05 0.0042719918874605982
+ 8.693798822841407e-05 0.0045146394015623476
+ 8.6938019414106485e-05 0.0047719795450323309
+ 8.6938050599798887e-05 0.0050171295125712645
+ 8.6938081785491303e-05 0.0052495906087394869
+ 8.6938112971183718e-05 0.0054689190353913904
+ 8.6938150418414351e-05 0.0057143885297757718
+ 8.693818786564497e-05 0.0059397992525804574
+ 8.6938225312875603e-05 0.006144702220679193
+ 8.6938270844195812e-05 0.0063657430322260553
+ 8.6938316375516036e-05 0.0065556175023236875
+ 8.6938361906836246e-05 0.0067142112673811444
+ 8.6938407438156456e-05 0.0068416534980290083
+ 8.6938441084028121e-05 0.0069160175765833089
+ 8.6938474729899787e-05 0.0069737900261410465
+ 8.6938508375771452e-05 0.0070152594941248576
+ 8.6938542021643118e-05 0.0070407746969006688
+ 8.6938575667514783e-05 0.007050740823760393
+ 8.6938609313386449e-05 0.0070456156939712805
+ 8.6938642959258114e-05 0.007025905702338452
+ 8.693867660512978e-05 0.0069921615895264296
+ 8.6938710251001445e-05 0.0069449740739896257
+ 8.6938736870668162e-05 0.006898526876910809
+ 8.6938763490334865e-05 0.0068443802044164921
+ 8.6938790110001581e-05 0.0067828688534493494
+ 8.6938816729668285e-05 0.0067143369242957376
+ 8.6938843349335001e-05 0.0066391364097472113
+ 8.6938869969001704e-05 0.0065576257964309343
+ 8.6938896588668421e-05 0.0064701686843428533
+ 8.6938923208335138e-05 0.0063771324303375145
+ 8.6938949828001841e-05 0.0062788868210215225
+ 8.6938976447668558e-05 0.0061758027801676225
+ 8.6939003067335261e-05 0.0060682511154162089
+ 8.6939029687001977e-05 0.0059566013086644297
+ 8.693905630666868e-05 0.0058412203541628417
+ 8.6939082926335397e-05 0.0057224716479485063
+ 8.69391095460021e-05 0.0056007139318451742
+ 8.6939136165668817e-05 0.0054763002948580381
+ 8.6939162785335534e-05 0.0053495772343856614
+ 8.6939189405002237e-05 0.0052208837792675896
+ 8.6939216024668953e-05 0.0050905506764474901
+ 8.6939239404935237e-05 0.0049749804171373225
+ 8.693926278520152e-05 0.0048586054363550972
+ 8.6939286165467816e-05 0.0047416314482211135
+ 8.69393095457341e-05 0.0046242577652878883
+ 8.6939332926000396e-05 0.0045066770343838705
+ 8.6939356306266679e-05 0.0043890750025309139
+ 8.6939379686532962e-05 0.0042716303126259531
+ 8.6939403066799259e-05 0.0041545143284691553
+ 8.6939426447065542e-05 0.0040378909886185305
+ 8.6939449827331825e-05 0.0039219166884552218
+ 8.6939473207598122e-05 0.0038067401897542695
+ 8.6939496587864405e-05 0.0036925025569730643
+ 8.6939519968130702e-05 0.0035793371193940525
+ 8.6939543348396985e-05 0.0034673694581895016
+ 8.6939566728663268e-05 0.0033567174174145066
+ 8.6939590108929565e-05 0.0032474911378798247
+ 8.6939613489195848e-05 0.0031397931128086067
+ 8.6939636869462131e-05 0.0030337182641405314
+ 8.6939660249728428e-05 0.0029293540383132049
+ 8.6939683629994711e-05 0.0028267805203238136
+ 8.6939707010261008e-05 0.0027260705648536779
+ 8.6939735591237528e-05 0.0026055855381113117
+ 8.6939764172214048e-05 0.0024880893416989024
+ 8.6939792753190569e-05 0.0023736731389782805
+ 8.6939821334167103e-05 0.0022624136400195647
+ 8.6939849915143623e-05 0.0021543736566158275
+ 8.6939886199806222e-05 0.0020219271947776738
+ 8.6939925453373388e-05 0.0018846580284455387
+ 8.6939946977215274e-05 0.0018120618774395494
+ 8.6939973696714703e-05 0.0017245821083065652
+ 8.6940000416214146e-05 0.0016400258203643724
+ 8.6940027135713575e-05 0.0015583844444338579
+ 8.6940053855213018e-05 0.0014796423351417674
+ 8.6940080574712448e-05 0.0014037772468436488
+ 8.694010729421189e-05 0.0013307608065583204
+ 8.694013401371132e-05 0.0012605589819463642
+ 8.6940160733210763e-05 0.0011931325425094006
+ 8.6940187452710192e-05 0.0011284375123336611
+ 8.6940214172209635e-05 0.0010664256128491564
+ 8.6940240891709064e-05 0.0010070446942234952
+ 8.6940262548859624e-05 0.00096080661895637035
+ 8.6940284206010171e-05 0.0009162294538821239
+ 8.6940305863160731e-05 0.00087328092606094238
+ 8.6940327520311278e-05 0.00083192771752318962
+ 8.6940349177461824e-05 0.00079213559354230647
+ 8.6940370834612385e-05 0.00075386952625768001
+ 8.6940392491762931e-05 0.00071709381353394315
+ 8.6940414148913478e-05 0.00068177219296354193
+ 8.6940435806064038e-05 0.00064786795094112185
+ 8.6940457463214585e-05 0.00061534402675914772
+ 8.6940479120365131e-05 0.00058416311167918647
+ 8.6940496765399613e-05 0.00055972551886932095
+ 8.6940514410434081e-05 0.00053613426244406741
+ 8.6940532055468562e-05 0.00051336904748169171
+ 8.694054970050303e-05 0.00049140960981622914
+ 8.6940567345537511e-05 0.00047023574348777509
+ 8.6940584990571979e-05 0.00044982732676715286
+ 8.6940602635606461e-05 0.00043016434677204047
+ 8.6940620280640928e-05 0.00041122692269401575
+ 8.6940637925675396e-05 0.00039299532765819798
+ 8.6940655570709878e-05 0.00037545000923921415
+ 8.6940673215744345e-05 0.00035857160865911174
+ 8.6940690860778827e-05 0.00034234097869457157
+ 8.6940708505813295e-05 0.00032673920032235228
+ 8.6940726150847776e-05 0.00031174759813332067
+ 8.6940743795882244e-05 0.00029734775454669758
+ 8.6940761440916725e-05 0.00028352152285727745
+ 8.6940779085951193e-05 0.0002702510391493668
+ 8.6940796730985661e-05 0.00025751873311203796
+ 8.6940814376020142e-05 0.00024530733779101174
+ 8.694083202105461e-05 0.00023359989831307307
+ 8.6940849666089092e-05 0.00022237977961939102
+ 8.6940867311123559e-05 0.00021163067324446447
+ 8.6940884956158041e-05 0.00020133660317765155
+ 8.6940902601192509e-05 0.00019148193084437179
+ 8.6940920246226977e-05 0.00018205135924409671
+ 8.6940937891261458e-05 0.00017302993628217709
+ 8.6940955536295926e-05 0.00016440305733239472
+ 8.6940973181330407e-05 0.00015615646706688136
+ 8.6940990826364875e-05 0.00014827626058972067
+ 8.6941008471399356e-05 0.00014074888391014853
+ 8.6941026116433824e-05 0.00013356113379079491
+ 8.6941043761468292e-05 0.00012670015700587552
+ 8.6941061406502773e-05 0.00012015344904364461
+ 8.6941079051537241e-05 0.00011390885228677083
+ 8.6941096696571723e-05 0.00010795455370359766
+ 8.694111434160619e-05 0.00010227908208250491
+ 8.6941131986640672e-05 9.687130484080241e-05
+ 8.694114963167514e-05 9.1720424438765868e-05
+ 8.6941167276709621e-05 8.6815974428572379e-05
+ 8.6941184921744089e-05 8.2147815167013072e-05
+ 8.6941202566778557e-05 7.7706129219957601e-05
+ 8.6941220211813038e-05 7.3481416485622882e-05
+ 8.6941237856847506e-05 6.9464489062760908e-05
+ 8.6941255501881987e-05 6.5646465888930612e-05
+ 8.6941273146916455e-05 6.2018767173060703e-05
+ 8.6941290791950937e-05 5.8573108645546759e-05
+ 8.6941308436985404e-05 5.5301495648160228e-05
+ 8.6941326082019886e-05 5.2196217085081444e-05
+ 8.6941343727054354e-05 4.9249839255407143e-05
+ 8.6941361372088822e-05 4.6455199586526805e-05
+ 8.6941379017123303e-05 4.3805400286814076e-05
+ 8.6941396662157771e-05 4.1293801935142287e-05
+ 8.6941414307192252e-05 3.8914017023807698e-05
+ 8.694143195222672e-05 3.6659903470533496e-05
+ 8.6941449597261201e-05 3.4525558114332587e-05
+ 8.6941467242295669e-05 3.2505310209129923e-05
+ 8.6941484887330137e-05 3.0593714928186798e-05
+ 8.6941502532364618e-05 2.878554689153125e-05
+ 8.6941520177399086e-05 2.7075793727781893e-05
+ 8.6941537822433568e-05 2.5459649680957857e-05
+ 8.6941555467468036e-05 2.3932509272096093e-05
+ 8.6941573112502517e-05 2.2489961024749567e-05
+ 8.6941590757536985e-05 2.1127781262716843e-05
+ 8.6941608402571453e-05 1.9841927987655173e-05
+ 8.6941626047605934e-05 1.8628534843556469e-05
+ 8.6941643692640402e-05 1.7483905174418017e-05
+ 8.6941661337674883e-05 1.6404506180818473e-05
+ 8.6941682620107581e-05 1.5184596516820046e-05
+ 8.6941702745281692e-05 1.4108722156777394e-05
+ 8.6941722870455788e-05 1.3103783271809466e-05
+ 8.6941742995629899e-05 1.2165512099818384e-05
+ 8.6941763120803995e-05 1.1289867233639744e-05
+ 8.6941783245978092e-05 1.0473023791237365e-05
+ 8.6941803371152202e-05 9.711363860421274e-06
+ 8.6941823496326299e-05 9.0014672215583367e-06
+ 8.6941843621500409e-05 8.3401023506671107e-06
+ 8.6941863746674506e-05 7.7242177042852387e-06
+ 8.6941888110746138e-05 7.0353574872189284e-06
+ 8.6941912474817757e-05 6.4041509733236313e-06
+ 8.694193683888939e-05 5.8261375978047346e-06
+ 8.6941961202961022e-05 5.2971679183216326e-06
+ 8.6941985567032641e-05 4.8133849648221628e-06
+ 8.6942009931104274e-05 4.3712064413582404e-06
+ 8.6942034295175907e-05 3.9673077642003495e-06
+ 8.6942058659247526e-05 3.5986059186122073e-06
+ 8.6942083023319158e-05 3.2622441148827113e-06
+ 8.6942107387390777e-05 2.955577222710442e-06
+ 8.6942136719683584e-05 2.6223173518557521e-06
+ 8.6942166051976377e-05 2.3246430183300364e-06
+ 8.694219538426917e-05 2.0589938235170389e-06
+ 8.6942224716561963e-05 1.8221375097881734e-06
+ 8.6942254048854757e-05 1.6111428978970881e-06
+ 8.694228338114755e-05 1.4233547079677823e-06
+ 8.6942312713440343e-05 1.2563701699769522e-06
+ 8.6942342045733136e-05 1.1080173307665688e-06
+ 8.69423778480292e-05 9.4935328593955194e-07
+ 8.6942412335454635e-05 8.1703614317247063e-07
+ 8.6942446822880069e-05 7.0231034037170861e-07
+ 8.6942481310305504e-05 6.0295931014601184e-07
+ 8.6942515797730938e-05 5.1702814794412422e-07
+ 8.6942557828321223e-05 4.2796498791424164e-07
+ 8.6942599858911494e-05 3.5358466304975593e-07
+ 8.6942641889501779e-05 2.9157919961691281e-07
+ 8.694268392009205e-05 2.3998333476715486e-07
+ 8.6942725950682335e-05 1.9712710629082681e-07
+ 8.6942777518503434e-05 1.5442331314774624e-07
+ 8.6942828186666485e-05 1.2110746118199679e-07
+ 8.6942878854829551e-05 9.4668212428266369e-08
+ 8.6942929522992602e-05 7.3741045625230226e-08
+ 8.6942993215143467e-05 5.3572482382509411e-08
+ 8.6943056907294331e-05 3.8650410566722333e-08
+ 8.6943120599445196e-05 2.7655607125139506e-08
+ 8.6943198945610729e-05 1.80624388894615e-08
+ 8.69432786576497e-05 1.1455385675920075e-08
+ 8.6943358369688672e-05 7.0279116712338033e-09
+ 8.6943461292370768e-05 3.42722610432318e-09
+ 8.6943569508909823e-05 1.2415251844169095e-09
+ 8.6943701914804448e-05 -1.7423168879043324e-10
+ 8.694384706503019e-05 -9.0046498724308251e-10
+ 8.6944034315235698e-05 -1.2675598336250834e-09
+ 8.6944255865010439e-05 -1.390661486095478e-09
+ 8.6944554034092516e-05 -1.4079464626524889e-09
+ 8.6944998769870898e-05 -1.3781166774969621e-09
+ 8.6945805003989007e-05 -1.313948994893242e-09
+ 8.6946711764368328e-05 -1.2450592154006523e-09
+ 8.6947737475686455e-05 -1.1711746826522686e-09
+ 8.6948801143402345e-05 -1.0985374417948889e-09
+ 8.6949944764949552e-05 -1.0244977902794022e-09
+ 8.6952231646278917e-05 -8.876839903243166e-10
+ 8.6954182681216665e-05 -7.8153991862173163e-10
+ 8.6956291228517253e-05 -6.7660226349856925e-10
+ 8.6958581467436175e-05 -5.7299433820914436e-10
+ 8.6960926666850033e-05 -4.7698621811411996e-10
+ 8.696327186626389e-05 -3.901690868650475e-10
+ 8.6965590537179641e-05 -3.1248869476676087e-10
+ 8.6968474569484294e-05 -2.2600941125466692e-10
+ 8.6971358601788934e-05 -1.4953972152878652e-10
+ 8.6974242634093587e-05 -8.1909642546355165e-11
+ 8.697712666639824e-05 -2.2097231394821104e-11
+ 8.698001069870288e-05 3.0804763949844941e-11
+ 8.6982894731007533e-05 7.7599184420572088e-11
+ 8.6985778763312187e-05 1.1899177680085989e-10
+ 8.6989342797663604e-05 1.6360497315690482e-10
+ 8.6992906832015021e-05 2.0194460469335925e-10
+ 8.6996470866366438e-05 2.3489304324568193e-10
+ 8.7000034900717869e-05 2.6320792465228799e-10
+ 8.7003598935069286e-05 2.8754418863776942e-10
+ 8.7007899961127365e-05 3.124003450031708e-10
+ 8.7012200987185458e-05 3.3310188136055884e-10
+ 8.7016502013243551e-05 3.5034335018174361e-10
+ 8.7020803039301631e-05 3.6470346013268147e-10
+ 8.7025104065359724e-05 3.7666442373221598e-10
+ 8.7030502505986988e-05 3.8888313831481749e-10
+ 8.7035900946614252e-05 3.9859542479219459e-10
+ 8.7041299387241529e-05 4.0629545583254085e-10
+ 8.7046697827868793e-05 4.1242659596079512e-10
+ 8.705346824765748e-05 4.1836450212166619e-10
+ 8.7060238667446168e-05 4.228142873871682e-10
+ 8.7067009087234856e-05 4.2614500842071573e-10
+ 8.7075385304343961e-05 4.2912633403108892e-10
+ 8.7083761521453081e-05 4.3120345772378355e-10
+ 8.7092137738562186e-05 4.3264838822889765e-10
+ 8.7103043385488666e-05 4.3388610175178318e-10
+ 8.7113949032415145e-05 4.3464666000495187e-10
+ 8.7126156063665143e-05 4.3514763453961883e-10
+ 8.7138363094915142e-05 4.3542384097085643e-10
+ 8.7150570126165141e-05 4.3556624282357159e-10
+ 8.7162777157415139e-05 4.3562884855868211e-10
+ 8.7174984188665138e-05 4.3564390919099658e-10
+ 8.7187191219915137e-05 4.3563071731303817e-10
+ 8.7199398251165135e-05 4.3560072832369711e-10
+ 8.7211605282415148e-05 4.3556071800624522e-10
+ 8.7223812313665146e-05 4.3551473285478916e-10
+ 8.7236019344915145e-05 4.3546520640556509e-10
+ 8.7248226376165144e-05 4.3541358487496968e-10
+ 8.7260433407415142e-05 4.3536071753580087e-10
+ 8.7272640438665141e-05 4.353071102954193e-10
+ 8.728484746991514e-05 4.3525307030070124e-10
+ 8.7297054501165152e-05 4.3519878102624261e-10
+ 8.730926153241515e-05 4.3514434891989702e-10
+ 8.7321468563665149e-05 4.3508983678706616e-10
+ 8.7333675594915148e-05 4.3503528333983576e-10
+ 8.7345882626165146e-05 4.3498071205926307e-10
+ 8.7358089657415145e-05 4.3492613633167183e-10
+ 8.7370296688665144e-05 4.348715638520445e-10
+ 8.7382503719915142e-05 4.3481699946235471e-10
+ 8.7394710751165141e-05 4.3476244620745766e-10
+ 8.7406917782415153e-05 4.3470790578886986e-10
+ 8.7419124813665152e-05 4.3465337912630206e-10
+ 8.743133184491515e-05 4.3459886680952396e-10
+ 8.7443538876165149e-05 4.3454436923774573e-10
+ 8.7455745907415148e-05 4.3448988663097442e-10
+ 8.7467952938665146e-05 4.3443541909242035e-10
+ 8.7480159969915145e-05 4.3438096668679938e-10
+ 8.7492367001165157e-05 4.3432652946422885e-10
+ 8.7499999999999999e-05 4.3429323819786375e-10
+ 8.7512207031249998e-05 4.3423882549145797e-10
+ 8.7524414062499996e-05 4.3418442800650571e-10
+ 8.7536621093749995e-05 4.3413004574565444e-10
+ 8.7548828124999994e-05 4.3407567870875607e-10
+ 8.7561035156249992e-05 4.3402132689399754e-10
+ 8.7573242187500005e-05 4.3396699029857563e-10
+ 8.7585449218750003e-05 4.3391266891909689e-10
+ 8.7597656250000002e-05 4.338583627518177e-10
+ 8.7609863281250001e-05 4.338040717927861e-10
+ 8.7622070312499999e-05 4.3374979603792648e-10
+ 8.7634277343749998e-05 4.3369553548309005e-10
+ 8.7646484374999997e-05 4.3364129012408513e-10
+ 8.7658691406249995e-05 4.3358705995669485e-10
+ 8.7670898437499994e-05 4.3353284497668784e-10
+ 8.7683105468749992e-05 4.3347864517982436e-10
+ 8.7695312500000005e-05 4.3342446056186068e-10
+ 8.7707519531250003e-05 4.3337029111855061e-10
+ 8.7719726562500002e-05 4.3331613684564742e-10
+ 8.7731933593750001e-05 4.3326199773890431e-10
+ 8.7744140624999999e-05 4.3320787379407488e-10
+ 8.7756347656249998e-05 4.3315376500691365e-10
+ 8.7768554687499997e-05 4.3309967137317592e-10
+ 8.7780761718749995e-05 4.3304559288861817e-10
+ 8.7792968749999994e-05 4.3299152954899793e-10
+ 8.7805175781249993e-05 4.3293748135007384e-10
+ 8.7817382812500005e-05 4.3288344828760572e-10
+ 8.7829589843750003e-05 4.3282943035735457e-10
+ 8.7841796875000002e-05 4.3277542755508266e-10
+ 8.7854003906250001e-05 4.327214398765532e-10
+ 8.7866210937499999e-05 4.3266746731753079e-10
+ 8.7878417968749998e-05 4.3261350987378112e-10
+ 8.7890624999999997e-05 4.3255956754107106e-10
+ 8.7902832031249995e-05 4.3250564031516869e-10
+ 8.7915039062499994e-05 4.324517281918434e-10
+ 8.7927246093749993e-05 4.3239783116686546e-10
+ 8.7939453125000005e-05 4.3234394923600652e-10
+ 8.7951660156250004e-05 4.3229008239503964e-10
+ 8.7963867187500002e-05 4.322362306397386e-10
+ 8.7976074218750001e-05 4.3218239396587857e-10
+ 8.798828125e-05 4.3212857236923607e-10
+ 8.8000488281249998e-05 4.3207476584558855e-10
+ 8.8012695312499997e-05 4.3202097439071481e-10
+ 8.8024902343749996e-05 4.3196719800039462e-10
+ 8.8037109374999994e-05 4.3191343667040926e-10
+ 8.8049316406249993e-05 4.3185969039654094e-10
+ 8.8061523437500005e-05 4.3180595917457319e-10
+ 8.8073730468750004e-05 4.3175224300029046e-10
+ 8.8085937500000002e-05 4.3169854186947872e-10
+ 8.8098144531250001e-05 4.3164485577792515e-10
+ 8.81103515625e-05 4.3159118472141752e-10
+ 8.8122558593749998e-05 4.315375286957455e-10
+ 8.8134765624999997e-05 4.3148388769669956e-10
+ 8.8146972656249996e-05 4.3143026172007142e-10
+ 8.8159179687499994e-05 4.3137665076165393e-10
+ 8.8171386718749993e-05 4.3132305481724119e-10
+ 8.8183593750000005e-05 4.3126947388262849e-10
+ 8.8195800781250004e-05 4.3121590795361226e-10
+ 8.8208007812500002e-05 4.3116235702599014e-10
+ 8.8220214843750001e-05 4.311088210955608e-10
+ 8.8232421875e-05 4.3105530015812432e-10
+ 8.8244628906249998e-05 4.3100179420948178e-10
+ 8.8256835937499997e-05 4.3094830324543561e-10
+ 8.8269042968749996e-05 4.3089482726178914e-10
+ 8.8281249999999994e-05 4.3084136625434698e-10
+ 8.8293457031249993e-05 4.3078792021891527e-10
+ 8.8305664062500005e-05 4.3073448915130076e-10
+ 8.8317871093750004e-05 4.3068107304731183e-10
+ 8.8330078125000003e-05 4.3062767190275767e-10
+ 8.8342285156250001e-05 4.3057428571344897e-10
+ 8.83544921875e-05 4.305209144751974e-10
+ 8.8366699218749999e-05 4.3046755818381573e-10
+ 8.8378906249999997e-05 4.3041421683511815e-10
+ 8.8391113281249996e-05 4.3036089042491982e-10
+ 8.8403320312499994e-05 4.3030757894903721e-10
+ 8.8415527343749993e-05 4.3025428240328784e-10
+ 8.8427734375000005e-05 4.3020100078349046e-10
+ 8.8439941406250004e-05 4.3014773408546503e-10
+ 8.8452148437500003e-05 4.3009448230503257e-10
+ 8.8464355468750001e-05 4.3004124543801536e-10
+ 8.84765625e-05 4.2998802348023685e-10
+ 8.8488769531249999e-05 4.2993481642752165e-10
+ 8.8500976562499997e-05 4.298816242756955e-10
+ 8.8513183593749996e-05 4.2982844702058526e-10
+ 8.8525390624999995e-05 4.2977528465801911e-10
+ 8.8537597656249993e-05 4.2972213718382639e-10
+ 8.8549804687500005e-05 4.296690045938374e-10
+ 8.8562011718750004e-05 4.2961588688388387e-10
+ 8.8574218750000003e-05 4.2956278404979846e-10
+ 8.8586425781250001e-05 4.2950969608741529e-10
+ 8.85986328125e-05 4.2945662299256918e-10
+ 8.8610839843749999e-05 4.2940356476109669e-10
+ 8.8623046874999997e-05 4.2935052138883517e-10
+ 8.8635253906249996e-05 4.2929749287162315e-10
+ 8.8647460937499995e-05 4.2924447920530045e-10
+ 8.8659667968749993e-05 4.2919148038570803e-10
+ 8.8671874999999992e-05 4.2913849640868801e-10
+ 8.8684082031250004e-05 4.2908552727008359e-10
+ 8.8696289062500003e-05 4.2903257296573924e-10
+ 8.8708496093750002e-05 4.2897963349150058e-10
+ 8.8720703125e-05 4.2892670884321429e-10
+ 8.8732910156249999e-05 4.288737990167283e-10
+ 8.8745117187499998e-05 4.2882090400789185e-10
+ 8.8757324218749996e-05 4.2876802381255504e-10
+ 8.8769531249999995e-05 4.2871515842656934e-10
+ 8.8781738281249993e-05 4.2866230784578723e-10
+ 8.8793945312499992e-05 4.2860947206606246e-10
+ 8.8806152343750004e-05 4.2855665108325002e-10
+ 8.8818359375000003e-05 4.2850384489320595e-10
+ 8.8830566406250002e-05 4.2845105349178732e-10
+ 8.88427734375e-05 4.2839827687485269e-10
+ 8.8854980468749999e-05 4.2834551503826145e-10
+ 8.8867187499999998e-05 4.2829276797787439e-10
+ 8.8879394531249996e-05 4.2824003568955333e-10
+ 8.8891601562499995e-05 4.2818731816916134e-10
+ 8.8903808593749994e-05 4.2813461541256231e-10
+ 8.8916015624999992e-05 4.2808192741562203e-10
+ 8.8928222656249991e-05 4.2802925417420679e-10
+ 8.8940429687500003e-05 4.2797659568418397e-10
+ 8.8952636718750002e-05 4.2792395194142275e-10
+ 8.896484375e-05 4.2787132294179297e-10
+ 8.8977050781249999e-05 4.2781870868116553e-10
+ 8.8989257812499998e-05 4.2776610915541303e-10
+ 8.9001464843749996e-05 4.2771352436040875e-10
+ 8.9013671874999995e-05 4.2766095429202714e-10
+ 8.9025878906249994e-05 4.2760839894614423e-10
+ 8.9038085937499992e-05 4.2755585831863669e-10
+ 8.9050292968749991e-05 4.2750333240538267e-10
+ 8.9062500000000003e-05 4.2745082120226136e-10
+ 8.9074707031250002e-05 4.2739832470515305e-10
+ 8.9086914062500001e-05 4.273458429099393e-10
+ 8.9099121093749999e-05 4.2729337581250278e-10
+ 8.9111328124999998e-05 4.2724092340872732e-10
+ 8.9123535156249996e-05 4.2718848569449787e-10
+ 8.9135742187499995e-05 4.2713606266570053e-10
+ 8.9147949218749994e-05 4.2708365431822263e-10
+ 8.9160156249999992e-05 4.270312606479525e-10
+ 8.9172363281249991e-05 4.2697888165077988e-10
+ 8.918457031249999e-05 4.2692651732259529e-10
+ 8.9196777343750002e-05 4.2687416765929084e-10
+ 8.9208984375000001e-05 4.2682183265675928e-10
+ 8.9221191406249999e-05 4.2676951231089505e-10
+ 8.9233398437499998e-05 4.2671720661759342e-10
+ 8.9245605468749997e-05 4.2666491557275079e-10
+ 8.9257812499999995e-05 4.2661263917226478e-10
+ 8.9270019531249994e-05 4.265603774120343e-10
+ 8.9282226562499993e-05 4.265081302879591e-10
+ 8.9294433593749991e-05 4.2645589779594043e-10
+ 8.930664062499999e-05 4.2640367993188038e-10
+ 8.9318847656249989e-05 4.2635147669168246e-10
+ 8.9331054687500001e-05 4.2629928807125108e-10
+ 8.9343261718749999e-05 4.2624711406649186e-10
+ 8.9355468749999998e-05 4.2619495467331169e-10
+ 8.9367675781249997e-05 4.2614280988761856e-10
+ 8.9379882812499995e-05 4.2609067970532156e-10
+ 8.9392089843749994e-05 4.2603856412233079e-10
+ 8.9404296874999993e-05 4.2598646313455786e-10
+ 8.9416503906249991e-05 4.2593437673791515e-10
+ 8.942871093749999e-05 4.2588230492831644e-10
+ 8.9440917968749989e-05 4.2583024770167654e-10
+ 8.9453124999999987e-05 4.2577820505391141e-10
+ 8.946533203125e-05 4.2572617698093814e-10
+ 8.9477539062499998e-05 4.2567416347867499e-10
+ 8.9489746093749997e-05 4.2562216454304139e-10
+ 8.9501953124999995e-05 4.2557018016995789e-10
+ 8.9514160156249994e-05 4.2551821035534623e-10
+ 8.9526367187499993e-05 4.2546625509512913e-10
+ 8.9538574218749991e-05 4.254143143852306e-10
+ 8.955078124999999e-05 4.2536238822157581e-10
+ 8.9562988281249989e-05 4.2531047660009089e-10
+ 8.9575195312499987e-05 4.2525857951670346e-10
+ 8.958740234375e-05 4.252066969673418e-10
+ 8.9599609374999998e-05 4.2515482894793579e-10
+ 8.9611816406249997e-05 4.2510297545441604e-10
+ 8.9624023437499996e-05 4.2505113648271467e-10
+ 8.9636230468749994e-05 4.2499931202876474e-10
+ 8.9648437499999993e-05 4.2494750208850055e-10
+ 8.9660644531249992e-05 4.248957066578573e-10
+ 8.967285156249999e-05 4.2482519493572964e-10
+ 8.9685058593749989e-05 4.2475256100502045e-10
+ 8.9697265624999988e-05 4.2468173951608737e-10
+ 8.9709472656249986e-05 4.2459666096075283e-10
+ 8.9721679687499998e-05 4.2448010616874532e-10
+ 8.9733886718749997e-05 4.242745676347303e-10
+ 8.9739990234374996e-05 4.2406762246865748e-10
+ 8.9746093749999996e-05 4.2364446431160585e-10
+ 8.9749145507812489e-05 4.2320637096990359e-10
+ 8.9752197265624995e-05 4.2237081875579266e-10
+ 8.9755249023437488e-05 4.2039912634768696e-10
+ 8.975660679077408e-05 4.184858057925494e-10
+ 8.9756998216660859e-05 4.1769354662518729e-10
+ 8.9757389642547639e-05 4.1673967866159501e-10
+ 8.9758368207264568e-05 4.1328644574257995e-10
+ 8.9759409502908178e-05 4.0647792025774505e-10
+ 8.9759970598735328e-05 4.0009399586852752e-10
+ 8.9760339629298366e-05 3.9400830485401903e-10
+ 8.9761110323815835e-05 3.7217296598144555e-10
+ 8.9761741481233844e-05 3.3482378565862255e-10
+ 8.9762113084009007e-05 2.9476725253157392e-10
+ 8.9762434193795784e-05 2.3913652951300332e-10
+ 8.9762647097925413e-05 2.1273235713088472e-10
+ 8.9762860002055029e-05 2.1207408791108858e-10
+ 8.976498904335125e-05 2.1185023895337551e-10
+ 8.9777196074601248e-05 2.0757980032582087e-10
+ 8.9789403105851247e-05 1.9827504053149293e-10
+ 8.9801610137101246e-05 1.8447156434439206e-10
+ 8.9813817168351244e-05 1.6696410651490149e-10
+ 8.9826024199601243e-05 1.4676018343964647e-10
+ 8.9838231230851242e-05 1.2502212943217047e-10
+ 8.985043826210124e-05 1.0300022779102304e-10
+ 8.9862645293351239e-05 8.1960799754197404e-11
+ 8.9874852324601238e-05 6.311338755160194e-11
+ 8.9887059355851236e-05 4.7541218733423125e-11
+ 8.9899266387101249e-05 3.6138949326912032e-11
+ 8.9911473418351247e-05 2.9561263935700322e-11
+ 8.9923680449601246e-05 2.8185285811614418e-11
+ 8.9935887480851245e-05 3.2088955187765566e-11
+ 8.9948094512101243e-05 4.1046615499322252e-11
+ 8.9960301543351242e-05 5.4542057385810135e-11
+ 8.997250857460124e-05 7.1798266491615728e-11
+ 8.9984715605851239e-05 9.1822160785597292e-11
+ 8.9996922637101238e-05 1.1346174161334856e-10
+ 9.0009129668351236e-05 1.3547236949090519e-10
+ 9.0021336699601235e-05 1.5658835172212636e-10
+ 9.0033543730851247e-05 1.7559572435646284e-10
+ 9.0045750762101246e-05 1.9140204326212496e-10
+ 9.0057957793351245e-05 2.030991720132836e-10
+ 9.0061009551163738e-05 2.0529687447679853e-10
+ 9.006131472694499e-05 2.0549982177660819e-10
+ 9.0062077666398113e-05 2.0599366009052315e-10
+ 9.0062459136124674e-05 2.062333046850057e-10
+ 9.0062482977982592e-05 2.0624812098499301e-10
+ 9.0062487746354176e-05 2.0625108196291897e-10
+ 9.0062497283097329e-05 2.0625700163649109e-10
+ 9.0062498046036791e-05 2.0625747507891284e-10
+ 9.0062499571915688e-05 2.0625842190532621e-10
+ 9.0062499693986011e-05 2.0625849764807365e-10
+ 9.0062499938126629e-05 2.0625864913207268e-10
+ 9.006249995765788e-05 2.0625866125070641e-10
+ 9.0062499996720384e-05 2.0625868548793557e-10
+ 9.0062500074845377e-05 8.3574849775232329e-10
+ 9.0062500152970383e-05 2.8382408459534785e-09
+ 9.006250093422038e-05 9.7910663945931592e-08
+ 9.0062508051845974e-05 6.9281309170090845e-06
+ 9.0062515169471569e-05 2.3496919613390592e-05
+ 9.0062522287097163e-05 4.8515586154137975e-05
+ 9.0062529404722757e-05 8.0864107426474553e-05
+ 9.0062536522348365e-05 0.0001195688537478285
+ 9.0062543639973959e-05 0.00016378325676260678
+ 9.0062550757599553e-05 0.00021277103077073492
+ 9.0062557875225148e-05 0.00026589161027525284
+ 9.0062564992850742e-05 0.00032258751106878353
+ 9.0062572110476336e-05 0.00038237336083026571
+ 9.0062579228101944e-05 0.00044482637875059637
+ 9.0062587807568563e-05 0.00052313156179263198
+ 9.0062596387035208e-05 0.00060422377214069478
+ 9.0062604966501827e-05 0.00068763160407692863
+ 9.0062613545968472e-05 0.00077295453496090106
+ 9.0062622125435091e-05 0.00085985181282763258
+ 9.0062630704901736e-05 0.00094803308914625053
+ 9.0062639284368355e-05 0.0010372505228311898
+ 9.0062647863835e-05 0.0011272921245865509
+ 9.0062658180770254e-05 0.0012364048498757886
+ 9.0062668497705508e-05 0.0013461799437633384
+ 9.0062678814640761e-05 0.0014563930288477433
+ 9.0062689131576015e-05 0.001566855276772596
+ 9.0062699448511269e-05 0.0016774068636345029
+ 9.0062709765446522e-05 0.001787911643031166
+ 9.0062720082381776e-05 0.0018982528107135616
+ 9.006273039931703e-05 0.0020083293767566338
+ 9.0062742902012252e-05 0.002141246780886198
+ 9.0062755404707475e-05 0.0022735106700283729
+ 9.0062767907402697e-05 0.0024050029041599369
+ 9.006278041009792e-05 0.0025356196305195535
+ 9.0062792912793129e-05 0.0026652683340791378
+ 9.0062805415488351e-05 0.002793865545581445
+ 9.0062817918183573e-05 0.0029213350620943554
+ 9.0062830420878796e-05 0.0030476065669750823
+ 9.0062845592253871e-05 0.0031991277392290247
+ 9.0062860763628959e-05 0.0033486794005026179
+ 9.0062875935004034e-05 0.0034961593179601309
+ 9.0062891106379108e-05 0.0036414711081661105
+ 9.0062906277754197e-05 0.0037845233735065873
+ 9.0062921449129271e-05 0.0039252290818992874
+ 9.0062936620504346e-05 0.0040635051254073566
+ 9.0062954860519557e-05 0.0042264209820281088
+ 9.0062973100534768e-05 0.0043855785109888799
+ 9.006299134054998e-05 0.004540852807539594
+ 9.0063009580565177e-05 0.0046921255232483241
+ 9.0063027820580388e-05 0.004839284756390172
+ 9.0063046060595599e-05 0.0049822250059800644
+ 9.0063068199865848e-05 0.0051499118748984281
+ 9.0063090339136096e-05 0.0053110729761570875
+ 9.0063112478406344e-05 0.0054655577982168782
+ 9.0063134617676593e-05 0.0056132299331846198
+ 9.0063161293011318e-05 0.0057819364493443522
+ 9.0063187873095805e-05 0.0059398423573548687
+ 9.0063214453180293e-05 0.0060874136176253622
+ 9.0063248688484338e-05 0.0062620603819550135
+ 9.0063282923788382e-05 0.0064191641307141745
+ 9.0063315356127044e-05 0.0065517091134031152
+ 9.0063347788465705e-05 0.0066683776453289999
+ 9.0063380220804367e-05 0.0067692021882621509
+ 9.0063412653143042e-05 0.0068542763543729904
+ 9.0063445085481703e-05 0.0069237529436825757
+ 9.0063477517820365e-05 0.0069778416850672731
+ 9.0063509950159026e-05 0.0070168067033145008
+ 9.0063542382497688e-05 0.0070409637367341727
+ 9.0063569584998139e-05 0.0070500711051410814
+ 9.0063596787498605e-05 0.0070492564131712353
+ 9.0063623989999057e-05 0.0070387804986578604
+ 9.0063651192499509e-05 0.0070189238317284377
+ 9.006367839499996e-05 0.0069899850256677273
+ 9.0063705597500412e-05 0.0069522793135452206
+ 9.0063732800000864e-05 0.0069061369988542495
+ 9.0063760002501316e-05 0.0068519018883273245
+ 9.0063787205001768e-05 0.0067899297149596706
+ 9.006381440750222e-05 0.0067205865590935169
+ 9.0063841610002685e-05 0.0066442472751925379
+ 9.0063868812503137e-05 0.006561293931672073
+ 9.0063896015003589e-05 0.0064721142708494637
+ 9.006392321750404e-05 0.0063771001957435066
+ 9.0063950420004492e-05 0.0062766462900859356
+ 9.0063977622504944e-05 0.0061711483775146155
+ 9.0064004825005396e-05 0.0060610021255013743
+ 9.0064032027505861e-05 0.0059466016991306979
+ 9.0064059230006313e-05 0.0058283384693926773
+ 9.0064086432506765e-05 0.0057065997804302861
+ 9.0064115300883503e-05 0.0055740309990659331
+ 9.0064144169260226e-05 0.0054384272991202893
+ 9.0064173037636964e-05 0.0053002282345430132
+ 9.0064201906013701e-05 0.0051598626838551204
+ 9.0064230774390439e-05 0.0050177476630414884
+ 9.0064259642767176e-05 0.0048742872442221231
+ 9.00642885111439e-05 0.0047298715812966012
+ 9.0064317379520638e-05 0.0045848760430473451
+ 9.0064346247897375e-05 0.0044396604535071188
+ 9.0064381135166678e-05 0.0042643637747592994
+ 9.006441602243598e-05 0.0040898203879790361
+ 9.0064449985506048e-05 0.0039211359224094145
+ 9.0064483948576116e-05 0.0037541355090310092
+ 9.006451791164617e-05 0.0035892460195200843
+ 9.0064551874716238e-05 0.0034268598627977894
+ 9.0064585837786306e-05 0.0032673350066711841
+ 9.0064627381082819e-05 0.0030765664536155394
+ 9.0064668924379332e-05 0.0028910852643209248
+ 9.0064710467675844e-05 0.0027113416169293153
+ 9.0064752010972357e-05 0.0025377141992044784
+ 9.00648023225231e-05 0.0023360685105670866
+ 9.0064853125173638e-05 0.0021424443576868821
+ 9.0064903927824163e-05 0.001959156496722657
+ 9.0064971607266251e-05 0.0017313192252947558
+ 9.0065039286708326e-05 0.0015222190408349249
+ 9.0065091919396559e-05 0.001372431253814393
+ 9.0065144552084806e-05 0.0012336381966261724
+ 9.0065197184773053e-05 0.0011055447342070166
+ 9.0065249817461299e-05 0.00098778684645394604
+ 9.0065297809929101e-05 0.00088906516794052203
+ 9.0065345802396902e-05 0.00079823747715313789
+ 9.0065393794864704e-05 0.00071492972227882204
+ 9.0065441787332505e-05 0.00063875107498295779
+ 9.0065489779800307e-05 0.00056929990178360005
+ 9.0065537261554865e-05 0.00050680910974394439
+ 9.0065584743309409e-05 0.00045011010916966049
+ 9.0065632225063953e-05 0.00039881145821643485
+ 9.0065679706818511e-05 0.00035252854906615789
+ 9.0065727188573056e-05 0.00031088653907439246
+ 9.00657746703276e-05 0.0002735227890958723
+ 9.0065824358583361e-05 0.00023862511600889196
+ 9.0065874046839123e-05 0.00020765025205703798
+ 9.0065923735094871e-05 0.00018023763188315632
+ 9.0065973423350632e-05 0.00015604795426756195
+ 9.0066023111606394e-05 0.0001347637411803884
+ 9.0066072799862141e-05 0.00011608953467670693
+ 9.0066127951386073e-05 9.8086983151495662e-05
+ 9.0066183102910006e-05 8.2620379659707852e-05
+ 9.0066238254433924e-05 6.937830638173144e-05
+ 9.0066293405957856e-05 5.8079646203919961e-05
+ 9.0066348557481775e-05 4.8471998343402797e-05
+ 9.006641164052054e-05 3.9267448447275403e-05
+ 9.0066474723559292e-05 3.1683839518460041e-05
+ 9.0066537806598058e-05 2.5463033689023789e-05
+ 9.006660088963681e-05 2.0382309617297274e-05
+ 9.0066674140146431e-05 1.5662206653736814e-05
+ 9.0066747390656039e-05 1.1971024407425274e-05
+ 9.0066820641165646e-05 9.101093726216712e-06
+ 9.0066905619421578e-05 6.5781195004269459e-06
+ 9.0066990597677523e-05 4.7207090840830405e-06
+ 9.0067093836844779e-05 3.1245246960755978e-06
+ 9.0067198171769417e-05 2.0371887602864823e-06
+ 9.0067302506694041e-05 1.3141391771344707e-06
+ 9.0067426664469167e-05 7.6923430377838728e-07
+ 9.0067550822244279e-05 4.435788450454647e-07
+ 9.0067705800806529e-05 2.1851475951109054e-07
+ 9.0067884937131783e-05 9.3708673373505121e-08
+ 9.0068098556602392e-05 3.2883700516734768e-08
+ 9.0068364485722954e-05 8.5309004428172277e-09
+ 9.0068717982712203e-05 1.4552417250701691e-09
+ 9.0069242097564145e-05 3.0578689270965244e-10
+ 9.0070136340120478e-05 2.4569663308855879e-10
+ 9.0072132807185036e-05 2.4259754686171839e-10
+ 9.0073988816858014e-05 2.4182034068072913e-10
+ 9.0076421668443078e-05 2.4138174969930913e-10
+ 9.0078854520028143e-05 2.4076582964276258e-10
+ 9.0081287371613207e-05 2.4012576594620444e-10
+ 9.0083720223198271e-05 2.4057963384973803e-10
+ 9.0086153074783336e-05 2.4092919901400983e-10
+ 9.00885859263684e-05 2.401872610697499e-10
+ 9.0091018777953464e-05 2.3987554496708928e-10
+ 9.0093451629538529e-05 2.4037942571475707e-10
+ 9.0095767705239776e-05 2.4025247901632375e-10
+ 9.0098819440406714e-05 2.4017887589128354e-10
+ 9.0101871175573653e-05 2.4009951114703349e-10
+ 9.0104922910740591e-05 2.4004351142745323e-10
+ 9.0107974645907529e-05 2.4016098617015712e-10
+ 9.0111026381074468e-05 2.4071442426522539e-10
+ 9.0114078116241406e-05 2.3968616681674537e-10
+ 9.0117773618773593e-05 2.4003007462135484e-10
+ 9.0121134288610912e-05 2.4006402385879101e-10
+ 9.0124494958448216e-05 2.4006047129867007e-10
+ 9.012862073169028e-05 2.4005210497337081e-10
+ 9.0132746504932329e-05 2.4004042399080182e-10
+ 9.0136872278174393e-05 2.4003044384477591e-10
+ 9.0140998051416456e-05 2.4003749578386358e-10
+ 9.0145123824658519e-05 2.4008180521387353e-10
+ 9.0150251138437095e-05 2.4016443526047099e-10
+ 9.0155378452215672e-05 2.3985136550844345e-10
+ 9.0160505765994261e-05 2.3994252727381691e-10
+ 9.0165633079772838e-05 2.4004700010028028e-10
+ 9.0171995979825145e-05 2.4004483697536087e-10
+ 9.0178358879877465e-05 2.3997024527683999e-10
+ 9.0184721779929772e-05 2.3997592655072043e-10
+ 9.0192497256254503e-05 2.4000749931504923e-10
+ 9.0200272732579248e-05 2.4001269631983051e-10
+ 9.0208048208903992e-05 2.3999782508278659e-10
+ 9.0217983441936062e-05 2.3999355892689472e-10
+ 9.0227918674968145e-05 2.4000179472492324e-10
+ 9.0240125706218143e-05 2.4000339716614338e-10
+ 9.0252332737468142e-05 2.3999888202599127e-10
+ 9.0264539768718141e-05 2.3999830525938688e-10
+ 9.0276746799968139e-05 2.4000037974237526e-10
+ 9.0288953831218138e-05 2.4000087414852165e-10
+ 9.0301160862468137e-05 2.3999993966201389e-10
+ 9.0313367893718135e-05 2.3999960494882817e-10
+ 9.0325574924968134e-05 2.4000001432309894e-10
+ 9.0337781956218146e-05 2.4000021737723387e-10
+ 9.0349988987468145e-05 2.4000004462513988e-10
+ 9.0362196018718143e-05 2.3999993006727966e-10
+ 9.0374403049968142e-05 2.3999999917748096e-10
+ 9.0386610081218141e-05 2.4000006049017395e-10
+ 9.0398817112468139e-05 2.4000003421757239e-10
+ 9.0411024143718138e-05 2.4000000237870328e-10
+ 9.0423231174968137e-05 2.4000001256652595e-10
+ 9.0435438206218135e-05 2.4000002745854788e-10
+ 9.0447645237468134e-05 2.4000002475271839e-10
+ 9.0459852268718146e-05 2.4000001795384735e-10
+ 9.0472059299968145e-05 2.400000173879749e-10
+ 9.0484266331218143e-05 2.4000002070407596e-10
+ 9.0496473362468142e-05 2.4000002067419452e-10
+ 9.0508680393718141e-05 2.4000001976473751e-10
+ 9.0520887424968139e-05 2.40000019362722e-10
+ 9.0533094456218138e-05 2.4000002028128461e-10
+ 9.0545301487468137e-05 2.4000002060646208e-10
+ 9.0557508518718135e-05 2.4000002008287723e-10
+ 9.0569715549968134e-05 2.4000001934276911e-10
+ 9.0581922581218133e-05 2.4000001968966948e-10
+ 9.0594129612468145e-05 2.4000002093381111e-10
+ 9.0606336643718144e-05 2.4000001965726013e-10
+ 9.0618543674968142e-05 2.4000001961507071e-10
+ 9.0630750706218141e-05 2.4000002048512451e-10
+ 9.064295773746814e-05 2.4000001998121006e-10
+ 9.0655164768718138e-05 2.400000199764228e-10
+ 9.0667371799968137e-05 2.4000001998665694e-10
+ 9.0679578831218135e-05 2.4000001988395378e-10
+ 9.0691785862468134e-05 2.4000001969840786e-10
+ 9.0703992893718133e-05 2.4000001962628526e-10
+ 9.0716199924968131e-05 2.4000001985975601e-10
+ 9.0728406956218144e-05 2.4000001994562599e-10
+ 9.0740613987468142e-05 2.4000001873790616e-10
+ 9.0752821018718141e-05 2.400000206888198e-10
+ 9.076502804996814e-05 2.4000002115772409e-10
+ 9.0777235081218138e-05 2.4000001926167516e-10
+ 9.0789442112468137e-05 2.4000001865095655e-10
+ 9.0801649143718136e-05 2.4000002024868279e-10
+ 9.0813856174968134e-05 2.4000002062807212e-10
+ 9.0826063206218133e-05 2.4000001971246058e-10
+ 9.0838270237468132e-05 2.4000001913611468e-10
+ 9.085047726871813e-05 2.4000001939609548e-10
+ 9.0862684299968142e-05 2.4000001928925776e-10
+ 9.0874891331218141e-05 2.4000002036211893e-10
+ 9.088709836246814e-05 2.4000001948566678e-10
+ 9.0899305393718138e-05 2.40000020557049e-10
+ 9.0911512424968137e-05 2.400000203491446e-10
+ 9.0923719456218136e-05 2.4000001961720044e-10
+ 9.0935926487468134e-05 2.400000200808237e-10
+ 9.0948133518718133e-05 2.4000002006495584e-10
+ 9.0960340549968132e-05 2.4000001941755901e-10
+ 9.097254758121813e-05 2.4000001925514504e-10
+ 9.0984754612468143e-05 2.4000001949494439e-10
+ 9.0996961643718141e-05 2.4000001987457185e-10
+ 9.100916867496814e-05 2.4000001956535886e-10
+ 9.1021375706218139e-05 2.4000001976899341e-10
+ 9.1033582737468137e-05 2.4000001989767335e-10
+ 9.1045789768718136e-05 2.4000002010421042e-10
+ 9.1057996799968134e-05 2.4000002031692612e-10
+ 9.1070203831218133e-05 2.4000001943796074e-10
+ 9.1082410862468132e-05 2.4000001979057998e-10
+ 9.109461789371813e-05 2.4000001994141042e-10
+ 9.1106824924968129e-05 2.4000001910787902e-10
+ 9.1119031956218141e-05 2.4000002014157438e-10
+ 9.113123898746814e-05 2.4000002007976212e-10
+ 9.1143446018718139e-05 2.4000001897875313e-10
+ 9.1155653049968137e-05 2.4000002030066949e-10
+ 9.1167860081218136e-05 2.4000002070432142e-10
+ 9.1180067112468135e-05 2.4000001950520541e-10
+ 9.1192274143718133e-05 2.4000001947980057e-10
+ 9.1204481174968132e-05 2.4000002027253361e-10
+ 9.1216688206218131e-05 2.40000020609859e-10
+ 9.1228895237468129e-05 2.4000001911322354e-10
+ 9.1241102268718141e-05 2.4000001969739074e-10
+ 9.125330929996814e-05 2.4000002073053612e-10
+ 9.1265516331218139e-05 2.4000001994814067e-10
+ 9.1277723362468137e-05 2.4000001923239209e-10
+ 9.1289930393718136e-05 2.4000002015288261e-10
+ 9.1302137424968135e-05 2.4000001930210656e-10
+ 9.1314344456218133e-05 2.4000001837686493e-10
+ 9.1326551487468132e-05 2.4000001946449939e-10
+ 9.1338758518718131e-05 2.4000002038326192e-10
+ 9.1350965549968129e-05 2.400000203109469e-10
+ 9.1363172581218142e-05 2.400000203952259e-10
+ 9.137537961246814e-05 2.4000001970496741e-10
+ 9.1387586643718139e-05 2.4000001924454606e-10
+ 9.1399793674968137e-05 2.4000001905466872e-10
+ 9.1412000706218136e-05 2.400000204518705e-10
+ 9.1424207737468135e-05 2.4000002011557764e-10
+ 9.1436414768718133e-05 2.4000001946831419e-10
+ 9.1448621799968132e-05 2.4000001925940771e-10
+ 9.1460828831218144e-05 2.4000001980987061e-10
+ 9.1473035862468143e-05 2.4000002089319245e-10
+ 9.1485242893718142e-05 2.4000001973823067e-10
+ 9.149744992496814e-05 2.4000001879346328e-10
+ 9.1509656956218139e-05 2.4000001869932423e-10
+ 9.1521863987468138e-05 2.4000002074828773e-10
+ 9.1534071018718136e-05 2.4000001934026167e-10
+ 9.1546278049968135e-05 2.4000001952115826e-10
+ 9.1558485081218147e-05 2.4000001987859593e-10
+ 9.1570692112468146e-05 2.400000198982881e-10
+ 9.1582899143718144e-05 2.40000018977687e-10
+ 9.1595106174968143e-05 2.4000001970468766e-10
+ 9.1607313206218142e-05 2.4000001969944985e-10
+ 9.161952023746814e-05 2.4000002027367879e-10
+ 9.1631727268718139e-05 2.4000001840031488e-10
+ 9.1643934299968138e-05 2.4000001957318321e-10
+ 9.165614133121815e-05 2.400000188108562e-10
+ 9.1668348362468149e-05 2.4000002046679305e-10
+ 9.1680555393718147e-05 2.4000001950571268e-10
+ 9.1692762424968146e-05 2.4000001838116472e-10
+ 9.1704969456218145e-05 2.4000001853089837e-10
+ 9.1717176487468143e-05 2.4000002004811227e-10
+ 9.1729383518718142e-05 2.4000001966057371e-10
+ 9.1741590549968141e-05 2.4000001941089245e-10
+ 9.1753797581218153e-05 2.4000001913185568e-10
+ 9.1766004612468151e-05 2.4000001954838558e-10
+ 9.177821164371815e-05 2.4000001920964592e-10
+ 9.1790418674968149e-05 2.4000001943469307e-10
+ 9.1802625706218147e-05 2.4000001866641258e-10
+ 9.1814832737468146e-05 2.4000002020897109e-10
+ 9.1827039768718145e-05 2.4000001940179987e-10
+ 9.1839246799968143e-05 2.4000001993507329e-10
+ 9.1851453831218156e-05 2.4000002008198123e-10
+ 9.1863660862468154e-05 2.400000198005213e-10
+ 9.1875867893718153e-05 2.4000001916301211e-10
+ 9.1888074924968151e-05 2.4000001960280073e-10
+ 9.190028195621815e-05 2.4000001963117276e-10
+ 9.1912488987468149e-05 2.400000196254434e-10
+ 9.1924696018718147e-05 2.4000002030623543e-10
+ 9.1936903049968146e-05 2.4000001985486468e-10
+ 9.1949110081218158e-05 2.4000001975560508e-10
+ 9.1961317112468157e-05 2.4000002002563028e-10
+ 9.1973524143718156e-05 2.4000001880683233e-10
+ 9.1985731174968154e-05 2.400000186107882e-10
+ 9.1997938206218153e-05 2.4000002026174485e-10
+ 9.2010145237468152e-05 2.4000001964579944e-10
+ 9.202235226871815e-05 2.4000001869414737e-10
+ 9.2034559299968149e-05 2.4000002024855297e-10
+ 9.2046766331218161e-05 2.4000001886895933e-10
+ 9.205897336246816e-05 2.4000001996539064e-10
+ 9.2071180393718158e-05 2.4000001852201533e-10
+ 9.2083387424968157e-05 2.4000001995376353e-10
+ 9.2095594456218156e-05 2.4000001885033681e-10
+ 9.2107801487468154e-05 2.400000202275795e-10
+ 9.2120008518718153e-05 2.4000001938682899e-10
+ 9.2132215549968152e-05 2.400000185286626e-10
+ 9.2144422581218164e-05 2.4000002021567022e-10
+ 9.2156629612468163e-05 2.4000001929093104e-10
+ 9.2168836643718161e-05 2.4000001945502139e-10
+ 9.218104367496816e-05 2.4000001849176264e-10
+ 9.2193250706218159e-05 2.4000001899160695e-10
+ 9.2205457737468157e-05 2.4000001908469775e-10
+ 9.2217664768718156e-05 2.4000002021320925e-10
+ 9.2229871799968154e-05 2.4000001986077044e-10
+ 9.2242078831218167e-05 2.4000001985660228e-10
+ 9.2254285862468165e-05 2.4000001982734366e-10
+ 9.2266492893718164e-05 2.4000001909394165e-10
+ 9.2278699924968163e-05 2.4000001971428865e-10
+ 9.2290906956218161e-05 2.4000001921042243e-10
+ 9.230311398746816e-05 2.400000190589926e-10
+ 9.2315321018718159e-05 2.400000192770844e-10
+ 9.2327528049968157e-05 2.4000001876027354e-10
+ 9.2339735081218169e-05 2.4000001963225885e-10
+ 9.2351942112468168e-05 2.4000001898595255e-10
+ 9.2364149143718167e-05 2.4000001876650681e-10
+ 9.2376356174968165e-05 2.4000001955479303e-10
+ 9.2388563206218164e-05 2.400000192149284e-10
+ 9.2400770237468163e-05 2.4000001962818762e-10
+ 9.2412977268718161e-05 2.400000192259498e-10
+ 9.242518429996816e-05 2.4000001958046752e-10
+ 9.2437391331218172e-05 2.4000001876653049e-10
+ 9.2449598362468171e-05 2.4000001901679062e-10
+ 9.246180539371817e-05 2.4000001929188411e-10
+ 9.2474012424968168e-05 2.4000001878460593e-10
+ 9.2486219456218167e-05 2.4000001895149019e-10
+ 9.2498426487468166e-05 2.4000001953324466e-10
+ 9.2510633518718164e-05 2.4000001930179932e-10
+ 9.2522840549968163e-05 2.4000001867284628e-10
+ 9.2535047581218175e-05 2.4000001876404646e-10
+ 9.2547254612468174e-05 2.4000001844012502e-10
+ 9.2559461643718172e-05 2.4000001847700822e-10
+ 9.2571668674968171e-05 2.4000001848915366e-10
+ 9.258387570621817e-05 2.4000001847211049e-10
+ 9.2596082737468168e-05 2.4000001842583542e-10
+ 9.2608289768718167e-05 2.4000001874485954e-10
+ 9.2620496799968166e-05 2.4000001864470591e-10
+ 9.2632703831218178e-05 2.400000192645186e-10
+ 9.2644910862468177e-05 2.4000001911011029e-10
+ 9.2657117893718175e-05 2.400000189594016e-10
+ 9.2669324924968174e-05 2.4000001834385696e-10
+ 9.2681531956218173e-05 2.4000001923683012e-10
+ 9.2693738987468171e-05 2.4000002008098464e-10
+ 9.270594601871817e-05 2.400000183211859e-10
+ 9.2718153049968168e-05 2.4000001983070817e-10
+ 9.2730360081218181e-05 2.4000001841550595e-10
+ 9.2742567112468179e-05 2.4000001987140726e-10
+ 9.2754774143718178e-05 2.4000001839799459e-10
+ 9.2766981174968177e-05 2.4000001979564812e-10
+ 9.2779188206218175e-05 2.4000001826400317e-10
+ 9.2791395237468174e-05 2.3996544537098469e-10
+ 9.2803602268718173e-05 2.3996256464191007e-10
+ 9.2815809299968171e-05 2.3996062147298765e-10
+ 9.2828016331218183e-05 2.399538992151035e-10
+ 9.2840223362468182e-05 2.3990864356794482e-10
+ 9.2852430393718181e-05 2.3980391697569448e-10
+ 9.2864637424968179e-05 2.3960325885649169e-10
+ 9.2870740940593179e-05 2.3930636780140344e-10
+ 9.2876844456218178e-05 2.3825018349924986e-10
+ 9.2879896214030685e-05 2.3664385617022961e-10
+ 9.2882947971843177e-05 2.313460144418538e-10
+ 9.2884473850749424e-05 2.2273712950258841e-10
+ 9.2885999729655684e-05 1.9502932447418286e-10
+ 9.2886991106889191e-05 1.3263414891107653e-10
+ 9.2887269733896236e-05 9.5672269136980181e-11
+ 9.2887548360903296e-05 4.6113023016783446e-11
+ 9.2888098835627964e-05 4.077304569289076e-11
+ 9.2890875273912431e-05 4.2347131994264368e-11
+ 9.2903082305162429e-05 4.4733371018365243e-11
+ 9.2915289336412441e-05 5.3058719093237963e-11
+ 9.292749636766244e-05 6.5249849962529414e-11
+ 9.2939703398912439e-05 8.0586557341896391e-11
+ 9.2951910430162437e-05 9.8186059694000248e-11
+ 9.2964117461412436e-05 1.1703587328666208e-10
+ 9.2976324492662435e-05 1.3605185310399104e-10
+ 9.2988531523912433e-05 1.5414054504639482e-10
+ 9.3000738555162432e-05 1.7026206156240515e-10
+ 9.3012945586412431e-05 1.8348986297121229e-10
+ 9.3025152617662443e-05 1.9306400774952091e-10
+ 9.3037359648912441e-05 1.9843481134517081e-10
+ 9.304956668016244e-05 1.9929440536940058e-10
+ 9.3061773711412439e-05 1.9559438520732841e-10
+ 9.3073980742662437e-05 1.8754853451668201e-10
+ 9.3086187773912436e-05 1.7562047328816539e-10
+ 9.3098394805162435e-05 1.6049694315998822e-10
+ 9.3110601836412447e-05 1.4304826930135124e-10
+ 9.3122808867662446e-05 1.2427827523140709e-10
+ 9.3135015898912444e-05 1.052665328361379e-10
+ 9.3147222930162443e-05 8.7106269937226752e-11
+ 9.3159429961412442e-05 7.0841506734532094e-11
+ 9.317163699266244e-05 5.7407035899497847e-11
+ 9.3183844023912439e-05 4.7574696846103914e-11
+ 9.3186895781724945e-05 4.5750674856066197e-11
+ 9.3187048369615565e-05 4.5666462612461995e-11
+ 9.3187429839342126e-05 4.5458870923120094e-11
+ 9.3187467986314781e-05 4.5438342991126504e-11
+ 9.318747561570932e-05 4.5434242455099145e-11
+ 9.3187490874498385e-05 4.5426046434154427e-11
+ 9.3187496978014e-05 4.5422769911655126e-11
+ 9.3187499419420262e-05 4.542145960441293e-11
+ 9.3187499604455788e-05 4.5421360302533612e-11
+ 9.3187499974526841e-05 4.5421161701746532e-11
+ 9.3187500714668947e-05 5.7234708751505077e-08
+ 9.3187501454811052e-05 2.3609835104101694e-07
+ 9.3187508856232149e-05 8.3378657603255145e-06
+ 9.3187516257653232e-05 2.6804211983519737e-05
+ 9.3187523659074329e-05 5.4212572160978158e-05
+ 9.3187531060495412e-05 8.9333429400249197e-05
+ 9.3187538461916508e-05 0.00013110387761772142
+ 9.3187547512355685e-05 0.00018988604042548046
+ 9.3187556562794862e-05 0.000255812068272275
+ 9.3187565613234052e-05 0.00032768193023753725
+ 9.3187574663673229e-05 0.00040448949601993325
+ 9.3187583714112406e-05 0.00048539058840956265
+ 9.3187595044533504e-05 0.00059137048504824714
+ 9.3187606374954603e-05 0.00070151686849491022
+ 9.3187617705375701e-05 0.0008149054011463608
+ 9.31876290357968e-05 0.00093078918228233572
+ 9.3187643214653361e-05 0.0010784080416500865
+ 9.3187657393509909e-05 0.0012280520970111633
+ 9.3187671572366471e-05 0.0013789889014004875
+ 9.3187689032396935e-05 0.0015657925325384681
+ 9.31877064924274e-05 0.0017528666320927736
+ 9.3187723952457865e-05 0.0019395804048633696
+ 9.3187746268477828e-05 0.0021769293571718938
+ 9.3187768584497804e-05 0.0024120996791847497
+ 9.3187790900517767e-05 0.0026444704336099976
+ 9.3187819090217243e-05 0.0029332237971511233
+ 9.3187847279916706e-05 0.0032158629328255771
+ 9.3187875469616182e-05 0.0034916668520790159
+ 9.3187903659315644e-05 0.0037599988278231356
+ 9.318793184901512e-05 0.0040202830355208904
+ 9.3187960038714596e-05 0.0042719918874605982
+ 9.3187988228414059e-05 0.0045146394015623476
+ 9.3188019414106474e-05 0.0047719795450323309
+ 9.3188050599798876e-05 0.0050171295125712645
+ 9.3188081785491292e-05 0.0052495906087394869
+ 9.3188112971183707e-05 0.0054689190353913904
+ 9.318815041841434e-05 0.0057143885297757718
+ 9.3188187865644959e-05 0.0059397992525804574
+ 9.3188225312875592e-05 0.006144702220679193
+ 9.3188270844195802e-05 0.0063657430322260553
+ 9.3188316375516025e-05 0.0065556175023236875
+ 9.3188361906836235e-05 0.0067142112673811444
+ 9.3188407438156445e-05 0.0068416534980290083
+ 9.318844108402811e-05 0.0069160175765833089
+ 9.3188474729899776e-05 0.0069737900261410465
+ 9.3188508375771441e-05 0.0070152594941248576
+ 9.3188542021643107e-05 0.0070407746969006688
+ 9.3188575667514772e-05 0.007050740823760393
+ 9.3188609313386438e-05 0.0070456156939712805
+ 9.3188642959258103e-05 0.007025905702338452
+ 9.3188676605129769e-05 0.0069921615895264296
+ 9.3188710251001434e-05 0.0069449740739896257
+ 9.3188736870668151e-05 0.006898526876910809
+ 9.3188763490334854e-05 0.0068443802044164921
+ 9.3188790110001571e-05 0.0067828688534493494
+ 9.3188816729668274e-05 0.0067143369242957376
+ 9.3188843349334991e-05 0.0066391364097472113
+ 9.3188869969001694e-05 0.0065576257964309343
+ 9.318889658866841e-05 0.0064701686843428533
+ 9.3188923208335127e-05 0.0063771324303375145
+ 9.318894982800183e-05 0.0062788868210215225
+ 9.3188976447668547e-05 0.0061758027801676225
+ 9.318900306733525e-05 0.0060682511154162089
+ 9.3189029687001967e-05 0.0059566013086644297
+ 9.318905630666867e-05 0.0058412203541628417
+ 9.3189082926335386e-05 0.0057224716479485063
+ 9.318910954600209e-05 0.0056007139318451742
+ 9.3189136165668806e-05 0.0054763002948580381
+ 9.3189162785335523e-05 0.0053495772343856614
+ 9.3189189405002226e-05 0.0052208837792675896
+ 9.3189216024668943e-05 0.0050905506764474901
+ 9.3189239404935226e-05 0.0049749804171373225
+ 9.3189262785201509e-05 0.0048586054363550972
+ 9.3189286165467806e-05 0.0047416314482211135
+ 9.3189309545734089e-05 0.0046242577652878883
+ 9.3189332926000385e-05 0.0045066770343838705
+ 9.3189356306266669e-05 0.0043890750025309139
+ 9.3189379686532952e-05 0.0042716303126259531
+ 9.3189403066799248e-05 0.0041545143284691553
+ 9.3189426447065532e-05 0.0040378909886185305
+ 9.3189449827331815e-05 0.0039219166884552218
+ 9.3189473207598111e-05 0.0038067401897542695
+ 9.3189496587864394e-05 0.0036925025569730643
+ 9.3189519968130691e-05 0.0035793371193940525
+ 9.3189543348396974e-05 0.0034673694581895016
+ 9.3189566728663257e-05 0.0033567174174145066
+ 9.3189590108929554e-05 0.0032474911378798247
+ 9.3189613489195837e-05 0.0031397931128086067
+ 9.318963686946212e-05 0.0030337182641405314
+ 9.3189660249728417e-05 0.0029293540383132049
+ 9.31896836299947e-05 0.0028267805203238136
+ 9.3189707010260997e-05 0.0027260705648536779
+ 9.3189735591237517e-05 0.0026055855381113117
+ 9.3189764172214038e-05 0.0024880893416989024
+ 9.3189792753190558e-05 0.0023736731389782805
+ 9.3189821334167092e-05 0.0022624136400195647
+ 9.3189849915143613e-05 0.0021543736566158275
+ 9.3189886199806211e-05 0.0020219271947776738
+ 9.3189925453373377e-05 0.0018846580284455387
+ 9.3189946977215263e-05 0.0018120618774395494
+ 9.3189973696714693e-05 0.0017245821083065652
+ 9.3190000416214135e-05 0.0016400258203643724
+ 9.3190027135713565e-05 0.0015583844444338579
+ 9.3190053855213008e-05 0.0014796423351417674
+ 9.3190080574712437e-05 0.0014037772468436488
+ 9.319010729421188e-05 0.0013307608065583204
+ 9.3190134013711309e-05 0.0012605589819463642
+ 9.3190160733210752e-05 0.0011931325425094006
+ 9.3190187452710181e-05 0.0011284375123336611
+ 9.3190214172209624e-05 0.0010664256128491564
+ 9.3190240891709053e-05 0.0010070446942234952
+ 9.3190262548859614e-05 0.00096080661895637035
+ 9.319028420601016e-05 0.0009162294538821239
+ 9.319030586316072e-05 0.00087328092606094238
+ 9.3190327520311267e-05 0.00083192771752318962
+ 9.3190349177461814e-05 0.00079213559354230647
+ 9.3190370834612374e-05 0.00075386952625768001
+ 9.3190392491762921e-05 0.00071709381353394315
+ 9.3190414148913467e-05 0.00068177219296354193
+ 9.3190435806064027e-05 0.00064786795094112185
+ 9.3190457463214574e-05 0.00061534402675914772
+ 9.3190479120365121e-05 0.00058416311167918647
+ 9.3190496765399602e-05 0.00055972551886932095
+ 9.319051441043407e-05 0.00053613426244406741
+ 9.3190532055468551e-05 0.00051336904748169171
+ 9.3190549700503019e-05 0.00049140960981622914
+ 9.3190567345537501e-05 0.00047023574348777509
+ 9.3190584990571968e-05 0.00044982732676715286
+ 9.319060263560645e-05 0.00043016434677204047
+ 9.3190620280640918e-05 0.00041122692269401575
+ 9.3190637925675386e-05 0.00039299532765819798
+ 9.3190655570709867e-05 0.00037545000923921415
+ 9.3190673215744335e-05 0.00035857160865911174
+ 9.3190690860778816e-05 0.00034234097869457157
+ 9.3190708505813284e-05 0.00032673920032235228
+ 9.3190726150847765e-05 0.00031174759813332067
+ 9.3190743795882233e-05 0.00029734775454669758
+ 9.3190761440916715e-05 0.00028352152285727745
+ 9.3190779085951182e-05 0.0002702510391493668
+ 9.319079673098565e-05 0.00025751873311203796
+ 9.3190814376020132e-05 0.00024530733779101174
+ 9.31908320210546e-05 0.00023359989831307307
+ 9.3190849666089081e-05 0.00022237977961939102
+ 9.3190867311123549e-05 0.00021163067324446447
+ 9.319088495615803e-05 0.00020133660317765155
+ 9.3190902601192498e-05 0.00019148193084437179
+ 9.3190920246226966e-05 0.00018205135924409671
+ 9.3190937891261447e-05 0.00017302993628217709
+ 9.3190955536295915e-05 0.00016440305733239472
+ 9.3190973181330396e-05 0.00015615646706688136
+ 9.3190990826364864e-05 0.00014827626058972067
+ 9.3191008471399346e-05 0.00014074888391014853
+ 9.3191026116433813e-05 0.00013356113379079491
+ 9.3191043761468281e-05 0.00012670015700587552
+ 9.3191061406502763e-05 0.00012015344904364461
+ 9.3191079051537231e-05 0.00011390885228677083
+ 9.3191096696571712e-05 0.00010795455370359766
+ 9.319111434160618e-05 0.00010227908208250491
+ 9.3191131986640661e-05 9.687130484080241e-05
+ 9.3191149631675129e-05 9.1720424438765868e-05
+ 9.319116727670961e-05 8.6815974428572379e-05
+ 9.3191184921744078e-05 8.2147815167013072e-05
+ 9.3191202566778546e-05 7.7706129219957601e-05
+ 9.3191220211813027e-05 7.3481416485622882e-05
+ 9.3191237856847495e-05 6.9464489062760908e-05
+ 9.3191255501881977e-05 6.5646465888930612e-05
+ 9.3191273146916445e-05 6.2018767173060703e-05
+ 9.3191290791950926e-05 5.8573108645546759e-05
+ 9.3191308436985394e-05 5.5301495648160228e-05
+ 9.3191326082019875e-05 5.2196217085081444e-05
+ 9.3191343727054343e-05 4.9249839255407143e-05
+ 9.3191361372088811e-05 4.6455199586526805e-05
+ 9.3191379017123292e-05 4.3805400286814076e-05
+ 9.319139666215776e-05 4.1293801935142287e-05
+ 9.3191414307192241e-05 3.8914017023807698e-05
+ 9.3191431952226709e-05 3.6659903470533496e-05
+ 9.3191449597261191e-05 3.4525558114332587e-05
+ 9.3191467242295659e-05 3.2505310209129923e-05
+ 9.3191484887330126e-05 3.0593714928186798e-05
+ 9.3191502532364608e-05 2.878554689153125e-05
+ 9.3191520177399076e-05 2.7075793727781893e-05
+ 9.3191537822433557e-05 2.5459649680957857e-05
+ 9.3191555467468025e-05 2.3932509272096093e-05
+ 9.3191573112502506e-05 2.2489961024749567e-05
+ 9.3191590757536974e-05 2.1127781262716843e-05
+ 9.3191608402571442e-05 1.9841927987655173e-05
+ 9.3191626047605923e-05 1.8628534843556469e-05
+ 9.3191643692640391e-05 1.7483905174418017e-05
+ 9.3191661337674873e-05 1.6404506180818473e-05
+ 9.3191682620107571e-05 1.5184596516820046e-05
+ 9.3191702745281681e-05 1.4108722156777394e-05
+ 9.3191722870455778e-05 1.3103783271809466e-05
+ 9.3191742995629888e-05 1.2165512099818384e-05
+ 9.3191763120803984e-05 1.1289867233639744e-05
+ 9.3191783245978081e-05 1.0473023791237365e-05
+ 9.3191803371152191e-05 9.711363860421274e-06
+ 9.3191823496326288e-05 9.0014672215583367e-06
+ 9.3191843621500398e-05 8.3401023506671107e-06
+ 9.3191863746674495e-05 7.7242177042852387e-06
+ 9.3191888110746128e-05 7.0353574872189284e-06
+ 9.3191912474817747e-05 6.4041509733236313e-06
+ 9.3191936838889379e-05 5.8261375978047346e-06
+ 9.3191961202961012e-05 5.2971679183216326e-06
+ 9.3191985567032631e-05 4.8133849648221628e-06
+ 9.3192009931104263e-05 4.3712064413582404e-06
+ 9.3192034295175896e-05 3.9673077642003495e-06
+ 9.3192058659247515e-05 3.5986059186122073e-06
+ 9.3192083023319148e-05 3.2622441148827113e-06
+ 9.3192107387390767e-05 2.955577222710442e-06
+ 9.3192136719683573e-05 2.6223173518557521e-06
+ 9.3192166051976366e-05 2.3246430183300364e-06
+ 9.319219538426916e-05 2.0589938235170389e-06
+ 9.3192224716561953e-05 1.8221375097881734e-06
+ 9.3192254048854746e-05 1.6111428978970881e-06
+ 9.3192283381147539e-05 1.4233547079677823e-06
+ 9.3192312713440332e-05 1.2563701699769522e-06
+ 9.3192342045733125e-05 1.1080173307665688e-06
+ 9.319237784802919e-05 9.4935328593955194e-07
+ 9.3192412335454624e-05 8.1703614317247063e-07
+ 9.3192446822880058e-05 7.0231034037170861e-07
+ 9.3192481310305493e-05 6.0295931014601184e-07
+ 9.3192515797730927e-05 5.1702814794412422e-07
+ 9.3192557828321212e-05 4.2796498791424164e-07
+ 9.3192599858911483e-05 3.5358466304975593e-07
+ 9.3192641889501768e-05 2.9157919961691281e-07
+ 9.3192683920092039e-05 2.3998333476715486e-07
+ 9.3192725950682324e-05 1.9712710629082681e-07
+ 9.3192777518503423e-05 1.5442331314774624e-07
+ 9.3192828186666475e-05 1.2110746118199679e-07
+ 9.319287885482954e-05 9.4668212428266369e-08
+ 9.3192929522992592e-05 7.3741045625230226e-08
+ 9.3192993215143456e-05 5.3572482382509411e-08
+ 9.319305690729432e-05 3.8650410566722333e-08
+ 9.3193120599445185e-05 2.7655607125139506e-08
+ 9.3193198945610718e-05 1.80624388894615e-08
+ 9.319327865764969e-05 1.1455385675920075e-08
+ 9.3193358369688661e-05 7.0279116712338033e-09
+ 9.3193461292370757e-05 3.42722610432318e-09
+ 9.3193569508909812e-05 1.2415251844169095e-09
+ 9.3193701914804437e-05 -1.7423168879043324e-10
+ 9.3193847065030179e-05 -9.0046498724308251e-10
+ 9.3194034315235687e-05 -1.2675598336250834e-09
+ 9.3194255865010429e-05 -1.390661486095478e-09
+ 9.3194554034092505e-05 -1.4079464626524889e-09
+ 9.3194998769870888e-05 -1.3781166774969621e-09
+ 9.3195805003988997e-05 -1.313948994893242e-09
+ 9.3196711764368317e-05 -1.2450592154006523e-09
+ 9.3197737475686444e-05 -1.1711746826522686e-09
+ 9.3198801143402335e-05 -1.0985374417948889e-09
+ 9.3199944764949541e-05 -1.0244977902794022e-09
+ 9.3202231646278907e-05 -8.876839903243166e-10
+ 9.3204182681216655e-05 -7.8153991862173163e-10
+ 9.3206291228517242e-05 -6.7660226349856925e-10
+ 9.3208581467436164e-05 -5.7299433820914436e-10
+ 9.3210926666850022e-05 -4.7698621811411996e-10
+ 9.321327186626388e-05 -3.901690868650475e-10
+ 9.321559053717963e-05 -3.1248869476676087e-10
+ 9.3218474569484283e-05 -2.2600941125466692e-10
+ 9.3221358601788923e-05 -1.4953972152878652e-10
+ 9.3224242634093576e-05 -8.1909642546355165e-11
+ 9.322712666639823e-05 -2.2097231394821104e-11
+ 9.3230010698702869e-05 3.0804763949844941e-11
+ 9.3232894731007523e-05 7.7599184420572088e-11
+ 9.3235778763312176e-05 1.1899177680085989e-10
+ 9.3239342797663593e-05 1.6360497315690482e-10
+ 9.324290683201501e-05 2.0194460469335925e-10
+ 9.3246470866366427e-05 2.3489304324568193e-10
+ 9.3250034900717858e-05 2.6320792465228799e-10
+ 9.3253598935069275e-05 2.8754418863776942e-10
+ 9.3257899961127354e-05 3.124003450031708e-10
+ 9.3262200987185448e-05 3.3310188136055884e-10
+ 9.3266502013243541e-05 3.5034335018174361e-10
+ 9.327080303930162e-05 3.6470346013268147e-10
+ 9.3275104065359713e-05 3.7666442373221598e-10
+ 9.3280502505986977e-05 3.8888313831481749e-10
+ 9.3285900946614241e-05 3.9859542479219459e-10
+ 9.3291299387241518e-05 4.0629545583254085e-10
+ 9.3296697827868782e-05 4.1242659596079512e-10
+ 9.330346824765747e-05 4.1836450212166619e-10
+ 9.3310238667446157e-05 4.228142873871682e-10
+ 9.3317009087234845e-05 4.2614500842071573e-10
+ 9.3325385304343951e-05 4.2912633403108892e-10
+ 9.333376152145307e-05 4.3120345772378355e-10
+ 9.3342137738562176e-05 4.3264838822889765e-10
+ 9.3353043385488655e-05 4.3388610175178318e-10
+ 9.3363949032415134e-05 4.3464666000495187e-10
+ 9.3376156063665133e-05 4.3514763453961883e-10
+ 9.3388363094915131e-05 4.3542384097085643e-10
+ 9.340057012616513e-05 4.3556624282357159e-10
+ 9.3412777157415129e-05 4.3562884855868211e-10
+ 9.3424984188665127e-05 4.3564390919099658e-10
+ 9.3437191219915126e-05 4.3563071731303817e-10
+ 9.3449398251165125e-05 4.3560072832369711e-10
+ 9.3461605282415137e-05 4.3556071800624522e-10
+ 9.3473812313665136e-05 4.3551473285478916e-10
+ 9.3486019344915134e-05 4.3546520640556509e-10
+ 9.3498226376165133e-05 4.3541358487496968e-10
+ 9.3510433407415131e-05 4.3536071753580087e-10
+ 9.352264043866513e-05 4.353071102954193e-10
+ 9.3534847469915129e-05 4.3525307030070124e-10
+ 9.3547054501165141e-05 4.3519878102624261e-10
+ 9.355926153241514e-05 4.3514434891989702e-10
+ 9.3571468563665138e-05 4.3508983678706616e-10
+ 9.3583675594915137e-05 4.3503528333983576e-10
+ 9.3595882626165136e-05 4.3498071205926307e-10
+ 9.3608089657415134e-05 4.3492613633167183e-10
+ 9.3620296688665133e-05 4.348715638520445e-10
+ 9.3632503719915132e-05 4.3481699946235471e-10
+ 9.364471075116513e-05 4.3476244620745766e-10
+ 9.3656917782415142e-05 4.3470790578886986e-10
+ 9.3669124813665141e-05 4.3465337912630206e-10
+ 9.368133184491514e-05 4.3459886680952396e-10
+ 9.3693538876165138e-05 4.3454436923774573e-10
+ 9.3705745907415137e-05 4.3448988663097442e-10
+ 9.3717952938665136e-05 4.3443541909242035e-10
+ 9.3730159969915134e-05 4.3438096668679938e-10
+ 9.3742367001165147e-05 4.3432652946422885e-10
+ 9.3750000000000002e-05 4.3429323819786375e-10
+ 9.3762207031250001e-05 4.3423882549145797e-10
+ 9.3774414062499999e-05 4.3418442800650571e-10
+ 9.3786621093749998e-05 4.3413004574565444e-10
+ 9.3798828124999997e-05 4.3407567870875607e-10
+ 9.3811035156249995e-05 4.3402132689399754e-10
+ 9.3823242187500007e-05 4.3396699029857563e-10
+ 9.3835449218750006e-05 4.3391266891909689e-10
+ 9.3847656250000005e-05 4.338583627518177e-10
+ 9.3859863281250003e-05 4.338040717927861e-10
+ 9.3872070312500002e-05 4.3374979603792648e-10
+ 9.3884277343750001e-05 4.3369553548309005e-10
+ 9.3896484374999999e-05 4.3364129012408513e-10
+ 9.3908691406249998e-05 4.3358705995669485e-10
+ 9.3920898437499997e-05 4.3353284497668784e-10
+ 9.3933105468749995e-05 4.3347864517982436e-10
+ 9.3945312500000008e-05 4.3342446056186068e-10
+ 9.3957519531250006e-05 4.3337029111855061e-10
+ 9.3969726562500005e-05 4.3331613684564742e-10
+ 9.3981933593750004e-05 4.3326199773890431e-10
+ 9.3994140625000002e-05 4.3320787379407488e-10
+ 9.4006347656250001e-05 4.3315376500691365e-10
+ 9.4018554687499999e-05 4.3309967137317592e-10
+ 9.4030761718749998e-05 4.3304559288861817e-10
+ 9.4042968749999997e-05 4.3299152954899793e-10
+ 9.4055175781249995e-05 4.3293748135007384e-10
+ 9.4067382812500008e-05 4.3288344828760572e-10
+ 9.4079589843750006e-05 4.3282943035735457e-10
+ 9.4091796875000005e-05 4.3277542755508266e-10
+ 9.4104003906250004e-05 4.327214398765532e-10
+ 9.4116210937500002e-05 4.3266746731753079e-10
+ 9.4128417968750001e-05 4.3261350987378112e-10
+ 9.4140625e-05 4.3255956754107106e-10
+ 9.4152832031249998e-05 4.3250564031516869e-10
+ 9.4165039062499997e-05 4.324517281918434e-10
+ 9.4177246093749996e-05 4.3239783116686546e-10
+ 9.4189453125000008e-05 4.3234394923600652e-10
+ 9.4201660156250006e-05 4.3229008239503964e-10
+ 9.4213867187500005e-05 4.322362306397386e-10
+ 9.4226074218750004e-05 4.3218239396587857e-10
+ 9.4238281250000002e-05 4.3212857236923607e-10
+ 9.4250488281250001e-05 4.3207476584558855e-10
+ 9.42626953125e-05 4.3202097439071481e-10
+ 9.4274902343749998e-05 4.3196719800039462e-10
+ 9.4287109374999997e-05 4.3191343667040926e-10
+ 9.4299316406249996e-05 4.3185969039654094e-10
+ 9.4311523437500008e-05 4.3180595917457319e-10
+ 9.4323730468750007e-05 4.3175224300029046e-10
+ 9.4335937500000005e-05 4.3169854186947872e-10
+ 9.4348144531250004e-05 4.3164485577792515e-10
+ 9.4360351562500002e-05 4.3159118472141752e-10
+ 9.4372558593750001e-05 4.315375286957455e-10
+ 9.4384765625e-05 4.3148388769669956e-10
+ 9.4396972656249998e-05 4.3143026172007142e-10
+ 9.4409179687499997e-05 4.3137665076165393e-10
+ 9.4421386718749996e-05 4.3132305481724119e-10
+ 9.4433593750000008e-05 4.3126947388262849e-10
+ 9.4445800781250007e-05 4.3121590795361226e-10
+ 9.4458007812500005e-05 4.3116235702599014e-10
+ 9.4470214843750004e-05 4.311088210955608e-10
+ 9.4482421875000003e-05 4.3105530015812432e-10
+ 9.4494628906250001e-05 4.3100179420948178e-10
+ 9.45068359375e-05 4.3094830324543561e-10
+ 9.4519042968749999e-05 4.3089482726178914e-10
+ 9.4531249999999997e-05 4.3084136625434698e-10
+ 9.4543457031249996e-05 4.3078792021891527e-10
+ 9.4555664062500008e-05 4.3073448915130076e-10
+ 9.4567871093750007e-05 4.3068107304731183e-10
+ 9.4580078125000005e-05 4.3062767190275767e-10
+ 9.4592285156250004e-05 4.3057428571344897e-10
+ 9.4604492187500003e-05 4.305209144751974e-10
+ 9.4616699218750001e-05 4.3046755818381573e-10
+ 9.462890625e-05 4.3041421683511815e-10
+ 9.4641113281249999e-05 4.3036089042491982e-10
+ 9.4653320312499997e-05 4.3030757894903721e-10
+ 9.466552734375001e-05 4.3025428240328784e-10
+ 9.4677734375000008e-05 4.3020100078349046e-10
+ 9.4689941406250007e-05 4.3014773408546503e-10
+ 9.4702148437500006e-05 4.3009448230503257e-10
+ 9.4714355468750004e-05 4.3004124543801536e-10
+ 9.4726562500000003e-05 4.2998802348023685e-10
+ 9.4738769531250001e-05 4.2993481642752165e-10
+ 9.47509765625e-05 4.298816242756955e-10
+ 9.4763183593749999e-05 4.2982844702058526e-10
+ 9.4775390624999997e-05 4.2977528465801911e-10
+ 9.4787597656249996e-05 4.2972213718382639e-10
+ 9.4799804687500008e-05 4.296690045938374e-10
+ 9.4812011718750007e-05 4.2961588688388387e-10
+ 9.4824218750000006e-05 4.2956278404979846e-10
+ 9.4836425781250004e-05 4.2950969608741529e-10
+ 9.4848632812500003e-05 4.2945662299256918e-10
+ 9.4860839843750002e-05 4.2940356476109669e-10
+ 9.4873046875e-05 4.2935052138883517e-10
+ 9.4885253906249999e-05 4.2929749287162315e-10
+ 9.4897460937499998e-05 4.2924447920530045e-10
+ 9.4909667968749996e-05 4.2919148038570803e-10
+ 9.4921875000000008e-05 4.2913849640868801e-10
+ 9.4934082031250007e-05 4.2908552727008359e-10
+ 9.4946289062500006e-05 4.2903257296573924e-10
+ 9.4958496093750004e-05 4.2897963349150058e-10
+ 9.4970703125000003e-05 4.2892670884321429e-10
+ 9.4982910156250002e-05 4.288737990167283e-10
+ 9.49951171875e-05 4.2882090400789185e-10
+ 9.5007324218749999e-05 4.2876802381255504e-10
+ 9.5019531249999998e-05 4.2871515842656934e-10
+ 9.5031738281249996e-05 4.2866230784578723e-10
+ 9.5043945312499995e-05 4.2860947206606246e-10
+ 9.5056152343750007e-05 4.2855665108325002e-10
+ 9.5068359375000006e-05 4.2850384489320595e-10
+ 9.5080566406250004e-05 4.2845105349178732e-10
+ 9.5092773437500003e-05 4.2839827687485269e-10
+ 9.5104980468750002e-05 4.2834551503826145e-10
+ 9.51171875e-05 4.2829276797787439e-10
+ 9.5129394531249999e-05 4.2824003568955333e-10
+ 9.5141601562499998e-05 4.2818731816916134e-10
+ 9.5153808593749996e-05 4.2813461541256231e-10
+ 9.5166015624999995e-05 4.2808192741562203e-10
+ 9.5178222656249994e-05 4.2802925417420679e-10
+ 9.5190429687500006e-05 4.2797659568418397e-10
+ 9.5202636718750005e-05 4.2792395194142275e-10
+ 9.5214843750000003e-05 4.2787132294179297e-10
+ 9.5227050781250002e-05 4.2781870868116553e-10
+ 9.5239257812500001e-05 4.2776610915541303e-10
+ 9.5251464843749999e-05 4.2771352436040875e-10
+ 9.5263671874999998e-05 4.2766095429202714e-10
+ 9.5275878906249997e-05 4.2760839894614423e-10
+ 9.5288085937499995e-05 4.2755585831863669e-10
+ 9.5300292968749994e-05 4.2750333240538267e-10
+ 9.5312499999999992e-05 4.2745082120226136e-10
+ 9.5324707031250005e-05 4.2739832470515305e-10
+ 9.5336914062500003e-05 4.273458429099393e-10
+ 9.5349121093750002e-05 4.2729337581250278e-10
+ 9.5361328125000001e-05 4.2724092340872732e-10
+ 9.5373535156249999e-05 4.2718848569449787e-10
+ 9.5385742187499998e-05 4.2713606266570053e-10
+ 9.5397949218749997e-05 4.2708365431822263e-10
+ 9.5410156249999995e-05 4.270312606479525e-10
+ 9.5422363281249994e-05 4.2697888165077988e-10
+ 9.5434570312499993e-05 4.2692651732259529e-10
+ 9.5446777343750005e-05 4.2687416765929084e-10
+ 9.5458984375000003e-05 4.2682183265675928e-10
+ 9.5471191406250002e-05 4.2676951231089505e-10
+ 9.5483398437500001e-05 4.2671720661759342e-10
+ 9.5495605468749999e-05 4.2666491557275079e-10
+ 9.5507812499999998e-05 4.2661263917226478e-10
+ 9.5520019531249997e-05 4.265603774120343e-10
+ 9.5532226562499995e-05 4.265081302879591e-10
+ 9.5544433593749994e-05 4.2645589779594043e-10
+ 9.5556640624999993e-05 4.2640367993188038e-10
+ 9.5568847656249991e-05 4.2635147669168246e-10
+ 9.5581054687500004e-05 4.2629928807125108e-10
+ 9.5593261718750002e-05 4.2624711406649186e-10
+ 9.5605468750000001e-05 4.2619495467331169e-10
+ 9.561767578125e-05 4.2614280988761856e-10
+ 9.5629882812499998e-05 4.2609067970532156e-10
+ 9.5642089843749997e-05 4.2603856412233079e-10
+ 9.5654296874999996e-05 4.2598646313455786e-10
+ 9.5666503906249994e-05 4.2593437673791515e-10
+ 9.5678710937499993e-05 4.2588230492831644e-10
+ 9.5690917968749991e-05 4.2583024770167654e-10
+ 9.5703125000000004e-05 4.2577820505391141e-10
+ 9.5715332031250002e-05 4.2572617698093814e-10
+ 9.5727539062500001e-05 4.2567416347867499e-10
+ 9.573974609375e-05 4.2562216454304139e-10
+ 9.5751953124999998e-05 4.2557018016995789e-10
+ 9.5764160156249997e-05 4.2551821035534623e-10
+ 9.5776367187499996e-05 4.2546625509512913e-10
+ 9.5788574218749994e-05 4.254143143852306e-10
+ 9.5800781249999993e-05 4.2536238822157581e-10
+ 9.5812988281249992e-05 4.2531047660009089e-10
+ 9.582519531249999e-05 4.2525857951670346e-10
+ 9.5837402343750002e-05 4.252066969673418e-10
+ 9.5849609375000001e-05 4.2515482894793579e-10
+ 9.586181640625e-05 4.2510297545441604e-10
+ 9.5874023437499998e-05 4.2505113648271467e-10
+ 9.5886230468749997e-05 4.2499931202876474e-10
+ 9.5898437499999996e-05 4.2494750208850055e-10
+ 9.5910644531249994e-05 4.248957066578573e-10
+ 9.5922851562499993e-05 4.2482519493572964e-10
+ 9.5935058593749992e-05 4.2475256100502045e-10
+ 9.594726562499999e-05 4.2468173951608737e-10
+ 9.5959472656249989e-05 4.2459666096075283e-10
+ 9.5971679687500001e-05 4.2448010616874532e-10
+ 9.598388671875e-05 4.242745676347303e-10
+ 9.5989990234374999e-05 4.2406762246865748e-10
+ 9.5996093749999999e-05 4.2364446431160585e-10
+ 9.5999145507812491e-05 4.2320637096990359e-10
+ 9.6002197265624998e-05 4.2237081875579266e-10
+ 9.6005249023437491e-05 4.2039912634768696e-10
+ 9.6006606790774082e-05 4.184858057925494e-10
+ 9.6006998216660862e-05 4.1769354662518729e-10
+ 9.6007389642547642e-05 4.1673967866159501e-10
+ 9.6008368207264571e-05 4.1328644574257995e-10
+ 9.6009409502908181e-05 4.0647792025774505e-10
+ 9.6009970598735317e-05 4.0009399586852752e-10
+ 9.6010339629298369e-05 3.9400830485401903e-10
+ 9.6011110323815838e-05 3.7217296598144555e-10
+ 9.6011741481233847e-05 3.3482378565862255e-10
+ 9.601211308400901e-05 2.9476725253157392e-10
+ 9.6012434193795787e-05 2.3913652951300332e-10
+ 9.6012647097925416e-05 2.1273235713088472e-10
+ 9.6012860002055031e-05 2.1207408791108858e-10
+ 9.6014989043351239e-05 2.1185023895337551e-10
+ 9.6027196074601251e-05 2.0757980032582087e-10
+ 9.603940310585125e-05 1.9827504053149293e-10
+ 9.6051610137101249e-05 1.8447156434439206e-10
+ 9.6063817168351247e-05 1.6696410651490149e-10
+ 9.6076024199601246e-05 1.4676018343964647e-10
+ 9.6088231230851245e-05 1.2502212943217047e-10
+ 9.6100438262101243e-05 1.0300022779102304e-10
+ 9.6112645293351242e-05 8.1960799754197404e-11
+ 9.6124852324601241e-05 6.311338755160194e-11
+ 9.6137059355851239e-05 4.7541218733423125e-11
+ 9.6149266387101251e-05 3.6138949326912032e-11
+ 9.616147341835125e-05 2.9561263935700322e-11
+ 9.6173680449601249e-05 2.8185285811614418e-11
+ 9.6185887480851247e-05 3.2088955187765566e-11
+ 9.6198094512101246e-05 4.1046615499322252e-11
+ 9.6210301543351245e-05 5.4542057385810135e-11
+ 9.6222508574601243e-05 7.1798266491615728e-11
+ 9.6234715605851242e-05 9.1822160785597292e-11
+ 9.6246922637101241e-05 1.1346174161334856e-10
+ 9.6259129668351239e-05 1.3547236949090519e-10
+ 9.6271336699601238e-05 1.5658835172212636e-10
+ 9.628354373085125e-05 1.7559572435646284e-10
+ 9.6295750762101249e-05 1.9140204326212496e-10
+ 9.6307957793351247e-05 2.030991720132836e-10
+ 9.631100955116374e-05 2.0529687447679853e-10
+ 9.6311314726944992e-05 2.0549982177660819e-10
+ 9.6312077666398116e-05 2.0599366009052315e-10
+ 9.6312459136124677e-05 2.062333046850057e-10
+ 9.6312482977982595e-05 2.0624812098499301e-10
+ 9.6312487746354178e-05 2.0625108196291897e-10
+ 9.6312497283097332e-05 2.0625700163649109e-10
+ 9.6312498046036794e-05 2.0625747507891284e-10
+ 9.6312499571915691e-05 2.0625842190532621e-10
+ 9.6312499693986014e-05 2.0625849764807365e-10
+ 9.6312499938126632e-05 2.0625864913207268e-10
+ 9.6312499957657883e-05 2.0625866125070641e-10
+ 9.6312499996720387e-05 2.0625868548793557e-10
+ 9.6312500074845379e-05 8.3574849775232329e-10
+ 9.6312500152970386e-05 2.8382408459534785e-09
+ 9.6312500934220383e-05 9.7910663945931592e-08
+ 9.6312508051845977e-05 6.9281309170090845e-06
+ 9.6312515169471571e-05 2.3496919613390592e-05
+ 9.6312522287097166e-05 4.8515586154137975e-05
+ 9.631252940472276e-05 8.0864107426474553e-05
+ 9.6312536522348368e-05 0.0001195688537478285
+ 9.6312543639973962e-05 0.00016378325676260678
+ 9.6312550757599556e-05 0.00021277103077073492
+ 9.6312557875225151e-05 0.00026589161027525284
+ 9.6312564992850745e-05 0.00032258751106878353
+ 9.6312572110476339e-05 0.00038237336083026571
+ 9.6312579228101933e-05 0.00044482637875059637
+ 9.6312587807568579e-05 0.00052313156179263198
+ 9.6312596387035197e-05 0.00060422377214069478
+ 9.6312604966501843e-05 0.00068763160407692863
+ 9.6312613545968461e-05 0.00077295453496090106
+ 9.6312622125435107e-05 0.00085985181282763258
+ 9.6312630704901726e-05 0.00094803308914625053
+ 9.6312639284368371e-05 0.0010372505228311898
+ 9.631264786383499e-05 0.0011272921245865509
+ 9.6312658180770257e-05 0.0012364048498757886
+ 9.6312668497705511e-05 0.0013461799437633384
+ 9.6312678814640764e-05 0.0014563930288477433
+ 9.6312689131576018e-05 0.001566855276772596
+ 9.6312699448511272e-05 0.0016774068636345029
+ 9.6312709765446525e-05 0.001787911643031166
+ 9.6312720082381779e-05 0.0018982528107135616
+ 9.6312730399317046e-05 0.0020083293767566338
+ 9.6312742902012255e-05 0.002141246780886198
+ 9.6312755404707478e-05 0.0022735106700283729
+ 9.63127679074027e-05 0.0024050029041599369
+ 9.6312780410097922e-05 0.0025356196305195535
+ 9.6312792912793131e-05 0.0026652683340791378
+ 9.6312805415488354e-05 0.002793865545581445
+ 9.6312817918183576e-05 0.0029213350620943554
+ 9.6312830420878799e-05 0.0030476065669750823
+ 9.6312845592253873e-05 0.0031991277392290247
+ 9.6312860763628948e-05 0.0033486794005026179
+ 9.6312875935004036e-05 0.0034961593179601309
+ 9.6312891106379111e-05 0.0036414711081661105
+ 9.63129062777542e-05 0.0037845233735065873
+ 9.6312921449129274e-05 0.0039252290818992874
+ 9.6312936620504349e-05 0.0040635051254073566
+ 9.631295486051956e-05 0.0042264209820281088
+ 9.6312973100534771e-05 0.0043855785109888799
+ 9.6312991340549982e-05 0.004540852807539594
+ 9.631300958056518e-05 0.0046921255232483241
+ 9.6313027820580391e-05 0.004839284756390172
+ 9.6313046060595602e-05 0.0049822250059800644
+ 9.631306819986585e-05 0.0051499118748984281
+ 9.6313090339136099e-05 0.0053110729761570875
+ 9.6313112478406347e-05 0.0054655577982168782
+ 9.6313134617676596e-05 0.0056132299331846198
+ 9.631316129301132e-05 0.0057819364493443522
+ 9.6313187873095808e-05 0.0059398423573548687
+ 9.6313214453180296e-05 0.0060874136176253622
+ 9.631324868848434e-05 0.0062620603819550135
+ 9.6313282923788385e-05 0.0064191641307141745
+ 9.6313315356127047e-05 0.0065517091134031152
+ 9.6313347788465708e-05 0.0066683776453289999
+ 9.631338022080437e-05 0.0067692021882621509
+ 9.6313412653143045e-05 0.0068542763543729904
+ 9.6313445085481706e-05 0.0069237529436825757
+ 9.6313477517820368e-05 0.0069778416850672731
+ 9.6313509950159029e-05 0.0070168067033145008
+ 9.631354238249769e-05 0.0070409637367341727
+ 9.6313569584998142e-05 0.0070500711051410814
+ 9.6313596787498594e-05 0.0070492564131712353
+ 9.631362398999906e-05 0.0070387804986578604
+ 9.6313651192499511e-05 0.0070189238317284377
+ 9.6313678394999963e-05 0.0069899850256677273
+ 9.6313705597500415e-05 0.0069522793135452206
+ 9.6313732800000867e-05 0.0069061369988542495
+ 9.6313760002501319e-05 0.0068519018883273245
+ 9.6313787205001771e-05 0.0067899297149596706
+ 9.6313814407502236e-05 0.0067205865590935169
+ 9.6313841610002688e-05 0.0066442472751925379
+ 9.631386881250314e-05 0.006561293931672073
+ 9.6313896015003591e-05 0.0064721142708494637
+ 9.6313923217504043e-05 0.0063771001957435066
+ 9.6313950420004495e-05 0.0062766462900859356
+ 9.6313977622504947e-05 0.0061711483775146155
+ 9.6314004825005399e-05 0.0060610021255013743
+ 9.6314032027505851e-05 0.0059466016991306979
+ 9.6314059230006316e-05 0.0058283384693926773
+ 9.6314086432506768e-05 0.0057065997804302861
+ 9.6314115300883505e-05 0.0055740309990659331
+ 9.6314144169260229e-05 0.0054384272991202893
+ 9.6314173037636967e-05 0.0053002282345430132
+ 9.6314201906013704e-05 0.0051598626838551204
+ 9.6314230774390442e-05 0.0050177476630414884
+ 9.6314259642767179e-05 0.0048742872442221231
+ 9.6314288511143903e-05 0.0047298715812966012
+ 9.6314317379520641e-05 0.0045848760430473451
+ 9.6314346247897378e-05 0.0044396604535071188
+ 9.631438113516668e-05 0.0042643637747592994
+ 9.6314416022435983e-05 0.0040898203879790361
+ 9.6314449985506051e-05 0.0039211359224094145
+ 9.6314483948576119e-05 0.0037541355090310092
+ 9.6314517911646173e-05 0.0035892460195200843
+ 9.6314551874716241e-05 0.0034268598627977894
+ 9.6314585837786309e-05 0.0032673350066711841
+ 9.6314627381082822e-05 0.0030765664536155394
+ 9.6314668924379334e-05 0.0028910852643209248
+ 9.6314710467675847e-05 0.0027113416169293153
+ 9.631475201097236e-05 0.0025377141992044784
+ 9.6314802322523103e-05 0.0023360685105670866
+ 9.6314853125173641e-05 0.0021424443576868821
+ 9.6314903927824166e-05 0.001959156496722657
+ 9.6314971607266254e-05 0.0017313192252947558
+ 9.6315039286708329e-05 0.0015222190408349249
+ 9.6315091919396562e-05 0.001372431253814393
+ 9.6315144552084809e-05 0.0012336381966261724
+ 9.6315197184773055e-05 0.0011055447342070166
+ 9.6315249817461302e-05 0.00098778684645394604
+ 9.6315297809929104e-05 0.00088906516794052203
+ 9.6315345802396905e-05 0.00079823747715313789
+ 9.6315393794864707e-05 0.00071492972227882204
+ 9.6315441787332508e-05 0.00063875107498295779
+ 9.631548977980031e-05 0.00056929990178360005
+ 9.6315537261554868e-05 0.00050680910974394439
+ 9.6315584743309412e-05 0.00045011010916966049
+ 9.6315632225063956e-05 0.00039881145821643485
+ 9.6315679706818514e-05 0.00035252854906615789
+ 9.6315727188573058e-05 0.00031088653907439246
+ 9.6315774670327616e-05 0.0002735227890958723
+ 9.6315824358583364e-05 0.00023862511600889196
+ 9.6315874046839126e-05 0.00020765025205703798
+ 9.6315923735094874e-05 0.00018023763188315632
+ 9.6315973423350635e-05 0.00015604795426756195
+ 9.6316023111606396e-05 0.0001347637411803884
+ 9.6316072799862144e-05 0.00011608953467670693
+ 9.6316127951386076e-05 9.8086983151495662e-05
+ 9.6316183102910008e-05 8.2620379659707852e-05
+ 9.6316238254433927e-05 6.937830638173144e-05
+ 9.6316293405957859e-05 5.8079646203919961e-05
+ 9.6316348557481778e-05 4.8471998343402797e-05
+ 9.6316411640520543e-05 3.9267448447275403e-05
+ 9.6316474723559295e-05 3.1683839518460041e-05
+ 9.6316537806598061e-05 2.5463033689023789e-05
+ 9.6316600889636813e-05 2.0382309617297274e-05
+ 9.631667414014642e-05 1.5662206653736814e-05
+ 9.6316747390656041e-05 1.1971024407425274e-05
+ 9.6316820641165649e-05 9.101093726216712e-06
+ 9.6316905619421581e-05 6.5781195004269459e-06
+ 9.6316990597677526e-05 4.7207090840830405e-06
+ 9.6317093836844781e-05 3.1245246960755978e-06
+ 9.631719817176942e-05 2.0371887602864823e-06
+ 9.6317302506694044e-05 1.3141391771344707e-06
+ 9.631742666446917e-05 7.6923430377838728e-07
+ 9.6317550822244281e-05 4.435788450454647e-07
+ 9.6317705800806532e-05 2.1851475951109054e-07
+ 9.6317884937131785e-05 9.3708673373505121e-08
+ 9.6318098556602395e-05 3.2883700516734768e-08
+ 9.6318364485722957e-05 8.5309004428172277e-09
+ 9.6318717982712206e-05 1.4552417250701691e-09
+ 9.6319242097564148e-05 3.0578689270965244e-10
+ 9.6320136340120481e-05 2.4569663308855879e-10
+ 9.6322132807185039e-05 2.4259754686171839e-10
+ 9.6323988816858017e-05 2.4182034068072913e-10
+ 9.6326421668443081e-05 2.4138174969930913e-10
+ 9.6328854520028146e-05 2.4076582964276258e-10
+ 9.633128737161321e-05 2.4012576594620444e-10
+ 9.6333720223198274e-05 2.4057963384973803e-10
+ 9.6336153074783339e-05 2.4092919901400983e-10
+ 9.6338585926368403e-05 2.401872610697499e-10
+ 9.6341018777953467e-05 2.3987554496708928e-10
+ 9.6343451629538532e-05 2.4037942571475707e-10
+ 9.6345767705239779e-05 2.4025247901632375e-10
+ 9.6348819440406717e-05 2.4017887589128354e-10
+ 9.6351871175573656e-05 2.4009951114703349e-10
+ 9.6354922910740594e-05 2.4004351142745323e-10
+ 9.6357974645907532e-05 2.4016098617015712e-10
+ 9.636102638107447e-05 2.4071442426522539e-10
+ 9.6364078116241409e-05 2.3968616681674537e-10
+ 9.6367773618773596e-05 2.4003007462135484e-10
+ 9.6371134288610914e-05 2.4006402385879101e-10
+ 9.6374494958448219e-05 2.4006047129867007e-10
+ 9.6378620731690283e-05 2.4005210497337081e-10
+ 9.6382746504932332e-05 2.4004042399080182e-10
+ 9.6386872278174396e-05 2.4003044384477591e-10
+ 9.6390998051416459e-05 2.4003749578386358e-10
+ 9.6395123824658522e-05 2.4008180521387353e-10
+ 9.6400251138437098e-05 2.4016443526047099e-10
+ 9.6405378452215675e-05 2.3985136550844345e-10
+ 9.6410505765994264e-05 2.3994252727381691e-10
+ 9.6415633079772841e-05 2.4004700010028028e-10
+ 9.6421995979825147e-05 2.4004483697536087e-10
+ 9.6428358879877468e-05 2.3997024527683999e-10
+ 9.6434721779929775e-05 2.3997592655072043e-10
+ 9.6442497256254506e-05 2.4000749931504923e-10
+ 9.645027273257925e-05 2.4001269631983051e-10
+ 9.6458048208903995e-05 2.3999782508278659e-10
+ 9.6467983441936064e-05 2.3999355892689472e-10
+ 9.6477918674968147e-05 2.4000179472492324e-10
+ 9.6490125706218146e-05 2.4000339716614338e-10
+ 9.6502332737468145e-05 2.3999888202599127e-10
+ 9.6514539768718143e-05 2.3999830525938688e-10
+ 9.6526746799968142e-05 2.4000037974237526e-10
+ 9.6538953831218141e-05 2.4000087414852165e-10
+ 9.6551160862468139e-05 2.3999993966201389e-10
+ 9.6563367893718138e-05 2.3999960494882817e-10
+ 9.6575574924968137e-05 2.4000001432309894e-10
+ 9.6587781956218149e-05 2.4000021737723387e-10
+ 9.6599988987468148e-05 2.4000004462513988e-10
+ 9.6612196018718146e-05 2.3999993006727966e-10
+ 9.6624403049968145e-05 2.3999999917748096e-10
+ 9.6636610081218143e-05 2.4000006049017395e-10
+ 9.6648817112468142e-05 2.4000003421757239e-10
+ 9.6661024143718141e-05 2.4000000237870328e-10
+ 9.6673231174968139e-05 2.4000001256652595e-10
+ 9.6685438206218138e-05 2.4000002745854788e-10
+ 9.6697645237468137e-05 2.4000002475271839e-10
+ 9.6709852268718135e-05 2.4000001795384735e-10
+ 9.6722059299968148e-05 2.400000173879749e-10
+ 9.6734266331218146e-05 2.4000002070407596e-10
+ 9.6746473362468145e-05 2.4000002067419452e-10
+ 9.6758680393718144e-05 2.4000001976473751e-10
+ 9.6770887424968142e-05 2.40000019362722e-10
+ 9.6783094456218141e-05 2.4000002028128461e-10
+ 9.679530148746814e-05 2.4000002060646208e-10
+ 9.6807508518718138e-05 2.4000002008287723e-10
+ 9.6819715549968137e-05 2.4000001934276911e-10
+ 9.6831922581218136e-05 2.4000001968966948e-10
+ 9.6844129612468148e-05 2.4000002093381111e-10
+ 9.6856336643718146e-05 2.4000001965726013e-10
+ 9.6868543674968145e-05 2.4000001961507071e-10
+ 9.6880750706218144e-05 2.4000002048512451e-10
+ 9.6892957737468142e-05 2.4000001998121006e-10
+ 9.6905164768718141e-05 2.400000199764228e-10
+ 9.691737179996814e-05 2.4000001998665694e-10
+ 9.6929578831218138e-05 2.4000001988395378e-10
+ 9.6941785862468137e-05 2.4000001969840786e-10
+ 9.6953992893718136e-05 2.4000001962628526e-10
+ 9.6966199924968134e-05 2.4000001985975601e-10
+ 9.6978406956218147e-05 2.4000001994562599e-10
+ 9.6990613987468145e-05 2.4000001873790616e-10
+ 9.7002821018718144e-05 2.400000206888198e-10
+ 9.7015028049968142e-05 2.4000002115772409e-10
+ 9.7027235081218141e-05 2.4000001926167516e-10
+ 9.703944211246814e-05 2.4000001865095655e-10
+ 9.7051649143718138e-05 2.4000002024868279e-10
+ 9.7063856174968137e-05 2.4000002062807212e-10
+ 9.7076063206218136e-05 2.4000001971246058e-10
+ 9.7088270237468134e-05 2.4000001913611468e-10
+ 9.7100477268718147e-05 2.4000001939609548e-10
+ 9.7112684299968145e-05 2.4000001928925776e-10
+ 9.7124891331218144e-05 2.4000002036211893e-10
+ 9.7137098362468143e-05 2.4000001948566678e-10
+ 9.7149305393718141e-05 2.40000020557049e-10
+ 9.716151242496814e-05 2.400000203491446e-10
+ 9.7173719456218139e-05 2.4000001961720044e-10
+ 9.7185926487468137e-05 2.400000200808237e-10
+ 9.7198133518718136e-05 2.4000002006495584e-10
+ 9.7210340549968135e-05 2.4000001941755901e-10
+ 9.7222547581218133e-05 2.4000001925514504e-10
+ 9.7234754612468145e-05 2.4000001949494439e-10
+ 9.7246961643718144e-05 2.4000001987457185e-10
+ 9.7259168674968143e-05 2.4000001956535886e-10
+ 9.7271375706218141e-05 2.4000001976899341e-10
+ 9.728358273746814e-05 2.4000001989767335e-10
+ 9.7295789768718139e-05 2.4000002010421042e-10
+ 9.7307996799968137e-05 2.4000002031692612e-10
+ 9.7320203831218136e-05 2.4000001943796074e-10
+ 9.7332410862468135e-05 2.4000001979057998e-10
+ 9.7344617893718133e-05 2.4000001994141042e-10
+ 9.7356824924968132e-05 2.4000001910787902e-10
+ 9.7369031956218144e-05 2.4000002014157438e-10
+ 9.7381238987468143e-05 2.4000002007976212e-10
+ 9.7393446018718141e-05 2.4000001897875313e-10
+ 9.740565304996814e-05 2.4000002030066949e-10
+ 9.7417860081218139e-05 2.4000002070432142e-10
+ 9.7430067112468137e-05 2.4000001950520541e-10
+ 9.7442274143718136e-05 2.4000001947980057e-10
+ 9.7454481174968135e-05 2.4000002027253361e-10
+ 9.7466688206218133e-05 2.40000020609859e-10
+ 9.7478895237468132e-05 2.4000001911322354e-10
+ 9.7491102268718131e-05 2.4000001969739074e-10
+ 9.7503309299968143e-05 2.4000002073053612e-10
+ 9.7515516331218142e-05 2.4000001994814067e-10
+ 9.752772336246814e-05 2.4000001923239209e-10
+ 9.7539930393718139e-05 2.4000002015288261e-10
+ 9.7552137424968138e-05 2.4000001930210656e-10
+ 9.7564344456218136e-05 2.4000001837686493e-10
+ 9.7576551487468135e-05 2.4000001946449939e-10
+ 9.7588758518718133e-05 2.4000002038326192e-10
+ 9.7600965549968132e-05 2.400000203109469e-10
+ 9.7613172581218144e-05 2.400000203952259e-10
+ 9.7625379612468143e-05 2.4000001970496741e-10
+ 9.7637586643718142e-05 2.4000001924454606e-10
+ 9.764979367496814e-05 2.4000001905466872e-10
+ 9.7662000706218139e-05 2.400000204518705e-10
+ 9.7674207737468138e-05 2.4000002011557764e-10
+ 9.7686414768718136e-05 2.4000001946831419e-10
+ 9.7698621799968135e-05 2.4000001925940771e-10
+ 9.7710828831218147e-05 2.4000001980987061e-10
+ 9.7723035862468146e-05 2.4000002089319245e-10
+ 9.7735242893718144e-05 2.4000001973823067e-10
+ 9.7747449924968143e-05 2.4000001879346328e-10
+ 9.7759656956218142e-05 2.4000001869932423e-10
+ 9.777186398746814e-05 2.4000002074828773e-10
+ 9.7784071018718139e-05 2.4000001934026167e-10
+ 9.7796278049968138e-05 2.4000001952115826e-10
+ 9.780848508121815e-05 2.4000001987859593e-10
+ 9.7820692112468149e-05 2.400000198982881e-10
+ 9.7832899143718147e-05 2.40000018977687e-10
+ 9.7845106174968146e-05 2.4000001970468766e-10
+ 9.7857313206218145e-05 2.4000001969944985e-10
+ 9.7869520237468143e-05 2.4000002027367879e-10
+ 9.7881727268718142e-05 2.4000001840031488e-10
+ 9.7893934299968141e-05 2.4000001957318321e-10
+ 9.7906141331218153e-05 2.400000188108562e-10
+ 9.7918348362468151e-05 2.4000002046679305e-10
+ 9.793055539371815e-05 2.4000001950571268e-10
+ 9.7942762424968149e-05 2.4000001838116472e-10
+ 9.7954969456218147e-05 2.4000001853089837e-10
+ 9.7967176487468146e-05 2.4000002004811227e-10
+ 9.7979383518718145e-05 2.4000001966057371e-10
+ 9.7991590549968143e-05 2.4000001941089245e-10
+ 9.8003797581218156e-05 2.4000001913185568e-10
+ 9.8016004612468154e-05 2.4000001954838558e-10
+ 9.8028211643718153e-05 2.4000001920964592e-10
+ 9.8040418674968152e-05 2.4000001943469307e-10
+ 9.805262570621815e-05 2.4000001866641258e-10
+ 9.8064832737468149e-05 2.4000002020897109e-10
+ 9.8077039768718147e-05 2.4000001940179987e-10
+ 9.8089246799968146e-05 2.4000001993507329e-10
+ 9.8101453831218158e-05 2.4000002008198123e-10
+ 9.8113660862468157e-05 2.400000198005213e-10
+ 9.8125867893718156e-05 2.4000001916301211e-10
+ 9.8138074924968154e-05 2.4000001960280073e-10
+ 9.8150281956218153e-05 2.4000001963117276e-10
+ 9.8162488987468152e-05 2.400000196254434e-10
+ 9.817469601871815e-05 2.4000002030623543e-10
+ 9.8186903049968149e-05 2.4000001985486468e-10
+ 9.8199110081218161e-05 2.4000001975560508e-10
+ 9.821131711246816e-05 2.4000002002563028e-10
+ 9.8223524143718158e-05 2.4000001880683233e-10
+ 9.8235731174968157e-05 2.400000186107882e-10
+ 9.8247938206218156e-05 2.4000002026174485e-10
+ 9.8260145237468154e-05 2.4000001964579944e-10
+ 9.8272352268718153e-05 2.4000001869414737e-10
+ 9.8284559299968152e-05 2.4000002024855297e-10
+ 9.8296766331218164e-05 2.4000001886895933e-10
+ 9.8308973362468163e-05 2.4000001996539064e-10
+ 9.8321180393718161e-05 2.4000001852201533e-10
+ 9.833338742496816e-05 2.4000001995376353e-10
+ 9.8345594456218159e-05 2.4000001885033681e-10
+ 9.8357801487468157e-05 2.400000202275795e-10
+ 9.8370008518718156e-05 2.4000001938682899e-10
+ 9.8382215549968155e-05 2.400000185286626e-10
+ 9.8394422581218167e-05 2.4000002021567022e-10
+ 9.8406629612468165e-05 2.4000001929093104e-10
+ 9.8418836643718164e-05 2.4000001945502139e-10
+ 9.8431043674968163e-05 2.4000001849176264e-10
+ 9.8443250706218161e-05 2.4000001899160695e-10
+ 9.845545773746816e-05 2.4000001908469775e-10
+ 9.8467664768718159e-05 2.4000002021320925e-10
+ 9.8479871799968157e-05 2.4000001986077044e-10
+ 9.849207883121817e-05 2.4000001985660228e-10
+ 9.8504285862468168e-05 2.4000001982734366e-10
+ 9.8516492893718167e-05 2.4000001909394165e-10
+ 9.8528699924968166e-05 2.4000001971428865e-10
+ 9.8540906956218164e-05 2.4000001921042243e-10
+ 9.8553113987468163e-05 2.400000190589926e-10
+ 9.8565321018718161e-05 2.400000192770844e-10
+ 9.857752804996816e-05 2.4000001876027354e-10
+ 9.8589735081218172e-05 2.4000001963225885e-10
+ 9.8601942112468171e-05 2.4000001898595255e-10
+ 9.861414914371817e-05 2.4000001876650681e-10
+ 9.8626356174968168e-05 2.4000001955479303e-10
+ 9.8638563206218167e-05 2.400000192149284e-10
+ 9.8650770237468166e-05 2.4000001962818762e-10
+ 9.8662977268718164e-05 2.400000192259498e-10
+ 9.8675184299968163e-05 2.4000001958046752e-10
+ 9.8687391331218175e-05 2.4000001876653049e-10
+ 9.8699598362468174e-05 2.4000001901679062e-10
+ 9.8711805393718172e-05 2.4000001929188411e-10
+ 9.8724012424968171e-05 2.4000001878460593e-10
+ 9.873621945621817e-05 2.4000001895149019e-10
+ 9.8748426487468168e-05 2.4000001953324466e-10
+ 9.8760633518718167e-05 2.4000001930179932e-10
+ 9.8772840549968166e-05 2.4000001867284628e-10
+ 9.8785047581218178e-05 2.4000001876404646e-10
+ 9.8797254612468177e-05 2.4000001844012502e-10
+ 9.8809461643718175e-05 2.4000001847700822e-10
+ 9.8821668674968174e-05 2.4000001848915366e-10
+ 9.8833875706218173e-05 2.4000001847211049e-10
+ 9.8846082737468171e-05 2.4000001842583542e-10
+ 9.885828976871817e-05 2.4000001874485954e-10
+ 9.8870496799968169e-05 2.4000001864470591e-10
+ 9.8882703831218181e-05 2.400000192645186e-10
+ 9.8894910862468179e-05 2.4000001911011029e-10
+ 9.8907117893718178e-05 2.400000189594016e-10
+ 9.8919324924968177e-05 2.4000001834385696e-10
+ 9.8931531956218175e-05 2.4000001923683012e-10
+ 9.8943738987468174e-05 2.4000002008098464e-10
+ 9.8955946018718173e-05 2.400000183211859e-10
+ 9.8968153049968171e-05 2.4000001983070817e-10
+ 9.8980360081218184e-05 2.4000001841550595e-10
+ 9.8992567112468182e-05 2.4000001987140726e-10
+ 9.9004774143718181e-05 2.4000001839799459e-10
+ 9.9016981174968179e-05 2.4000001979564812e-10
+ 9.9029188206218178e-05 2.4000001826400317e-10
+ 9.9041395237468177e-05 2.3996544537098469e-10
+ 9.9053602268718175e-05 2.3996256464191007e-10
+ 9.9065809299968174e-05 2.3996062147298765e-10
+ 9.9078016331218186e-05 2.399538992151035e-10
+ 9.9090223362468185e-05 2.3990864356794482e-10
+ 9.9102430393718184e-05 2.3980391697569448e-10
+ 9.9114637424968182e-05 2.3960325885649169e-10
+ 9.9120740940593182e-05 2.3930636780140344e-10
+ 9.9126844456218181e-05 2.3825018349924986e-10
+ 9.9129896214030687e-05 2.3664385617022961e-10
+ 9.913294797184318e-05 2.313460144418538e-10
+ 9.9134473850749427e-05 2.2273712950258841e-10
+ 9.9135999729655687e-05 1.9502932447418286e-10
+ 9.913699110688918e-05 1.3263414891107653e-10
+ 9.9137269733896239e-05 9.5672269136980181e-11
+ 9.9137548360903299e-05 4.6113023016783446e-11
+ 9.9138098835627967e-05 4.077304569289076e-11
+ 9.9140875273912433e-05 4.2347131994264368e-11
+ 9.9153082305162432e-05 4.4733371018365243e-11
+ 9.9165289336412431e-05 5.3058719093237963e-11
+ 9.9177496367662443e-05 6.5249849962529414e-11
+ 9.9189703398912442e-05 8.0586557341896391e-11
+ 9.920191043016244e-05 9.8186059694000248e-11
+ 9.9214117461412439e-05 1.1703587328666208e-10
+ 9.9226324492662438e-05 1.3605185310399104e-10
+ 9.9238531523912436e-05 1.5414054504639482e-10
+ 9.9250738555162435e-05 1.7026206156240515e-10
+ 9.9262945586412447e-05 1.8348986297121229e-10
+ 9.9275152617662446e-05 1.9306400774952091e-10
+ 9.9287359648912444e-05 1.9843481134517081e-10
+ 9.9299566680162443e-05 1.9929440536940058e-10
+ 9.9311773711412442e-05 1.9559438520732841e-10
+ 9.932398074266244e-05 1.8754853451668201e-10
+ 9.9336187773912439e-05 1.7562047328816539e-10
+ 9.9348394805162438e-05 1.6049694315998822e-10
+ 9.9360601836412436e-05 1.4304826930135124e-10
+ 9.9372808867662448e-05 1.2427827523140709e-10
+ 9.9385015898912447e-05 1.052665328361379e-10
+ 9.9397222930162446e-05 8.7106269937226752e-11
+ 9.9409429961412444e-05 7.0841506734532094e-11
+ 9.9421636992662443e-05 5.7407035899497847e-11
+ 9.9433844023912442e-05 4.7574696846103914e-11
+ 9.9436895781724948e-05 4.5750674856066197e-11
+ 9.9437048369615567e-05 4.5666462612461995e-11
+ 9.9437429839342129e-05 4.5458870923120094e-11
+ 9.9437467986314784e-05 4.5438342991126504e-11
+ 9.9437475615709323e-05 4.5434242455099145e-11
+ 9.9437490874498388e-05 4.5426046434154427e-11
+ 9.9437496978014003e-05 4.5422769911655126e-11
+ 9.9437499419420265e-05 4.542145960441293e-11
+ 9.9437499604455791e-05 4.5421360302533612e-11
+ 9.9437499974526844e-05 4.5421161701746532e-11
+ 9.943750071466895e-05 5.7234708751505077e-08
+ 9.9437501454811055e-05 2.3609835104101694e-07
+ 9.9437508856232152e-05 8.3378657603255145e-06
+ 9.9437516257653235e-05 2.6804211983519737e-05
+ 9.9437523659074331e-05 5.4212572160978158e-05
+ 9.9437531060495414e-05 8.9333429400249197e-05
+ 9.9437538461916511e-05 0.00013110387761772142
+ 9.9437547512355688e-05 0.00018988604042548046
+ 9.9437556562794865e-05 0.000255812068272275
+ 9.9437565613234055e-05 0.00032768193023753725
+ 9.9437574663673232e-05 0.00040448949601993325
+ 9.9437583714112409e-05 0.00048539058840956265
+ 9.9437595044533507e-05 0.00059137048504824714
+ 9.9437606374954606e-05 0.00070151686849491022
+ 9.9437617705375704e-05 0.0008149054011463608
+ 9.9437629035796802e-05 0.00093078918228233572
+ 9.9437643214653364e-05 0.0010784080416500865
+ 9.9437657393509912e-05 0.0012280520970111633
+ 9.9437671572366474e-05 0.0013789889014004875
+ 9.9437689032396938e-05 0.0015657925325384681
+ 9.9437706492427403e-05 0.0017528666320927736
+ 9.9437723952457868e-05 0.0019395804048633696
+ 9.943774626847783e-05 0.0021769293571718938
+ 9.9437768584497807e-05 0.0024120996791847497
+ 9.943779090051777e-05 0.0026444704336099976
+ 9.9437819090217246e-05 0.0029332237971511233
+ 9.9437847279916709e-05 0.0032158629328255771
+ 9.9437875469616185e-05 0.0034916668520790159
+ 9.9437903659315647e-05 0.0037599988278231356
+ 9.9437931849015123e-05 0.0040202830355208904
+ 9.9437960038714586e-05 0.0042719918874605982
+ 9.9437988228414062e-05 0.0045146394015623476
+ 9.9438019414106477e-05 0.0047719795450323309
+ 9.9438050599798879e-05 0.0050171295125712645
+ 9.9438081785491295e-05 0.0052495906087394869
+ 9.943811297118371e-05 0.0054689190353913904
+ 9.9438150418414343e-05 0.0057143885297757718
+ 9.9438187865644962e-05 0.0059397992525804574
+ 9.9438225312875595e-05 0.006144702220679193
+ 9.9438270844195805e-05 0.0063657430322260553
+ 9.9438316375516028e-05 0.0065556175023236875
+ 9.9438361906836238e-05 0.0067142112673811444
+ 9.9438407438156448e-05 0.0068416534980290083
+ 9.9438441084028113e-05 0.0069160175765833089
+ 9.9438474729899779e-05 0.0069737900261410465
+ 9.9438508375771444e-05 0.0070152594941248576
+ 9.943854202164311e-05 0.0070407746969006688
+ 9.9438575667514775e-05 0.007050740823760393
+ 9.9438609313386441e-05 0.0070456156939712805
+ 9.9438642959258106e-05 0.007025905702338452
+ 9.9438676605129772e-05 0.0069921615895264296
+ 9.9438710251001437e-05 0.0069449740739896257
+ 9.9438736870668154e-05 0.006898526876910809
+ 9.9438763490334857e-05 0.0068443802044164921
+ 9.9438790110001574e-05 0.0067828688534493494
+ 9.9438816729668277e-05 0.0067143369242957376
+ 9.9438843349334993e-05 0.0066391364097472113
+ 9.9438869969001697e-05 0.0065576257964309343
+ 9.9438896588668413e-05 0.0064701686843428533
+ 9.9438923208335116e-05 0.0063771324303375145
+ 9.9438949828001833e-05 0.0062788868210215225
+ 9.943897644766855e-05 0.0061758027801676225
+ 9.9439003067335253e-05 0.0060682511154162089
+ 9.9439029687001969e-05 0.0059566013086644297
+ 9.9439056306668673e-05 0.0058412203541628417
+ 9.9439082926335389e-05 0.0057224716479485063
+ 9.9439109546002092e-05 0.0056007139318451742
+ 9.9439136165668809e-05 0.0054763002948580381
+ 9.9439162785335526e-05 0.0053495772343856614
+ 9.9439189405002229e-05 0.0052208837792675896
+ 9.9439216024668946e-05 0.0050905506764474901
+ 9.9439239404935229e-05 0.0049749804171373225
+ 9.9439262785201512e-05 0.0048586054363550972
+ 9.9439286165467809e-05 0.0047416314482211135
+ 9.9439309545734092e-05 0.0046242577652878883
+ 9.9439332926000388e-05 0.0045066770343838705
+ 9.9439356306266671e-05 0.0043890750025309139
+ 9.9439379686532955e-05 0.0042716303126259531
+ 9.9439403066799251e-05 0.0041545143284691553
+ 9.9439426447065534e-05 0.0040378909886185305
+ 9.9439449827331817e-05 0.0039219166884552218
+ 9.9439473207598114e-05 0.0038067401897542695
+ 9.9439496587864397e-05 0.0036925025569730643
+ 9.9439519968130694e-05 0.0035793371193940525
+ 9.9439543348396977e-05 0.0034673694581895016
+ 9.943956672866326e-05 0.0033567174174145066
+ 9.9439590108929557e-05 0.0032474911378798247
+ 9.943961348919584e-05 0.0031397931128086067
+ 9.9439636869462123e-05 0.0030337182641405314
+ 9.943966024972842e-05 0.0029293540383132049
+ 9.9439683629994703e-05 0.0028267805203238136
+ 9.9439707010261e-05 0.0027260705648536779
+ 9.943973559123752e-05 0.0026055855381113117
+ 9.9439764172214041e-05 0.0024880893416989024
+ 9.9439792753190561e-05 0.0023736731389782805
+ 9.9439821334167095e-05 0.0022624136400195647
+ 9.9439849915143616e-05 0.0021543736566158275
+ 9.9439886199806214e-05 0.0020219271947776738
+ 9.943992545337338e-05 0.0018846580284455387
+ 9.9439946977215266e-05 0.0018120618774395494
+ 9.9439973696714695e-05 0.0017245821083065652
+ 9.9440000416214138e-05 0.0016400258203643724
+ 9.9440027135713568e-05 0.0015583844444338579
+ 9.944005385521301e-05 0.0014796423351417674
+ 9.944008057471244e-05 0.0014037772468436488
+ 9.9440107294211883e-05 0.0013307608065583204
+ 9.9440134013711312e-05 0.0012605589819463642
+ 9.9440160733210755e-05 0.0011931325425094006
+ 9.9440187452710184e-05 0.0011284375123336611
+ 9.9440214172209627e-05 0.0010664256128491564
+ 9.9440240891709056e-05 0.0010070446942234952
+ 9.9440262548859616e-05 0.00096080661895637035
+ 9.9440284206010163e-05 0.0009162294538821239
+ 9.944030586316071e-05 0.00087328092606094238
+ 9.944032752031127e-05 0.00083192771752318962
+ 9.9440349177461817e-05 0.00079213559354230647
+ 9.9440370834612377e-05 0.00075386952625768001
+ 9.9440392491762923e-05 0.00071709381353394315
+ 9.944041414891347e-05 0.00068177219296354193
+ 9.944043580606403e-05 0.00064786795094112185
+ 9.9440457463214577e-05 0.00061534402675914772
+ 9.9440479120365137e-05 0.00058416311167918647
+ 9.9440496765399605e-05 0.00055972551886932095
+ 9.9440514410434073e-05 0.00053613426244406741
+ 9.9440532055468554e-05 0.00051336904748169171
+ 9.9440549700503022e-05 0.00049140960981622914
+ 9.9440567345537503e-05 0.00047023574348777509
+ 9.9440584990571971e-05 0.00044982732676715286
+ 9.9440602635606453e-05 0.00043016434677204047
+ 9.9440620280640921e-05 0.00041122692269401575
+ 9.9440637925675388e-05 0.00039299532765819798
+ 9.944065557070987e-05 0.00037545000923921415
+ 9.9440673215744338e-05 0.00035857160865911174
+ 9.9440690860778819e-05 0.00034234097869457157
+ 9.9440708505813287e-05 0.00032673920032235228
+ 9.9440726150847768e-05 0.00031174759813332067
+ 9.9440743795882236e-05 0.00029734775454669758
+ 9.9440761440916704e-05 0.00028352152285727745
+ 9.9440779085951185e-05 0.0002702510391493668
+ 9.9440796730985653e-05 0.00025751873311203796
+ 9.9440814376020135e-05 0.00024530733779101174
+ 9.9440832021054602e-05 0.00023359989831307307
+ 9.9440849666089084e-05 0.00022237977961939102
+ 9.9440867311123552e-05 0.00021163067324446447
+ 9.9440884956158033e-05 0.00020133660317765155
+ 9.9440902601192501e-05 0.00019148193084437179
+ 9.9440920246226969e-05 0.00018205135924409671
+ 9.944093789126145e-05 0.00017302993628217709
+ 9.9440955536295918e-05 0.00016440305733239472
+ 9.9440973181330399e-05 0.00015615646706688136
+ 9.9440990826364867e-05 0.00014827626058972067
+ 9.9441008471399348e-05 0.00014074888391014853
+ 9.9441026116433816e-05 0.00013356113379079491
+ 9.9441043761468298e-05 0.00012670015700587552
+ 9.9441061406502766e-05 0.00012015344904364461
+ 9.9441079051537233e-05 0.00011390885228677083
+ 9.9441096696571715e-05 0.00010795455370359766
+ 9.9441114341606183e-05 0.00010227908208250491
+ 9.9441131986640664e-05 9.687130484080241e-05
+ 9.9441149631675132e-05 9.1720424438765868e-05
+ 9.9441167276709613e-05 8.6815974428572379e-05
+ 9.9441184921744081e-05 8.2147815167013072e-05
+ 9.9441202566778549e-05 7.7706129219957601e-05
+ 9.944122021181303e-05 7.3481416485622882e-05
+ 9.9441237856847498e-05 6.9464489062760908e-05
+ 9.944125550188198e-05 6.5646465888930612e-05
+ 9.9441273146916447e-05 6.2018767173060703e-05
+ 9.9441290791950929e-05 5.8573108645546759e-05
+ 9.9441308436985397e-05 5.5301495648160228e-05
+ 9.9441326082019864e-05 5.2196217085081444e-05
+ 9.9441343727054346e-05 4.9249839255407143e-05
+ 9.9441361372088814e-05 4.6455199586526805e-05
+ 9.9441379017123295e-05 4.3805400286814076e-05
+ 9.9441396662157763e-05 4.1293801935142287e-05
+ 9.9441414307192244e-05 3.8914017023807698e-05
+ 9.9441431952226712e-05 3.6659903470533496e-05
+ 9.9441449597261194e-05 3.4525558114332587e-05
+ 9.9441467242295661e-05 3.2505310209129923e-05
+ 9.9441484887330129e-05 3.0593714928186798e-05
+ 9.9441502532364611e-05 2.878554689153125e-05
+ 9.9441520177399078e-05 2.7075793727781893e-05
+ 9.944153782243356e-05 2.5459649680957857e-05
+ 9.9441555467468028e-05 2.3932509272096093e-05
+ 9.9441573112502509e-05 2.2489961024749567e-05
+ 9.9441590757536977e-05 2.1127781262716843e-05
+ 9.9441608402571458e-05 1.9841927987655173e-05
+ 9.9441626047605926e-05 1.8628534843556469e-05
+ 9.9441643692640394e-05 1.7483905174418017e-05
+ 9.9441661337674875e-05 1.6404506180818473e-05
+ 9.9441682620107574e-05 1.5184596516820046e-05
+ 9.9441702745281684e-05 1.4108722156777394e-05
+ 9.944172287045578e-05 1.3103783271809466e-05
+ 9.9441742995629891e-05 1.2165512099818384e-05
+ 9.9441763120803987e-05 1.1289867233639744e-05
+ 9.9441783245978084e-05 1.0473023791237365e-05
+ 9.9441803371152194e-05 9.711363860421274e-06
+ 9.9441823496326291e-05 9.0014672215583367e-06
+ 9.9441843621500401e-05 8.3401023506671107e-06
+ 9.9441863746674498e-05 7.7242177042852387e-06
+ 9.944188811074613e-05 7.0353574872189284e-06
+ 9.9441912474817749e-05 6.4041509733236313e-06
+ 9.9441936838889382e-05 5.8261375978047346e-06
+ 9.9441961202961015e-05 5.2971679183216326e-06
+ 9.9441985567032634e-05 4.8133849648221628e-06
+ 9.9442009931104266e-05 4.3712064413582404e-06
+ 9.9442034295175899e-05 3.9673077642003495e-06
+ 9.9442058659247518e-05 3.5986059186122073e-06
+ 9.944208302331915e-05 3.2622441148827113e-06
+ 9.9442107387390769e-05 2.955577222710442e-06
+ 9.9442136719683576e-05 2.6223173518557521e-06
+ 9.9442166051976369e-05 2.3246430183300364e-06
+ 9.9442195384269162e-05 2.0589938235170389e-06
+ 9.9442224716561956e-05 1.8221375097881734e-06
+ 9.9442254048854749e-05 1.6111428978970881e-06
+ 9.9442283381147542e-05 1.4233547079677823e-06
+ 9.9442312713440335e-05 1.2563701699769522e-06
+ 9.9442342045733128e-05 1.1080173307665688e-06
+ 9.9442377848029192e-05 9.4935328593955194e-07
+ 9.9442412335454627e-05 8.1703614317247063e-07
+ 9.9442446822880061e-05 7.0231034037170861e-07
+ 9.9442481310305496e-05 6.0295931014601184e-07
+ 9.944251579773093e-05 5.1702814794412422e-07
+ 9.9442557828321215e-05 4.2796498791424164e-07
+ 9.9442599858911486e-05 3.5358466304975593e-07
+ 9.9442641889501771e-05 2.9157919961691281e-07
+ 9.9442683920092042e-05 2.3998333476715486e-07
+ 9.9442725950682327e-05 1.9712710629082681e-07
+ 9.9442777518503426e-05 1.5442331314774624e-07
+ 9.9442828186666477e-05 1.2110746118199679e-07
+ 9.9442878854829543e-05 9.4668212428266369e-08
+ 9.9442929522992594e-05 7.3741045625230226e-08
+ 9.9442993215143459e-05 5.3572482382509411e-08
+ 9.9443056907294323e-05 3.8650410566722333e-08
+ 9.9443120599445188e-05 2.7655607125139506e-08
+ 9.9443198945610721e-05 1.80624388894615e-08
+ 9.9443278657649692e-05 1.1455385675920075e-08
+ 9.9443358369688664e-05 7.0279116712338033e-09
+ 9.944346129237076e-05 3.42722610432318e-09
+ 9.9443569508909815e-05 1.2415251844169095e-09
+ 9.944370191480444e-05 -1.7423168879043324e-10
+ 9.9443847065030182e-05 -9.0046498724308251e-10
+ 9.944403431523569e-05 -1.2675598336250834e-09
+ 9.9444255865010432e-05 -1.390661486095478e-09
+ 9.9444554034092508e-05 -1.4079464626524889e-09
+ 9.9444998769870891e-05 -1.3781166774969621e-09
+ 9.9445805003989e-05 -1.313948994893242e-09
+ 9.944671176436832e-05 -1.2450592154006523e-09
+ 9.9447737475686447e-05 -1.1711746826522686e-09
+ 9.9448801143402338e-05 -1.0985374417948889e-09
+ 9.9449944764949544e-05 -1.0244977902794022e-09
+ 9.945223164627891e-05 -8.876839903243166e-10
+ 9.9454182681216657e-05 -7.8153991862173163e-10
+ 9.9456291228517245e-05 -6.7660226349856925e-10
+ 9.9458581467436167e-05 -5.7299433820914436e-10
+ 9.9460926666850025e-05 -4.7698621811411996e-10
+ 9.9463271866263883e-05 -3.901690868650475e-10
+ 9.9465590537179633e-05 -3.1248869476676087e-10
+ 9.9468474569484286e-05 -2.2600941125466692e-10
+ 9.9471358601788926e-05 -1.4953972152878652e-10
+ 9.9474242634093579e-05 -8.1909642546355165e-11
+ 9.9477126666398233e-05 -2.2097231394821104e-11
+ 9.9480010698702872e-05 3.0804763949844941e-11
+ 9.9482894731007526e-05 7.7599184420572088e-11
+ 9.9485778763312179e-05 1.1899177680085989e-10
+ 9.9489342797663596e-05 1.6360497315690482e-10
+ 9.9492906832015013e-05 2.0194460469335925e-10
+ 9.949647086636643e-05 2.3489304324568193e-10
+ 9.9500034900717847e-05 2.6320792465228799e-10
+ 9.9503598935069278e-05 2.8754418863776942e-10
+ 9.9507899961127357e-05 3.124003450031708e-10
+ 9.951220098718545e-05 3.3310188136055884e-10
+ 9.9516502013243544e-05 3.5034335018174361e-10
+ 9.9520803039301623e-05 3.6470346013268147e-10
+ 9.9525104065359716e-05 3.7666442373221598e-10
+ 9.953050250598698e-05 3.8888313831481749e-10
+ 9.9535900946614257e-05 3.9859542479219459e-10
+ 9.9541299387241521e-05 4.0629545583254085e-10
+ 9.9546697827868785e-05 4.1242659596079512e-10
+ 9.9553468247657472e-05 4.1836450212166619e-10
+ 9.956023866744616e-05 4.228142873871682e-10
+ 9.9567009087234848e-05 4.2614500842071573e-10
+ 9.9575385304343953e-05 4.2912633403108892e-10
+ 9.9583761521453073e-05 4.3120345772378355e-10
+ 9.9592137738562178e-05 4.3264838822889765e-10
+ 9.9603043385488658e-05 4.3388610175178318e-10
+ 9.9613949032415137e-05 4.3464666000495187e-10
+ 9.9626156063665136e-05 4.3514763453961883e-10
+ 9.9638363094915134e-05 4.3542384097085643e-10
+ 9.9650570126165133e-05 4.3556624282357159e-10
+ 9.9662777157415132e-05 4.3562884855868211e-10
+ 9.967498418866513e-05 4.3564390919099658e-10
+ 9.9687191219915129e-05 4.3563071731303817e-10
+ 9.9699398251165141e-05 4.3560072832369711e-10
+ 9.971160528241514e-05 4.3556071800624522e-10
+ 9.9723812313665138e-05 4.3551473285478916e-10
+ 9.9736019344915137e-05 4.3546520640556509e-10
+ 9.9748226376165136e-05 4.3541358487496968e-10
+ 9.9760433407415134e-05 4.3536071753580087e-10
+ 9.9772640438665133e-05 4.353071102954193e-10
+ 9.9784847469915132e-05 4.3525307030070124e-10
+ 9.979705450116513e-05 4.3519878102624261e-10
+ 9.9809261532415142e-05 4.3514434891989702e-10
+ 9.9821468563665141e-05 4.3508983678706616e-10
+ 9.983367559491514e-05 4.3503528333983576e-10
+ 9.9845882626165138e-05 4.3498071205926307e-10
+ 9.9858089657415137e-05 4.3492613633167183e-10
+ 9.9870296688665136e-05 4.348715638520445e-10
+ 9.9882503719915134e-05 4.3481699946235471e-10
+ 9.9894710751165147e-05 4.3476244620745766e-10
+ 9.9906917782415145e-05 4.3470790578886986e-10
+ 9.9919124813665144e-05 4.3465337912630206e-10
+ 9.9931331844915143e-05 4.3459886680952396e-10
+ 9.9943538876165141e-05 4.3454436923774573e-10
+ 9.995574590741514e-05 4.3448988663097442e-10
+ 9.9967952938665139e-05 4.3443541909242035e-10
+ 9.9980159969915137e-05 4.3438096668679938e-10
+ 9.9992367001165136e-05 4.3432652946422885e-10
+ 0.0001 4.3429249785616217e-10
+ )
Xamp pgndB pgndA supply 0 reference output INA181A1
Rload output 0 10000
.options klu method=gear maxord=2 reltol=9.9999999999999995e-07 abstol=1e-10
.control
set wr_singlescale
set wr_vecnames
set numdgt=17
tran 3.0517578125000001e-09 0.0001 0 3.0517578125000001e-09 uic
let reported_current=(v(output)-2.5)/0.10000000000000001
wrdata transient.dat reported_current i(VpgndA) i(VpgndB)
quit
.endc
.end
