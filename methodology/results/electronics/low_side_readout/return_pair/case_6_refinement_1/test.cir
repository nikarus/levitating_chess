INA181A1 low-side acquisition diagnostic; imposed shunt current, not a complete bridge
.include ina181a1.lib
Vs supply 0 5
Vref reference 0 2.5
Vcurrent imposed_current 0 -6.5
VgateA gateA 0 PULSE(1 0 1.5625000000000001e-06 9.9999999999999995e-08 9.9999999999999995e-08 3.3250000000000004e-06 6.2500000000000003e-06)
BshuntA shuntA 0 V=-0.0050000000000000001*v(imposed_current)*v(gateA)
VgateB gateB 0 PULSE(1 0 1.8625e-06 9.9999999999999995e-08 9.9999999999999995e-08 2.7250000000000002e-06 6.2500000000000003e-06)
BshuntB shuntB 0 V=0.0050000000000000001*v(imposed_current)*v(gateB)
Xamp shuntB shuntA supply 0 reference output INA181A1
Rload output 0 10000
.options klu method=gear maxord=2 reltol=9.9999999999999995e-07 abstol=1e-10
.control
set wr_singlescale
set wr_vecnames
set numdgt=17
dc Vcurrent -6.5 6.5 0.13
wrdata dc.dat v(output)
tran 3.0517578125000001e-09 5.0000000000000002e-05 0 3.0517578125000001e-09
let reported_current = (v(output)-2.5)/0.10000000000000001
let differential_input = v(shuntB)-v(shuntA)
wrdata transient.dat differential_input reported_current
quit
.endc
.end
